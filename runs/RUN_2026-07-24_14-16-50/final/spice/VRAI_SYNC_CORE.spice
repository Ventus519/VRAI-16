* NGSPICE file created from VRAI_SYNC_CORE.ext - technology: sky130A

* Black-box entry subcircuit for sky130_fd_sc_hd__decap_3 abstract view
.subckt sky130_fd_sc_hd__decap_3 VGND VNB VPB VPWR
.ends

* Black-box entry subcircuit for sky130_fd_sc_hd__fill_1 abstract view
.subckt sky130_fd_sc_hd__fill_1 VGND VNB VPB VPWR
.ends

* Black-box entry subcircuit for sky130_fd_sc_hd__a22o_2 abstract view
.subckt sky130_fd_sc_hd__a22o_2 A1 A2 B1 B2 VGND VNB VPB VPWR X
.ends

* Black-box entry subcircuit for sky130_fd_sc_hd__fill_2 abstract view
.subckt sky130_fd_sc_hd__fill_2 VGND VNB VPB VPWR
.ends

* Black-box entry subcircuit for sky130_fd_sc_hd__nor2_2 abstract view
.subckt sky130_fd_sc_hd__nor2_2 A B VGND VNB VPB VPWR Y
.ends

* Black-box entry subcircuit for sky130_fd_sc_hd__tapvpwrvgnd_1 abstract view
.subckt sky130_fd_sc_hd__tapvpwrvgnd_1 VGND VPWR
.ends

* Black-box entry subcircuit for sky130_fd_sc_hd__mux2_1 abstract view
.subckt sky130_fd_sc_hd__mux2_1 A0 A1 S VGND VNB VPB VPWR X
.ends

* Black-box entry subcircuit for sky130_fd_sc_hd__clkbuf_8 abstract view
.subckt sky130_fd_sc_hd__clkbuf_8 A VGND VNB VPB VPWR X
.ends

* Black-box entry subcircuit for sky130_fd_sc_hd__dfxtp_2 abstract view
.subckt sky130_fd_sc_hd__dfxtp_2 CLK D VGND VNB VPB VPWR Q
.ends

* Black-box entry subcircuit for sky130_fd_sc_hd__or3_2 abstract view
.subckt sky130_fd_sc_hd__or3_2 A B C VGND VNB VPB VPWR X
.ends

* Black-box entry subcircuit for sky130_fd_sc_hd__mux4_2 abstract view
.subckt sky130_fd_sc_hd__mux4_2 A0 A1 A2 A3 S0 S1 VGND VNB VPB VPWR X
.ends

* Black-box entry subcircuit for sky130_fd_sc_hd__or2_2 abstract view
.subckt sky130_fd_sc_hd__or2_2 A B VGND VNB VPB VPWR X
.ends

* Black-box entry subcircuit for sky130_fd_sc_hd__o22a_2 abstract view
.subckt sky130_fd_sc_hd__o22a_2 A1 A2 B1 B2 VGND VNB VPB VPWR X
.ends

* Black-box entry subcircuit for sky130_fd_sc_hd__a221o_2 abstract view
.subckt sky130_fd_sc_hd__a221o_2 A1 A2 B1 B2 C1 VGND VNB VPB VPWR X
.ends

* Black-box entry subcircuit for sky130_fd_sc_hd__a311o_2 abstract view
.subckt sky130_fd_sc_hd__a311o_2 A1 A2 A3 B1 C1 VGND VNB VPB VPWR X
.ends

* Black-box entry subcircuit for sky130_fd_sc_hd__or4b_2 abstract view
.subckt sky130_fd_sc_hd__or4b_2 A B C D_N VGND VNB VPB VPWR X
.ends

* Black-box entry subcircuit for sky130_fd_sc_hd__and3_2 abstract view
.subckt sky130_fd_sc_hd__and3_2 A B C VGND VNB VPB VPWR X
.ends

* Black-box entry subcircuit for sky130_fd_sc_hd__a21oi_2 abstract view
.subckt sky130_fd_sc_hd__a21oi_2 A1 A2 B1 VGND VNB VPB VPWR Y
.ends

* Black-box entry subcircuit for sky130_fd_sc_hd__a21o_2 abstract view
.subckt sky130_fd_sc_hd__a21o_2 A1 A2 B1 VGND VNB VPB VPWR X
.ends

* Black-box entry subcircuit for sky130_fd_sc_hd__a21bo_2 abstract view
.subckt sky130_fd_sc_hd__a21bo_2 A1 A2 B1_N VGND VNB VPB VPWR X
.ends

* Black-box entry subcircuit for sky130_fd_sc_hd__xnor2_2 abstract view
.subckt sky130_fd_sc_hd__xnor2_2 A B VGND VNB VPB VPWR Y
.ends

* Black-box entry subcircuit for sky130_fd_sc_hd__o211a_2 abstract view
.subckt sky130_fd_sc_hd__o211a_2 A1 A2 B1 C1 VGND VNB VPB VPWR X
.ends

* Black-box entry subcircuit for sky130_fd_sc_hd__inv_2 abstract view
.subckt sky130_fd_sc_hd__inv_2 A VGND VNB VPB VPWR Y
.ends

* Black-box entry subcircuit for sky130_fd_sc_hd__and2_2 abstract view
.subckt sky130_fd_sc_hd__and2_2 A B VGND VNB VPB VPWR X
.ends

* Black-box entry subcircuit for sky130_fd_sc_hd__o221a_2 abstract view
.subckt sky130_fd_sc_hd__o221a_2 A1 A2 B1 B2 C1 VGND VNB VPB VPWR X
.ends

* Black-box entry subcircuit for sky130_fd_sc_hd__nor3_2 abstract view
.subckt sky130_fd_sc_hd__nor3_2 A B C VGND VNB VPB VPWR Y
.ends

* Black-box entry subcircuit for sky130_fd_sc_hd__nand2_2 abstract view
.subckt sky130_fd_sc_hd__nand2_2 A B VGND VNB VPB VPWR Y
.ends

* Black-box entry subcircuit for sky130_fd_sc_hd__and2b_2 abstract view
.subckt sky130_fd_sc_hd__and2b_2 A_N B VGND VNB VPB VPWR X
.ends

* Black-box entry subcircuit for sky130_fd_sc_hd__o31a_2 abstract view
.subckt sky130_fd_sc_hd__o31a_2 A1 A2 A3 B1 VGND VNB VPB VPWR X
.ends

* Black-box entry subcircuit for sky130_fd_sc_hd__o21ai_2 abstract view
.subckt sky130_fd_sc_hd__o21ai_2 A1 A2 B1 VGND VNB VPB VPWR Y
.ends

* Black-box entry subcircuit for sky130_fd_sc_hd__or4_2 abstract view
.subckt sky130_fd_sc_hd__or4_2 A B C D VGND VNB VPB VPWR X
.ends

* Black-box entry subcircuit for sky130_fd_sc_hd__a31o_2 abstract view
.subckt sky130_fd_sc_hd__a31o_2 A1 A2 A3 B1 VGND VNB VPB VPWR X
.ends

* Black-box entry subcircuit for sky130_fd_sc_hd__clkdlybuf4s25_1 abstract view
.subckt sky130_fd_sc_hd__clkdlybuf4s25_1 A VGND VNB VPB VPWR X
.ends

* Black-box entry subcircuit for sky130_fd_sc_hd__a211o_2 abstract view
.subckt sky130_fd_sc_hd__a211o_2 A1 A2 B1 C1 VGND VNB VPB VPWR X
.ends

* Black-box entry subcircuit for sky130_fd_sc_hd__clkbuf_16 abstract view
.subckt sky130_fd_sc_hd__clkbuf_16 A VGND VNB VPB VPWR X
.ends

* Black-box entry subcircuit for sky130_fd_sc_hd__o21a_2 abstract view
.subckt sky130_fd_sc_hd__o21a_2 A1 A2 B1 VGND VNB VPB VPWR X
.ends

* Black-box entry subcircuit for sky130_fd_sc_hd__or3b_2 abstract view
.subckt sky130_fd_sc_hd__or3b_2 A B C_N VGND VNB VPB VPWR X
.ends

* Black-box entry subcircuit for sky130_fd_sc_hd__dfxtp_4 abstract view
.subckt sky130_fd_sc_hd__dfxtp_4 CLK D VGND VNB VPB VPWR Q
.ends

* Black-box entry subcircuit for sky130_fd_sc_hd__o21ba_2 abstract view
.subckt sky130_fd_sc_hd__o21ba_2 A1 A2 B1_N VGND VNB VPB VPWR X
.ends

* Black-box entry subcircuit for sky130_fd_sc_hd__and4bb_2 abstract view
.subckt sky130_fd_sc_hd__and4bb_2 A_N B_N C D VGND VNB VPB VPWR X
.ends

* Black-box entry subcircuit for sky130_fd_sc_hd__o311a_2 abstract view
.subckt sky130_fd_sc_hd__o311a_2 A1 A2 A3 B1 C1 VGND VNB VPB VPWR X
.ends

* Black-box entry subcircuit for sky130_fd_sc_hd__nand2b_2 abstract view
.subckt sky130_fd_sc_hd__nand2b_2 A_N B VGND VNB VPB VPWR Y
.ends

* Black-box entry subcircuit for sky130_fd_sc_hd__o2bb2a_2 abstract view
.subckt sky130_fd_sc_hd__o2bb2a_2 A1_N A2_N B1 B2 VGND VNB VPB VPWR X
.ends

* Black-box entry subcircuit for sky130_fd_sc_hd__o32a_2 abstract view
.subckt sky130_fd_sc_hd__o32a_2 A1 A2 A3 B1 B2 VGND VNB VPB VPWR X
.ends

* Black-box entry subcircuit for sky130_fd_sc_hd__o31ai_2 abstract view
.subckt sky130_fd_sc_hd__o31ai_2 A1 A2 A3 B1 VGND VNB VPB VPWR Y
.ends

* Black-box entry subcircuit for sky130_fd_sc_hd__a41o_2 abstract view
.subckt sky130_fd_sc_hd__a41o_2 A1 A2 A3 A4 B1 VGND VNB VPB VPWR X
.ends

* Black-box entry subcircuit for sky130_fd_sc_hd__a32o_2 abstract view
.subckt sky130_fd_sc_hd__a32o_2 A1 A2 A3 B1 B2 VGND VNB VPB VPWR X
.ends

* Black-box entry subcircuit for sky130_fd_sc_hd__and4b_2 abstract view
.subckt sky130_fd_sc_hd__and4b_2 A_N B C D VGND VNB VPB VPWR X
.ends

* Black-box entry subcircuit for sky130_fd_sc_hd__o2111a_2 abstract view
.subckt sky130_fd_sc_hd__o2111a_2 A1 A2 B1 C1 D1 VGND VNB VPB VPWR X
.ends

* Black-box entry subcircuit for sky130_fd_sc_hd__xor2_2 abstract view
.subckt sky130_fd_sc_hd__xor2_2 A B VGND VNB VPB VPWR X
.ends

* Black-box entry subcircuit for sky130_fd_sc_hd__inv_6 abstract view
.subckt sky130_fd_sc_hd__inv_6 A VGND VNB VPB VPWR Y
.ends

* Black-box entry subcircuit for sky130_fd_sc_hd__a221oi_2 abstract view
.subckt sky130_fd_sc_hd__a221oi_2 A1 A2 B1 B2 C1 VGND VNB VPB VPWR Y
.ends

* Black-box entry subcircuit for sky130_fd_sc_hd__a22oi_2 abstract view
.subckt sky130_fd_sc_hd__a22oi_2 A1 A2 B1 B2 VGND VNB VPB VPWR Y
.ends

* Black-box entry subcircuit for sky130_fd_sc_hd__o22ai_2 abstract view
.subckt sky130_fd_sc_hd__o22ai_2 A1 A2 B1 B2 VGND VNB VPB VPWR Y
.ends

* Black-box entry subcircuit for sky130_fd_sc_hd__nor4_2 abstract view
.subckt sky130_fd_sc_hd__nor4_2 A B C D VGND VNB VPB VPWR Y
.ends

* Black-box entry subcircuit for sky130_fd_sc_hd__inv_12 abstract view
.subckt sky130_fd_sc_hd__inv_12 A VGND VNB VPB VPWR Y
.ends

* Black-box entry subcircuit for sky130_fd_sc_hd__a211oi_2 abstract view
.subckt sky130_fd_sc_hd__a211oi_2 A1 A2 B1 C1 VGND VNB VPB VPWR Y
.ends

* Black-box entry subcircuit for sky130_fd_sc_hd__nand3b_2 abstract view
.subckt sky130_fd_sc_hd__nand3b_2 A_N B C VGND VNB VPB VPWR Y
.ends

* Black-box entry subcircuit for sky130_fd_sc_hd__a2111oi_2 abstract view
.subckt sky130_fd_sc_hd__a2111oi_2 A1 A2 B1 C1 D1 VGND VNB VPB VPWR Y
.ends

* Black-box entry subcircuit for sky130_fd_sc_hd__bufinv_16 abstract view
.subckt sky130_fd_sc_hd__bufinv_16 A VGND VNB VPB VPWR Y
.ends

* Black-box entry subcircuit for sky130_fd_sc_hd__inv_8 abstract view
.subckt sky130_fd_sc_hd__inv_8 A VGND VNB VPB VPWR Y
.ends

* Black-box entry subcircuit for sky130_fd_sc_hd__clkbuf_4 abstract view
.subckt sky130_fd_sc_hd__clkbuf_4 A VGND VNB VPB VPWR X
.ends

* Black-box entry subcircuit for sky130_fd_sc_hd__a311oi_2 abstract view
.subckt sky130_fd_sc_hd__a311oi_2 A1 A2 A3 B1 C1 VGND VNB VPB VPWR Y
.ends

* Black-box entry subcircuit for sky130_fd_sc_hd__nor4_4 abstract view
.subckt sky130_fd_sc_hd__nor4_4 A B C D VGND VNB VPB VPWR Y
.ends

* Black-box entry subcircuit for sky130_fd_sc_hd__and4_2 abstract view
.subckt sky130_fd_sc_hd__and4_2 A B C D VGND VNB VPB VPWR X
.ends

* Black-box entry subcircuit for sky130_fd_sc_hd__or4bb_2 abstract view
.subckt sky130_fd_sc_hd__or4bb_2 A B C_N D_N VGND VNB VPB VPWR X
.ends

* Black-box entry subcircuit for sky130_fd_sc_hd__clkinv_2 abstract view
.subckt sky130_fd_sc_hd__clkinv_2 A VGND VNB VPB VPWR Y
.ends

* Black-box entry subcircuit for sky130_fd_sc_hd__mux2_2 abstract view
.subckt sky130_fd_sc_hd__mux2_2 A0 A1 S VGND VNB VPB VPWR X
.ends

* Black-box entry subcircuit for sky130_fd_sc_hd__o21bai_2 abstract view
.subckt sky130_fd_sc_hd__o21bai_2 A1 A2 B1_N VGND VNB VPB VPWR Y
.ends

* Black-box entry subcircuit for sky130_fd_sc_hd__and3b_2 abstract view
.subckt sky130_fd_sc_hd__and3b_2 A_N B C VGND VNB VPB VPWR X
.ends

* Black-box entry subcircuit for sky130_fd_sc_hd__a2bb2o_2 abstract view
.subckt sky130_fd_sc_hd__a2bb2o_2 A1_N A2_N B1 B2 VGND VNB VPB VPWR X
.ends

* Black-box entry subcircuit for sky130_fd_sc_hd__nand4_2 abstract view
.subckt sky130_fd_sc_hd__nand4_2 A B C D VGND VNB VPB VPWR Y
.ends

* Black-box entry subcircuit for sky130_fd_sc_hd__o211ai_2 abstract view
.subckt sky130_fd_sc_hd__o211ai_2 A1 A2 B1 C1 VGND VNB VPB VPWR Y
.ends

* Black-box entry subcircuit for sky130_fd_sc_hd__buf_6 abstract view
.subckt sky130_fd_sc_hd__buf_6 A VGND VNB VPB VPWR X
.ends

* Black-box entry subcircuit for sky130_fd_sc_hd__buf_12 abstract view
.subckt sky130_fd_sc_hd__buf_12 A VGND VNB VPB VPWR X
.ends

* Black-box entry subcircuit for sky130_fd_sc_hd__buf_4 abstract view
.subckt sky130_fd_sc_hd__buf_4 A VGND VNB VPB VPWR X
.ends

* Black-box entry subcircuit for sky130_fd_sc_hd__o221ai_2 abstract view
.subckt sky130_fd_sc_hd__o221ai_2 A1 A2 B1 B2 C1 VGND VNB VPB VPWR Y
.ends

* Black-box entry subcircuit for sky130_fd_sc_hd__a21boi_2 abstract view
.subckt sky130_fd_sc_hd__a21boi_2 A1 A2 B1_N VGND VNB VPB VPWR Y
.ends

* Black-box entry subcircuit for sky130_fd_sc_hd__nand3_2 abstract view
.subckt sky130_fd_sc_hd__nand3_2 A B C VGND VNB VPB VPWR Y
.ends

* Black-box entry subcircuit for sky130_fd_sc_hd__nor2_4 abstract view
.subckt sky130_fd_sc_hd__nor2_4 A B VGND VNB VPB VPWR Y
.ends

* Black-box entry subcircuit for sky130_fd_sc_hd__diode_2 abstract view
.subckt sky130_fd_sc_hd__diode_2 DIODE VGND VNB VPB VPWR
.ends

* Black-box entry subcircuit for sky130_fd_sc_hd__a2111o_2 abstract view
.subckt sky130_fd_sc_hd__a2111o_2 A1 A2 B1 C1 D1 VGND VNB VPB VPWR X
.ends

* Black-box entry subcircuit for sky130_fd_sc_hd__o311ai_2 abstract view
.subckt sky130_fd_sc_hd__o311ai_2 A1 A2 A3 B1 C1 VGND VNB VPB VPWR Y
.ends

* Black-box entry subcircuit for sky130_fd_sc_hd__nor3b_2 abstract view
.subckt sky130_fd_sc_hd__nor3b_2 A B C_N VGND VNB VPB VPWR Y
.ends

.subckt VRAI_SYNC_CORE CLK DEVICES_LDH DEVICES_LDW DEVICES_STRH DEVICES_STRW EX_HALT
+ INSTR_ADDR[0] INSTR_ADDR[10] INSTR_ADDR[11] INSTR_ADDR[12] INSTR_ADDR[13] INSTR_ADDR[14]
+ INSTR_ADDR[15] INSTR_ADDR[1] INSTR_ADDR[2] INSTR_ADDR[3] INSTR_ADDR[4] INSTR_ADDR[5]
+ INSTR_ADDR[6] INSTR_ADDR[7] INSTR_ADDR[8] INSTR_ADDR[9] INSTR_STREAM[0] INSTR_STREAM[10]
+ INSTR_STREAM[11] INSTR_STREAM[12] INSTR_STREAM[13] INSTR_STREAM[14] INSTR_STREAM[15]
+ INSTR_STREAM[16] INSTR_STREAM[17] INSTR_STREAM[18] INSTR_STREAM[19] INSTR_STREAM[1]
+ INSTR_STREAM[20] INSTR_STREAM[21] INSTR_STREAM[22] INSTR_STREAM[23] INSTR_STREAM[24]
+ INSTR_STREAM[25] INSTR_STREAM[26] INSTR_STREAM[27] INSTR_STREAM[28] INSTR_STREAM[29]
+ INSTR_STREAM[2] INSTR_STREAM[30] INSTR_STREAM[31] INSTR_STREAM[3] INSTR_STREAM[4]
+ INSTR_STREAM[5] INSTR_STREAM[6] INSTR_STREAM[7] INSTR_STREAM[8] INSTR_STREAM[9]
+ INVALID_MEM MAIN_LDH MAIN_LDW MAIN_STRH MAIN_STRW MEM_ADDR[0] MEM_ADDR[10] MEM_ADDR[11]
+ MEM_ADDR[12] MEM_ADDR[13] MEM_ADDR[14] MEM_ADDR[15] MEM_ADDR[1] MEM_ADDR[2] MEM_ADDR[3]
+ MEM_ADDR[4] MEM_ADDR[5] MEM_ADDR[6] MEM_ADDR[7] MEM_ADDR[8] MEM_ADDR[9] MEM_LD_DATA[0]
+ MEM_LD_DATA[10] MEM_LD_DATA[11] MEM_LD_DATA[12] MEM_LD_DATA[13] MEM_LD_DATA[14]
+ MEM_LD_DATA[15] MEM_LD_DATA[1] MEM_LD_DATA[2] MEM_LD_DATA[3] MEM_LD_DATA[4] MEM_LD_DATA[5]
+ MEM_LD_DATA[6] MEM_LD_DATA[7] MEM_LD_DATA[8] MEM_LD_DATA[9] MEM_STR_DATA[0] MEM_STR_DATA[10]
+ MEM_STR_DATA[11] MEM_STR_DATA[12] MEM_STR_DATA[13] MEM_STR_DATA[14] MEM_STR_DATA[15]
+ MEM_STR_DATA[1] MEM_STR_DATA[2] MEM_STR_DATA[3] MEM_STR_DATA[4] MEM_STR_DATA[5]
+ MEM_STR_DATA[6] MEM_STR_DATA[7] MEM_STR_DATA[8] MEM_STR_DATA[9] RESET VGND VPWR
XFILLER_67_520 VGND VGND VPWR VPWR sky130_fd_sc_hd__decap_3
XFILLER_36_19 VGND VGND VPWR VPWR sky130_fd_sc_hd__fill_1
XFILLER_39_277 VGND VGND VPWR VPWR sky130_fd_sc_hd__decap_3
X_3155_ _2891_/X _3170_/A2 _3170_/B1 _5059_/Q VGND VGND VPWR VPWR _5059_/D sky130_fd_sc_hd__a22o_2
XFILLER_27_439 VGND VGND VPWR VPWR sky130_fd_sc_hd__decap_3
X_3086_ _2913_/X _3093_/A2 _3096_/B1 _5000_/Q VGND VGND VPWR VPWR _5000_/D sky130_fd_sc_hd__a22o_2
XFILLER_42_409 VGND VGND VPWR VPWR sky130_fd_sc_hd__decap_3
XFILLER_35_483 VGND VGND VPWR VPWR sky130_fd_sc_hd__decap_3
XFILLER_52_29 VGND VGND VPWR VPWR sky130_fd_sc_hd__decap_3
XFILLER_10_306 VGND VGND VPWR VPWR sky130_fd_sc_hd__fill_2
XFILLER_22_155 VGND VGND VPWR VPWR sky130_fd_sc_hd__fill_1
XFILLER_50_475 VGND VGND VPWR VPWR sky130_fd_sc_hd__fill_1
X_3988_ _5178_/Q _3989_/B VGND VGND VPWR VPWR _4313_/B sky130_fd_sc_hd__nor2_2
XFILLER_50_486 VGND VGND VPWR VPWR sky130_fd_sc_hd__fill_2
X_2939_ _4880_/Q _2897_/Y _2938_/X _2897_/B VGND VGND VPWR VPWR _4880_/D sky130_fd_sc_hd__a22o_2
XTAP_TAPCELL_ROW_20_389 VGND VPWR sky130_fd_sc_hd__tapvpwrvgnd_1
X_4609_ _4547_/A _4115_/A _4609_/S VGND VGND VPWR VPWR _4609_/X sky130_fd_sc_hd__mux2_1
XFILLER_77_26 VGND VGND VPWR VPWR sky130_fd_sc_hd__fill_2
XFILLER_77_15 VGND VGND VPWR VPWR sky130_fd_sc_hd__decap_3
XFILLER_77_48 VGND VGND VPWR VPWR sky130_fd_sc_hd__decap_3
XFILLER_77_317 VGND VGND VPWR VPWR sky130_fd_sc_hd__decap_3
XFILLER_58_542 VGND VGND VPWR VPWR sky130_fd_sc_hd__decap_3
XFILLER_73_501 VGND VGND VPWR VPWR sky130_fd_sc_hd__decap_3
XFILLER_92_309 VGND VGND VPWR VPWR sky130_fd_sc_hd__decap_3
XFILLER_73_523 VGND VGND VPWR VPWR sky130_fd_sc_hd__decap_3
XTAP_TAPCELL_ROW_56_732 VGND VPWR sky130_fd_sc_hd__tapvpwrvgnd_1
XFILLER_26_472 VGND VGND VPWR VPWR sky130_fd_sc_hd__decap_3
XTAP_TAPCELL_ROW_28_467 VGND VPWR sky130_fd_sc_hd__tapvpwrvgnd_1
XFILLER_13_111 VGND VGND VPWR VPWR sky130_fd_sc_hd__fill_1
XFILLER_13_133 VGND VGND VPWR VPWR sky130_fd_sc_hd__fill_2
XFILLER_26_85 VGND VGND VPWR VPWR sky130_fd_sc_hd__decap_3
XFILLER_41_420 VGND VGND VPWR VPWR sky130_fd_sc_hd__decap_3
XFILLER_13_188 VGND VGND VPWR VPWR sky130_fd_sc_hd__decap_3
XFILLER_42_40 VGND VGND VPWR VPWR sky130_fd_sc_hd__fill_1
XFILLER_5_343 VGND VGND VPWR VPWR sky130_fd_sc_hd__decap_3
XFILLER_3_12 VGND VGND VPWR VPWR sky130_fd_sc_hd__fill_1
XFILLER_67_70 VGND VGND VPWR VPWR sky130_fd_sc_hd__fill_1
XFILLER_76_361 VGND VGND VPWR VPWR sky130_fd_sc_hd__decap_3
XFILLER_64_512 VGND VGND VPWR VPWR sky130_fd_sc_hd__decap_3
Xclkbuf_leaf_6_CLK clkbuf_leaf_8_CLK/A VGND VGND VPWR VPWR clkload6/A sky130_fd_sc_hd__clkbuf_8
XFILLER_76_383 VGND VGND VPWR VPWR sky130_fd_sc_hd__decap_3
XFILLER_64_545 VGND VGND VPWR VPWR sky130_fd_sc_hd__decap_3
XFILLER_17_461 VGND VGND VPWR VPWR sky130_fd_sc_hd__decap_3
XFILLER_17_483 VGND VGND VPWR VPWR sky130_fd_sc_hd__decap_3
X_4960_ _5122_/CLK _4960_/D VGND VGND VPWR VPWR _4960_/Q sky130_fd_sc_hd__dfxtp_2
XFILLER_91_386 VGND VGND VPWR VPWR sky130_fd_sc_hd__decap_3
X_4891_ _5106_/CLK _4891_/D VGND VGND VPWR VPWR _4891_/Q sky130_fd_sc_hd__dfxtp_2
X_3911_ _4453_/B _4326_/A _3911_/C VGND VGND VPWR VPWR _3911_/X sky130_fd_sc_hd__or3_2
XFILLER_32_464 VGND VGND VPWR VPWR sky130_fd_sc_hd__decap_3
X_3842_ _4445_/B _4405_/B VGND VGND VPWR VPWR _4482_/S sky130_fd_sc_hd__nor2_2
X_3773_ _4962_/Q _4946_/Q _4930_/Q _4914_/Q _5127_/Q _5128_/Q VGND VGND VPWR VPWR
+ _3773_/X sky130_fd_sc_hd__mux4_2
X_2724_ _5134_/Q _2719_/X _2721_/X _2723_/X VGND VGND VPWR VPWR _3259_/B sky130_fd_sc_hd__a22o_2
X_2655_ _5125_/Q _2655_/B VGND VGND VPWR VPWR _2655_/X sky130_fd_sc_hd__or2_2
X_4325_ _4453_/B _3911_/C _4291_/A _4291_/B VGND VGND VPWR VPWR _4326_/B sky130_fd_sc_hd__o22a_2
X_2586_ _4884_/Q _4868_/Q _5092_/Q _5076_/Q _5123_/Q _2671_/S1 VGND VGND VPWR VPWR
+ _2586_/X sky130_fd_sc_hd__mux4_2
XFILLER_59_306 VGND VGND VPWR VPWR sky130_fd_sc_hd__decap_3
XFILLER_86_114 VGND VGND VPWR VPWR sky130_fd_sc_hd__fill_1
X_4256_ _4275_/B _3869_/Y _4002_/Y _2678_/A _4110_/A VGND VGND VPWR VPWR _4256_/X
+ sky130_fd_sc_hd__a221o_2
X_4187_ _4191_/A _3898_/X _4360_/B _4181_/Y _4186_/X VGND VGND VPWR VPWR _4187_/X
+ sky130_fd_sc_hd__a311o_2
X_3207_ _3207_/A _3207_/B VGND VGND VPWR VPWR _3208_/B sky130_fd_sc_hd__nor2_2
XFILLER_86_158 VGND VGND VPWR VPWR sky130_fd_sc_hd__decap_3
XFILLER_55_512 VGND VGND VPWR VPWR sky130_fd_sc_hd__decap_3
X_3138_ _2900_/X _3152_/A2 _3136_/Y _5044_/Q VGND VGND VPWR VPWR _5044_/D sky130_fd_sc_hd__a22o_2
XFILLER_55_545 VGND VGND VPWR VPWR sky130_fd_sc_hd__decap_3
XFILLER_82_342 VGND VGND VPWR VPWR sky130_fd_sc_hd__decap_3
X_3069_ _2919_/X _3074_/A2 _3061_/Y _4986_/Q VGND VGND VPWR VPWR _4986_/D sky130_fd_sc_hd__a22o_2
XTAP_TAPCELL_ROW_53_702 VGND VPWR sky130_fd_sc_hd__tapvpwrvgnd_1
XTAP_TAPCELL_ROW_25_437 VGND VPWR sky130_fd_sc_hd__tapvpwrvgnd_1
XFILLER_82_397 VGND VGND VPWR VPWR sky130_fd_sc_hd__decap_3
XFILLER_23_442 VGND VGND VPWR VPWR sky130_fd_sc_hd__decap_3
XFILLER_23_475 VGND VGND VPWR VPWR sky130_fd_sc_hd__decap_3
XFILLER_10_136 VGND VGND VPWR VPWR sky130_fd_sc_hd__decap_3
XFILLER_88_58 VGND VGND VPWR VPWR sky130_fd_sc_hd__decap_3
XFILLER_77_125 VGND VGND VPWR VPWR sky130_fd_sc_hd__decap_3
XFILLER_46_501 VGND VGND VPWR VPWR sky130_fd_sc_hd__decap_3
XFILLER_58_350 VGND VGND VPWR VPWR sky130_fd_sc_hd__decap_3
XFILLER_65_309 VGND VGND VPWR VPWR sky130_fd_sc_hd__decap_3
XFILLER_58_383 VGND VGND VPWR VPWR sky130_fd_sc_hd__decap_3
XFILLER_58_394 VGND VGND VPWR VPWR sky130_fd_sc_hd__decap_3
XFILLER_73_320 VGND VGND VPWR VPWR sky130_fd_sc_hd__decap_3
XFILLER_33_206 VGND VGND VPWR VPWR sky130_fd_sc_hd__fill_1
XFILLER_61_526 VGND VGND VPWR VPWR sky130_fd_sc_hd__decap_3
XFILLER_33_228 VGND VGND VPWR VPWR sky130_fd_sc_hd__decap_3
XFILLER_33_239 VGND VGND VPWR VPWR sky130_fd_sc_hd__decap_3
XFILLER_61_548 VGND VGND VPWR VPWR sky130_fd_sc_hd__decap_3
XFILLER_41_250 VGND VGND VPWR VPWR sky130_fd_sc_hd__decap_3
XFILLER_41_272 VGND VGND VPWR VPWR sky130_fd_sc_hd__decap_3
XFILLER_5_140 VGND VGND VPWR VPWR sky130_fd_sc_hd__decap_3
X_2440_ _3867_/A _5178_/Q VGND VGND VPWR VPWR _2446_/B sky130_fd_sc_hd__or2_2
XFILLER_68_136 VGND VGND VPWR VPWR sky130_fd_sc_hd__decap_3
X_4110_ _4110_/A _4110_/B _4110_/C _4109_/X VGND VGND VPWR VPWR _4110_/X sky130_fd_sc_hd__or4b_2
X_5090_ _5134_/CLK _5090_/D VGND VGND VPWR VPWR _5090_/Q sky130_fd_sc_hd__dfxtp_2
XFILLER_78_91 VGND VGND VPWR VPWR sky130_fd_sc_hd__fill_2
XFILLER_56_309 VGND VGND VPWR VPWR sky130_fd_sc_hd__decap_3
XFILLER_68_169 VGND VGND VPWR VPWR sky130_fd_sc_hd__decap_3
X_4041_ _4110_/A _4041_/B _4041_/C VGND VGND VPWR VPWR _4041_/X sky130_fd_sc_hd__and3_2
XFILLER_83_106 VGND VGND VPWR VPWR sky130_fd_sc_hd__decap_3
XFILLER_49_361 VGND VGND VPWR VPWR sky130_fd_sc_hd__decap_3
XTAP_TAPCELL_ROW_67_838 VGND VPWR sky130_fd_sc_hd__tapvpwrvgnd_1
XFILLER_64_342 VGND VGND VPWR VPWR sky130_fd_sc_hd__decap_3
XFILLER_52_504 VGND VGND VPWR VPWR sky130_fd_sc_hd__decap_3
X_4943_ _5007_/CLK _4943_/D VGND VGND VPWR VPWR _4943_/Q sky130_fd_sc_hd__dfxtp_2
XTAP_TAPCELL_ROW_22_407 VGND VPWR sky130_fd_sc_hd__tapvpwrvgnd_1
XFILLER_20_401 VGND VGND VPWR VPWR sky130_fd_sc_hd__decap_3
X_4874_ _5210_/CLK _4874_/D VGND VGND VPWR VPWR _4874_/Q sky130_fd_sc_hd__dfxtp_2
XFILLER_32_294 VGND VGND VPWR VPWR sky130_fd_sc_hd__fill_2
X_3825_ _4493_/A _4397_/A VGND VGND VPWR VPWR _3825_/X sky130_fd_sc_hd__or2_2
X_3756_ _4766_/S _3756_/B VGND VGND VPWR VPWR _4291_/A sky130_fd_sc_hd__nor2_2
X_2707_ _4547_/A _4115_/A _2887_/B VGND VGND VPWR VPWR _2851_/A sky130_fd_sc_hd__a21oi_2
XTAP_TAPCELL_ROW_30_484 VGND VPWR sky130_fd_sc_hd__tapvpwrvgnd_1
X_3687_ _4955_/Q _4939_/Q _4923_/Q _4907_/Q _5127_/Q _5128_/Q VGND VGND VPWR VPWR
+ _3687_/X sky130_fd_sc_hd__mux4_2
X_2638_ _2638_/A _2638_/B VGND VGND VPWR VPWR _3682_/A sky130_fd_sc_hd__nor2_2
X_2569_ _5110_/Q _4998_/Q _4982_/Q _4966_/Q _2658_/S0 _2671_/S1 VGND VGND VPWR VPWR
+ _2569_/X sky130_fd_sc_hd__mux4_2
X_4308_ _4291_/A _4289_/B _3756_/B VGND VGND VPWR VPWR _4309_/B sky130_fd_sc_hd__a21o_2
XFILLER_87_423 VGND VGND VPWR VPWR sky130_fd_sc_hd__decap_3
XFILLER_59_158 VGND VGND VPWR VPWR sky130_fd_sc_hd__decap_3
XFILLER_59_169 VGND VGND VPWR VPWR sky130_fd_sc_hd__decap_3
X_4239_ _4195_/Y _4285_/D _4717_/S VGND VGND VPWR VPWR _4241_/B sky130_fd_sc_hd__a21oi_2
XFILLER_87_489 VGND VGND VPWR VPWR sky130_fd_sc_hd__decap_3
XFILLER_74_49 VGND VGND VPWR VPWR sky130_fd_sc_hd__fill_1
XFILLER_55_364 VGND VGND VPWR VPWR sky130_fd_sc_hd__decap_3
XFILLER_70_312 VGND VGND VPWR VPWR sky130_fd_sc_hd__decap_3
XTAP_TAPCELL_ROW_38_562 VGND VPWR sky130_fd_sc_hd__tapvpwrvgnd_1
XFILLER_15_228 VGND VGND VPWR VPWR sky130_fd_sc_hd__decap_3
XFILLER_70_345 VGND VGND VPWR VPWR sky130_fd_sc_hd__decap_3
XFILLER_82_183 VGND VGND VPWR VPWR sky130_fd_sc_hd__decap_3
XFILLER_82_172 VGND VGND VPWR VPWR sky130_fd_sc_hd__decap_3
XFILLER_70_389 VGND VGND VPWR VPWR sky130_fd_sc_hd__decap_3
XFILLER_11_467 VGND VGND VPWR VPWR sky130_fd_sc_hd__fill_1
XFILLER_23_86 VGND VGND VPWR VPWR sky130_fd_sc_hd__decap_3
XFILLER_7_449 VGND VGND VPWR VPWR sky130_fd_sc_hd__decap_3
XFILLER_38_309 VGND VGND VPWR VPWR sky130_fd_sc_hd__fill_1
XFILLER_48_50 VGND VGND VPWR VPWR sky130_fd_sc_hd__fill_1
XFILLER_93_404 VGND VGND VPWR VPWR sky130_fd_sc_hd__decap_3
XTAP_TAPCELL_ROW_64_808 VGND VPWR sky130_fd_sc_hd__tapvpwrvgnd_1
XFILLER_0_46 VGND VGND VPWR VPWR sky130_fd_sc_hd__decap_3
XFILLER_0_57 VGND VGND VPWR VPWR sky130_fd_sc_hd__decap_3
XFILLER_46_386 VGND VGND VPWR VPWR sky130_fd_sc_hd__decap_3
XFILLER_64_71 VGND VGND VPWR VPWR sky130_fd_sc_hd__decap_3
XFILLER_64_82 VGND VGND VPWR VPWR sky130_fd_sc_hd__fill_2
XFILLER_73_183 VGND VGND VPWR VPWR sky130_fd_sc_hd__decap_3
XFILLER_61_356 VGND VGND VPWR VPWR sky130_fd_sc_hd__decap_3
XTAP_TAPCELL_ROW_72_885 VGND VPWR sky130_fd_sc_hd__tapvpwrvgnd_1
XFILLER_9_55 VGND VGND VPWR VPWR sky130_fd_sc_hd__fill_1
X_4590_ _4470_/B _4589_/X _4588_/Y VGND VGND VPWR VPWR _4595_/D sky130_fd_sc_hd__a21bo_2
X_3610_ _5129_/Q _3610_/B VGND VGND VPWR VPWR _3610_/X sky130_fd_sc_hd__or2_2
XFILLER_80_81 VGND VGND VPWR VPWR sky130_fd_sc_hd__decap_3
X_3541_ _3541_/A _3541_/B VGND VGND VPWR VPWR _3541_/Y sky130_fd_sc_hd__xnor2_2
XFILLER_50_3 VGND VGND VPWR VPWR sky130_fd_sc_hd__decap_3
X_3472_ _5189_/Q _4168_/A _3471_/X _3448_/B VGND VGND VPWR VPWR _5189_/D sky130_fd_sc_hd__o211a_2
X_5211_ clkload8/A _5211_/D VGND VGND VPWR VPWR _5211_/Q sky130_fd_sc_hd__dfxtp_2
X_2423_ _5198_/Q VGND VGND VPWR VPWR _2423_/Y sky130_fd_sc_hd__inv_2
X_5142_ _5200_/CLK _5142_/D VGND VGND VPWR VPWR _5142_/Q sky130_fd_sc_hd__dfxtp_2
XFILLER_56_106 VGND VGND VPWR VPWR sky130_fd_sc_hd__decap_3
X_5073_ clkload6/A _5073_/D VGND VGND VPWR VPWR _5073_/Q sky130_fd_sc_hd__dfxtp_2
XFILLER_84_415 VGND VGND VPWR VPWR sky130_fd_sc_hd__decap_3
XFILLER_37_331 VGND VGND VPWR VPWR sky130_fd_sc_hd__decap_3
X_4024_ _3629_/X _3633_/Y _4063_/A VGND VGND VPWR VPWR _4024_/X sky130_fd_sc_hd__mux2_1
XFILLER_71_109 VGND VGND VPWR VPWR sky130_fd_sc_hd__decap_3
XFILLER_52_312 VGND VGND VPWR VPWR sky130_fd_sc_hd__decap_3
XFILLER_64_194 VGND VGND VPWR VPWR sky130_fd_sc_hd__fill_2
XFILLER_92_492 VGND VGND VPWR VPWR sky130_fd_sc_hd__decap_3
XFILLER_40_507 VGND VGND VPWR VPWR sky130_fd_sc_hd__decap_3
XFILLER_52_345 VGND VGND VPWR VPWR sky130_fd_sc_hd__decap_3
XTAP_TAPCELL_ROW_35_532 VGND VPWR sky130_fd_sc_hd__tapvpwrvgnd_1
X_4926_ _5116_/CLK _4926_/D VGND VGND VPWR VPWR _4926_/Q sky130_fd_sc_hd__dfxtp_2
X_4857_ _5166_/Q _3450_/C _3228_/Y _3241_/X VGND VGND VPWR VPWR _5166_/D sky130_fd_sc_hd__o22a_2
XFILLER_20_253 VGND VGND VPWR VPWR sky130_fd_sc_hd__decap_3
X_3808_ _4449_/A _4403_/A VGND VGND VPWR VPWR _3809_/B sky130_fd_sc_hd__and2_2
X_4788_ _4787_/X _4759_/A _4802_/A VGND VGND VPWR VPWR _4789_/B sky130_fd_sc_hd__mux2_1
X_3739_ _3737_/X _3738_/X _5129_/Q VGND VGND VPWR VPWR _3739_/X sky130_fd_sc_hd__mux2_1
XFILLER_69_38 VGND VGND VPWR VPWR sky130_fd_sc_hd__fill_1
XFILLER_75_404 VGND VGND VPWR VPWR sky130_fd_sc_hd__decap_3
XTAP_TAPCELL_ROW_7_268 VGND VPWR sky130_fd_sc_hd__tapvpwrvgnd_1
XFILLER_87_253 VGND VGND VPWR VPWR sky130_fd_sc_hd__decap_3
XFILLER_87_231 VGND VGND VPWR VPWR sky130_fd_sc_hd__decap_3
XFILLER_85_15 VGND VGND VPWR VPWR sky130_fd_sc_hd__decap_3
XFILLER_75_437 VGND VGND VPWR VPWR sky130_fd_sc_hd__decap_3
XFILLER_47_139 VGND VGND VPWR VPWR sky130_fd_sc_hd__decap_3
XFILLER_90_429 VGND VGND VPWR VPWR sky130_fd_sc_hd__decap_3
XFILLER_90_407 VGND VGND VPWR VPWR sky130_fd_sc_hd__decap_3
XFILLER_16_548 VGND VGND VPWR VPWR sky130_fd_sc_hd__decap_3
XFILLER_18_97 VGND VGND VPWR VPWR sky130_fd_sc_hd__decap_3
XFILLER_55_172 VGND VGND VPWR VPWR sky130_fd_sc_hd__fill_2
XFILLER_55_194 VGND VGND VPWR VPWR sky130_fd_sc_hd__decap_3
XFILLER_70_120 VGND VGND VPWR VPWR sky130_fd_sc_hd__decap_3
XFILLER_83_492 VGND VGND VPWR VPWR sky130_fd_sc_hd__decap_3
XFILLER_43_378 VGND VGND VPWR VPWR sky130_fd_sc_hd__decap_3
XFILLER_34_85 VGND VGND VPWR VPWR sky130_fd_sc_hd__decap_3
XFILLER_11_264 VGND VGND VPWR VPWR sky130_fd_sc_hd__decap_3
XFILLER_50_62 VGND VGND VPWR VPWR sky130_fd_sc_hd__decap_3
XFILLER_3_430 VGND VGND VPWR VPWR sky130_fd_sc_hd__decap_3
XFILLER_3_452 VGND VGND VPWR VPWR sky130_fd_sc_hd__fill_2
XFILLER_59_60 VGND VGND VPWR VPWR sky130_fd_sc_hd__decap_3
XFILLER_78_253 VGND VGND VPWR VPWR sky130_fd_sc_hd__decap_3
XFILLER_78_242 VGND VGND VPWR VPWR sky130_fd_sc_hd__decap_3
XFILLER_66_404 VGND VGND VPWR VPWR sky130_fd_sc_hd__decap_3
XTAP_TAPCELL_ROW_77_933 VGND VPWR sky130_fd_sc_hd__tapvpwrvgnd_1
XFILLER_15_6 VGND VGND VPWR VPWR sky130_fd_sc_hd__decap_3
XFILLER_66_448 VGND VGND VPWR VPWR sky130_fd_sc_hd__decap_3
XTAP_TAPCELL_ROW_49_668 VGND VPWR sky130_fd_sc_hd__tapvpwrvgnd_1
XFILLER_75_81 VGND VGND VPWR VPWR sky130_fd_sc_hd__decap_3
XFILLER_34_301 VGND VGND VPWR VPWR sky130_fd_sc_hd__decap_3
XFILLER_34_312 VGND VGND VPWR VPWR sky130_fd_sc_hd__fill_2
XFILLER_34_334 VGND VGND VPWR VPWR sky130_fd_sc_hd__decap_3
XFILLER_46_183 VGND VGND VPWR VPWR sky130_fd_sc_hd__decap_3
XFILLER_22_507 VGND VGND VPWR VPWR sky130_fd_sc_hd__decap_3
XFILLER_61_186 VGND VGND VPWR VPWR sky130_fd_sc_hd__decap_3
X_2972_ _2906_/X _2984_/A2 _2968_/Y _4902_/Q VGND VGND VPWR VPWR _4902_/D sky130_fd_sc_hd__a22o_2
XTAP_TAPCELL_ROW_32_502 VGND VPWR sky130_fd_sc_hd__tapvpwrvgnd_1
X_4711_ _3682_/B _4224_/A _4417_/X _4641_/X _4705_/X VGND VGND VPWR VPWR _4712_/D
+ sky130_fd_sc_hd__o221a_2
X_4642_ _4642_/A _4686_/S _4642_/C VGND VGND VPWR VPWR _4671_/B sky130_fd_sc_hd__nor3_2
X_4573_ _4573_/A _4573_/B VGND VGND VPWR VPWR _4573_/Y sky130_fd_sc_hd__nand2_2
X_3524_ _3522_/X _3524_/B VGND VGND VPWR VPWR _3526_/A sky130_fd_sc_hd__and2b_2
X_3455_ _5175_/Q _5174_/Q _5173_/Q _3453_/X VGND VGND VPWR VPWR _3455_/X sky130_fd_sc_hd__o31a_2
XFILLER_39_19 VGND VGND VPWR VPWR sky130_fd_sc_hd__decap_3
X_3386_ _5166_/Q _3386_/B VGND VGND VPWR VPWR _3387_/B sky130_fd_sc_hd__or2_2
XFILLER_29_106 VGND VGND VPWR VPWR sky130_fd_sc_hd__decap_3
X_5125_ clkload3/A _5125_/D VGND VGND VPWR VPWR _5125_/Q sky130_fd_sc_hd__dfxtp_2
XTAP_TAPCELL_ROW_4_238 VGND VPWR sky130_fd_sc_hd__tapvpwrvgnd_1
XFILLER_29_128 VGND VGND VPWR VPWR sky130_fd_sc_hd__decap_3
X_5056_ clkload6/A _5056_/D VGND VGND VPWR VPWR _5056_/Q sky130_fd_sc_hd__dfxtp_2
XFILLER_84_234 VGND VGND VPWR VPWR sky130_fd_sc_hd__decap_3
XFILLER_72_418 VGND VGND VPWR VPWR sky130_fd_sc_hd__fill_2
X_4007_ _4471_/A _4551_/A _4010_/S VGND VGND VPWR VPWR _4007_/X sky130_fd_sc_hd__mux2_1
XFILLER_25_301 VGND VGND VPWR VPWR sky130_fd_sc_hd__decap_3
XFILLER_25_334 VGND VGND VPWR VPWR sky130_fd_sc_hd__fill_2
XFILLER_37_161 VGND VGND VPWR VPWR sky130_fd_sc_hd__decap_3
XFILLER_37_172 VGND VGND VPWR VPWR sky130_fd_sc_hd__decap_3
XFILLER_65_481 VGND VGND VPWR VPWR sky130_fd_sc_hd__decap_3
XFILLER_52_153 VGND VGND VPWR VPWR sky130_fd_sc_hd__decap_3
XFILLER_80_440 VGND VGND VPWR VPWR sky130_fd_sc_hd__decap_3
XFILLER_40_315 VGND VGND VPWR VPWR sky130_fd_sc_hd__decap_3
XFILLER_71_17 VGND VGND VPWR VPWR sky130_fd_sc_hd__decap_3
XFILLER_80_495 VGND VGND VPWR VPWR sky130_fd_sc_hd__decap_3
XFILLER_40_348 VGND VGND VPWR VPWR sky130_fd_sc_hd__decap_3
X_4909_ _5007_/CLK _4909_/D VGND VGND VPWR VPWR _4909_/Q sky130_fd_sc_hd__dfxtp_2
XFILLER_20_21 VGND VGND VPWR VPWR sky130_fd_sc_hd__decap_3
XFILLER_20_43 VGND VGND VPWR VPWR sky130_fd_sc_hd__decap_3
XFILLER_0_433 VGND VGND VPWR VPWR sky130_fd_sc_hd__fill_2
XFILLER_0_455 VGND VGND VPWR VPWR sky130_fd_sc_hd__decap_3
XFILLER_0_477 VGND VGND VPWR VPWR sky130_fd_sc_hd__decap_3
XFILLER_29_30 VGND VGND VPWR VPWR sky130_fd_sc_hd__decap_3
XFILLER_48_404 VGND VGND VPWR VPWR sky130_fd_sc_hd__decap_3
XFILLER_75_212 VGND VGND VPWR VPWR sky130_fd_sc_hd__fill_2
XFILLER_29_85 VGND VGND VPWR VPWR sky130_fd_sc_hd__decap_3
XFILLER_48_437 VGND VGND VPWR VPWR sky130_fd_sc_hd__decap_3
XFILLER_63_418 VGND VGND VPWR VPWR sky130_fd_sc_hd__decap_3
XTAP_TAPCELL_ROW_74_903 VGND VPWR sky130_fd_sc_hd__tapvpwrvgnd_1
XFILLER_28_161 VGND VGND VPWR VPWR sky130_fd_sc_hd__decap_3
XFILLER_56_492 VGND VGND VPWR VPWR sky130_fd_sc_hd__fill_1
XTAP_TAPCELL_ROW_46_638 VGND VPWR sky130_fd_sc_hd__tapvpwrvgnd_1
XFILLER_90_237 VGND VGND VPWR VPWR sky130_fd_sc_hd__fill_1
XFILLER_16_356 VGND VGND VPWR VPWR sky130_fd_sc_hd__decap_3
XFILLER_43_131 VGND VGND VPWR VPWR sky130_fd_sc_hd__fill_1
XFILLER_43_142 VGND VGND VPWR VPWR sky130_fd_sc_hd__decap_3
XFILLER_43_175 VGND VGND VPWR VPWR sky130_fd_sc_hd__fill_1
XFILLER_71_462 VGND VGND VPWR VPWR sky130_fd_sc_hd__decap_3
XFILLER_71_495 VGND VGND VPWR VPWR sky130_fd_sc_hd__fill_2
XTAP_TAPCELL_ROW_82_980 VGND VPWR sky130_fd_sc_hd__tapvpwrvgnd_1
XFILLER_31_337 VGND VGND VPWR VPWR sky130_fd_sc_hd__decap_3
XFILLER_8_522 VGND VGND VPWR VPWR sky130_fd_sc_hd__decap_3
XFILLER_8_500 VGND VGND VPWR VPWR sky130_fd_sc_hd__fill_2
XFILLER_61_72 VGND VGND VPWR VPWR sky130_fd_sc_hd__decap_3
XFILLER_8_533 VGND VGND VPWR VPWR sky130_fd_sc_hd__fill_1
XFILLER_6_23 VGND VGND VPWR VPWR sky130_fd_sc_hd__decap_3
XFILLER_6_78 VGND VGND VPWR VPWR sky130_fd_sc_hd__decap_3
X_3240_ _5165_/Q _3429_/C _3228_/Y _3239_/X VGND VGND VPWR VPWR _5128_/D sky130_fd_sc_hd__o22a_2
XFILLER_79_551 VGND VGND VPWR VPWR sky130_fd_sc_hd__fill_2
X_3171_ _3189_/A _3171_/B VGND VGND VPWR VPWR _3172_/B sky130_fd_sc_hd__nor2_2
XFILLER_13_3 VGND VGND VPWR VPWR sky130_fd_sc_hd__fill_1
XFILLER_66_223 VGND VGND VPWR VPWR sky130_fd_sc_hd__decap_3
XFILLER_54_418 VGND VGND VPWR VPWR sky130_fd_sc_hd__fill_2
XFILLER_66_256 VGND VGND VPWR VPWR sky130_fd_sc_hd__decap_3
XTAP_TAPCELL_ROW_1_208 VGND VPWR sky130_fd_sc_hd__tapvpwrvgnd_1
XFILLER_19_172 VGND VGND VPWR VPWR sky130_fd_sc_hd__decap_3
XFILLER_47_492 VGND VGND VPWR VPWR sky130_fd_sc_hd__decap_3
XFILLER_34_153 VGND VGND VPWR VPWR sky130_fd_sc_hd__fill_1
XTAP_TAPCELL_ROW_17_362 VGND VPWR sky130_fd_sc_hd__tapvpwrvgnd_1
XFILLER_22_326 VGND VGND VPWR VPWR sky130_fd_sc_hd__decap_3
XFILLER_22_359 VGND VGND VPWR VPWR sky130_fd_sc_hd__decap_3
XFILLER_34_197 VGND VGND VPWR VPWR sky130_fd_sc_hd__decap_3
X_2955_ _2916_/X _2961_/A2 _2961_/B1 _4889_/Q VGND VGND VPWR VPWR _4889_/D sky130_fd_sc_hd__a22o_2
X_2886_ _2886_/A _2886_/B _2886_/C VGND VGND VPWR VPWR _2887_/A sky130_fd_sc_hd__and3_2
X_4625_ _4624_/A _4521_/Y _4624_/Y VGND VGND VPWR VPWR _4625_/Y sky130_fd_sc_hd__o21ai_2
X_4556_ _4556_/A _4556_/B _4556_/C _4556_/D VGND VGND VPWR VPWR _4556_/X sky130_fd_sc_hd__or4_2
X_3507_ _5157_/Q _5138_/Q VGND VGND VPWR VPWR _3510_/A sky130_fd_sc_hd__nor2_2
XFILLER_89_304 VGND VGND VPWR VPWR sky130_fd_sc_hd__decap_3
X_4487_ _4388_/Y _4481_/X _4486_/X _4136_/Y VGND VGND VPWR VPWR _4487_/X sky130_fd_sc_hd__a31o_2
X_3438_ _5260_/Q _3448_/B _3438_/C VGND VGND VPWR VPWR _3438_/X sky130_fd_sc_hd__and3_2
X_3369_ _3369_/A _3369_/B VGND VGND VPWR VPWR _3378_/B sky130_fd_sc_hd__and2_2
X_5108_ _5119_/CLK _5108_/D VGND VGND VPWR VPWR _5108_/Q sky130_fd_sc_hd__dfxtp_2
XFILLER_57_256 VGND VGND VPWR VPWR sky130_fd_sc_hd__decap_3
XFILLER_57_278 VGND VGND VPWR VPWR sky130_fd_sc_hd__fill_2
X_5039_ _5098_/CLK _5039_/D VGND VGND VPWR VPWR _5039_/Q sky130_fd_sc_hd__dfxtp_2
XFILLER_25_131 VGND VGND VPWR VPWR sky130_fd_sc_hd__decap_3
XTAP_TAPCELL_ROW_43_608 VGND VPWR sky130_fd_sc_hd__tapvpwrvgnd_1
XFILLER_82_38 VGND VGND VPWR VPWR sky130_fd_sc_hd__decap_3
XFILLER_15_32 VGND VGND VPWR VPWR sky130_fd_sc_hd__decap_3
XFILLER_53_473 VGND VGND VPWR VPWR sky130_fd_sc_hd__decap_3
XFILLER_13_326 VGND VGND VPWR VPWR sky130_fd_sc_hd__decap_3
XFILLER_13_337 VGND VGND VPWR VPWR sky130_fd_sc_hd__decap_3
XFILLER_40_134 VGND VGND VPWR VPWR sky130_fd_sc_hd__decap_3
XFILLER_80_292 VGND VGND VPWR VPWR sky130_fd_sc_hd__decap_3
XFILLER_15_76 VGND VGND VPWR VPWR sky130_fd_sc_hd__fill_2
XFILLER_40_167 VGND VGND VPWR VPWR sky130_fd_sc_hd__decap_3
XFILLER_40_178 VGND VGND VPWR VPWR sky130_fd_sc_hd__decap_3
XTAP_TAPCELL_ROW_51_685 VGND VPWR sky130_fd_sc_hd__tapvpwrvgnd_1
Xoutput53 _2699_/Y VGND VGND VPWR VPWR DEVICES_STRW sky130_fd_sc_hd__clkdlybuf4s25_1
Xoutput64 _5136_/Q VGND VGND VPWR VPWR INSTR_ADDR[3] sky130_fd_sc_hd__clkdlybuf4s25_1
Xoutput75 _2693_/Y VGND VGND VPWR VPWR MAIN_STRW sky130_fd_sc_hd__clkdlybuf4s25_1
XTAP_TAPCELL_ROW_91_1069 VGND VPWR sky130_fd_sc_hd__tapvpwrvgnd_1
Xoutput86 _2862_/Y VGND VGND VPWR VPWR MEM_ADDR[4] sky130_fd_sc_hd__clkdlybuf4s25_1
Xoutput97 _2842_/X VGND VGND VPWR VPWR MEM_STR_DATA[14] sky130_fd_sc_hd__clkdlybuf4s25_1
XFILLER_0_274 VGND VGND VPWR VPWR sky130_fd_sc_hd__decap_3
XFILLER_0_296 VGND VGND VPWR VPWR sky130_fd_sc_hd__fill_2
XFILLER_48_212 VGND VGND VPWR VPWR sky130_fd_sc_hd__decap_3
XFILLER_88_381 VGND VGND VPWR VPWR sky130_fd_sc_hd__decap_3
XFILLER_36_407 VGND VGND VPWR VPWR sky130_fd_sc_hd__decap_3
XFILLER_48_267 VGND VGND VPWR VPWR sky130_fd_sc_hd__fill_2
XFILLER_56_50 VGND VGND VPWR VPWR sky130_fd_sc_hd__decap_3
XTAP_TAPCELL_ROW_59_763 VGND VPWR sky130_fd_sc_hd__tapvpwrvgnd_1
XFILLER_56_83 VGND VGND VPWR VPWR sky130_fd_sc_hd__fill_1
XFILLER_56_94 VGND VGND VPWR VPWR sky130_fd_sc_hd__decap_3
XFILLER_44_462 VGND VGND VPWR VPWR sky130_fd_sc_hd__fill_2
XFILLER_16_197 VGND VGND VPWR VPWR sky130_fd_sc_hd__decap_3
XFILLER_71_270 VGND VGND VPWR VPWR sky130_fd_sc_hd__decap_3
XTAP_TAPCELL_ROW_14_332 VGND VPWR sky130_fd_sc_hd__tapvpwrvgnd_1
X_2740_ _4950_/Q _4934_/Q _4918_/Q _4902_/Q _2812_/S0 _2848_/S1 VGND VGND VPWR VPWR
+ _2740_/X sky130_fd_sc_hd__mux4_2
XFILLER_82_6 VGND VGND VPWR VPWR sky130_fd_sc_hd__fill_2
X_2671_ _4957_/Q _4941_/Q _4925_/Q _4909_/Q _5123_/Q _2671_/S1 VGND VGND VPWR VPWR
+ _2671_/X sky130_fd_sc_hd__mux4_2
X_4410_ _4432_/B _4429_/B _4523_/S VGND VGND VPWR VPWR _4411_/A sky130_fd_sc_hd__mux2_1
X_4341_ _4341_/A _4523_/S VGND VGND VPWR VPWR _4342_/A sky130_fd_sc_hd__nand2_2
X_4272_ _5176_/Q _4750_/S _4287_/A _3999_/B VGND VGND VPWR VPWR _4274_/B sky130_fd_sc_hd__a211o_2
X_3223_ _2941_/X _3208_/B _3208_/Y _5121_/Q VGND VGND VPWR VPWR _5121_/D sky130_fd_sc_hd__a22o_2
XFILLER_86_318 VGND VGND VPWR VPWR sky130_fd_sc_hd__decap_3
XFILLER_39_212 VGND VGND VPWR VPWR sky130_fd_sc_hd__decap_3
XFILLER_67_532 VGND VGND VPWR VPWR sky130_fd_sc_hd__decap_3
XFILLER_39_267 VGND VGND VPWR VPWR sky130_fd_sc_hd__fill_2
X_3154_ _4866_/A _3154_/B VGND VGND VPWR VPWR _3154_/Y sky130_fd_sc_hd__nor2_2
XFILLER_54_215 VGND VGND VPWR VPWR sky130_fd_sc_hd__decap_3
X_3085_ _2910_/X _3093_/A2 _3096_/B1 _4999_/Q VGND VGND VPWR VPWR _4999_/D sky130_fd_sc_hd__a22o_2
XFILLER_54_259 VGND VGND VPWR VPWR sky130_fd_sc_hd__fill_2
XFILLER_82_546 VGND VGND VPWR VPWR sky130_fd_sc_hd__decap_3
XFILLER_22_123 VGND VGND VPWR VPWR sky130_fd_sc_hd__decap_3
XFILLER_50_421 VGND VGND VPWR VPWR sky130_fd_sc_hd__decap_3
XFILLER_62_270 VGND VGND VPWR VPWR sky130_fd_sc_hd__decap_3
XFILLER_22_167 VGND VGND VPWR VPWR sky130_fd_sc_hd__decap_3
XFILLER_50_454 VGND VGND VPWR VPWR sky130_fd_sc_hd__fill_2
X_3987_ _3999_/A _4003_/B VGND VGND VPWR VPWR _3989_/B sky130_fd_sc_hd__or2_2
Xclkbuf_2_2__f_CLK clkbuf_0_CLK/X VGND VGND VPWR VPWR clkload1/A sky130_fd_sc_hd__clkbuf_16
X_2938_ _5203_/Q _2455_/X _3456_/B _5251_/Q _2937_/X VGND VGND VPWR VPWR _2938_/X
+ sky130_fd_sc_hd__a221o_2
X_2869_ _2887_/B _2869_/B VGND VGND VPWR VPWR _2869_/Y sky130_fd_sc_hd__nor2_2
X_4608_ _4662_/A _4608_/B VGND VGND VPWR VPWR _4608_/Y sky130_fd_sc_hd__nand2_2
X_4539_ _4541_/A VGND VGND VPWR VPWR _4539_/Y sky130_fd_sc_hd__inv_2
XFILLER_77_329 VGND VGND VPWR VPWR sky130_fd_sc_hd__decap_3
XFILLER_58_521 VGND VGND VPWR VPWR sky130_fd_sc_hd__decap_3
XFILLER_93_15 VGND VGND VPWR VPWR sky130_fd_sc_hd__decap_3
XFILLER_85_340 VGND VGND VPWR VPWR sky130_fd_sc_hd__decap_3
XFILLER_45_204 VGND VGND VPWR VPWR sky130_fd_sc_hd__fill_2
XFILLER_73_535 VGND VGND VPWR VPWR sky130_fd_sc_hd__decap_3
XFILLER_85_373 VGND VGND VPWR VPWR sky130_fd_sc_hd__decap_3
XFILLER_45_248 VGND VGND VPWR VPWR sky130_fd_sc_hd__decap_3
XTAP_TAPCELL_ROW_56_733 VGND VPWR sky130_fd_sc_hd__tapvpwrvgnd_1
XFILLER_26_64 VGND VGND VPWR VPWR sky130_fd_sc_hd__fill_1
XFILLER_60_218 VGND VGND VPWR VPWR sky130_fd_sc_hd__decap_3
XTAP_TAPCELL_ROW_28_468 VGND VPWR sky130_fd_sc_hd__tapvpwrvgnd_1
XFILLER_26_484 VGND VGND VPWR VPWR sky130_fd_sc_hd__decap_3
XFILLER_41_432 VGND VGND VPWR VPWR sky130_fd_sc_hd__decap_3
XFILLER_53_281 VGND VGND VPWR VPWR sky130_fd_sc_hd__decap_3
XFILLER_9_116 VGND VGND VPWR VPWR sky130_fd_sc_hd__decap_3
XFILLER_41_487 VGND VGND VPWR VPWR sky130_fd_sc_hd__decap_3
XTAP_TAPCELL_ROW_11_302 VGND VPWR sky130_fd_sc_hd__tapvpwrvgnd_1
XFILLER_42_74 VGND VGND VPWR VPWR sky130_fd_sc_hd__decap_3
XFILLER_42_85 VGND VGND VPWR VPWR sky130_fd_sc_hd__decap_3
XFILLER_5_322 VGND VGND VPWR VPWR sky130_fd_sc_hd__decap_3
XPHY_EDGE_ROW_39_Left_133 VGND VGND VPWR VPWR sky130_fd_sc_hd__decap_3
XFILLER_5_399 VGND VGND VPWR VPWR sky130_fd_sc_hd__fill_2
XFILLER_1_550 VGND VGND VPWR VPWR sky130_fd_sc_hd__decap_3
XFILLER_3_24 VGND VGND VPWR VPWR sky130_fd_sc_hd__decap_3
XFILLER_68_307 VGND VGND VPWR VPWR sky130_fd_sc_hd__fill_1
XFILLER_67_60 VGND VGND VPWR VPWR sky130_fd_sc_hd__decap_3
XFILLER_49_543 VGND VGND VPWR VPWR sky130_fd_sc_hd__fill_2
XFILLER_64_524 VGND VGND VPWR VPWR sky130_fd_sc_hd__decap_3
XPHY_EDGE_ROW_48_Left_142 VGND VGND VPWR VPWR sky130_fd_sc_hd__decap_3
XFILLER_76_395 VGND VGND VPWR VPWR sky130_fd_sc_hd__decap_3
XFILLER_17_440 VGND VGND VPWR VPWR sky130_fd_sc_hd__decap_3
XFILLER_36_237 VGND VGND VPWR VPWR sky130_fd_sc_hd__decap_3
XFILLER_36_259 VGND VGND VPWR VPWR sky130_fd_sc_hd__decap_3
XFILLER_91_376 VGND VGND VPWR VPWR sky130_fd_sc_hd__decap_3
XFILLER_83_70 VGND VGND VPWR VPWR sky130_fd_sc_hd__decap_3
XFILLER_17_495 VGND VGND VPWR VPWR sky130_fd_sc_hd__decap_3
XFILLER_32_432 VGND VGND VPWR VPWR sky130_fd_sc_hd__decap_3
XFILLER_44_292 VGND VGND VPWR VPWR sky130_fd_sc_hd__decap_3
X_4890_ _5114_/CLK _4890_/D VGND VGND VPWR VPWR _4890_/Q sky130_fd_sc_hd__dfxtp_2
X_3910_ _4473_/A _3910_/B VGND VGND VPWR VPWR _3910_/Y sky130_fd_sc_hd__nor2_2
X_3841_ _4445_/B _4405_/B VGND VGND VPWR VPWR _3992_/B sky130_fd_sc_hd__nand2_2
X_3772_ _3831_/A _3771_/X _5130_/Q VGND VGND VPWR VPWR _3772_/X sky130_fd_sc_hd__o21a_2
XFILLER_80_3 VGND VGND VPWR VPWR sky130_fd_sc_hd__decap_3
X_2723_ _5133_/Q _2722_/X _2437_/Y VGND VGND VPWR VPWR _2723_/X sky130_fd_sc_hd__o21a_2
XPHY_EDGE_ROW_57_Left_151 VGND VGND VPWR VPWR sky130_fd_sc_hd__decap_3
X_2654_ _4894_/Q _4878_/Q _5102_/Q _5086_/Q _2658_/S0 _2671_/S1 VGND VGND VPWR VPWR
+ _2655_/B sky130_fd_sc_hd__mux4_2
X_2585_ _2585_/A _2585_/B VGND VGND VPWR VPWR _4048_/A sky130_fd_sc_hd__nor2_2
X_4324_ _4324_/A _4324_/B _4318_/X VGND VGND VPWR VPWR _4324_/X sky130_fd_sc_hd__or3b_2
XFILLER_59_329 VGND VGND VPWR VPWR sky130_fd_sc_hd__decap_3
X_4255_ _4255_/A _4255_/B VGND VGND VPWR VPWR _4258_/D sky130_fd_sc_hd__or2_2
XFILLER_67_351 VGND VGND VPWR VPWR sky130_fd_sc_hd__decap_3
X_4186_ _4172_/X _4174_/X _4183_/X _2452_/Y VGND VGND VPWR VPWR _4186_/X sky130_fd_sc_hd__a211o_2
X_3206_ _2944_/X _3190_/B _3190_/Y _5106_/Q VGND VGND VPWR VPWR _5106_/D sky130_fd_sc_hd__a22o_2
XPHY_EDGE_ROW_66_Left_160 VGND VGND VPWR VPWR sky130_fd_sc_hd__decap_3
XFILLER_55_502 VGND VGND VPWR VPWR sky130_fd_sc_hd__fill_2
X_3137_ _2891_/X _3152_/A2 _3136_/Y _5043_/Q VGND VGND VPWR VPWR _5043_/D sky130_fd_sc_hd__a22o_2
XFILLER_82_321 VGND VGND VPWR VPWR sky130_fd_sc_hd__decap_3
XFILLER_42_218 VGND VGND VPWR VPWR sky130_fd_sc_hd__decap_3
X_3068_ _2916_/X _3074_/A2 _3061_/Y _4985_/Q VGND VGND VPWR VPWR _4985_/D sky130_fd_sc_hd__a22o_2
XTAP_TAPCELL_ROW_53_703 VGND VPWR sky130_fd_sc_hd__tapvpwrvgnd_1
XFILLER_82_376 VGND VGND VPWR VPWR sky130_fd_sc_hd__decap_3
XFILLER_23_421 VGND VGND VPWR VPWR sky130_fd_sc_hd__decap_3
XFILLER_35_281 VGND VGND VPWR VPWR sky130_fd_sc_hd__decap_3
XTAP_TAPCELL_ROW_25_438 VGND VPWR sky130_fd_sc_hd__tapvpwrvgnd_1
XFILLER_50_251 VGND VGND VPWR VPWR sky130_fd_sc_hd__fill_1
XFILLER_10_115 VGND VGND VPWR VPWR sky130_fd_sc_hd__decap_3
XFILLER_50_273 VGND VGND VPWR VPWR sky130_fd_sc_hd__decap_3
XTAP_TAPCELL_ROW_61_780 VGND VPWR sky130_fd_sc_hd__tapvpwrvgnd_1
XFILLER_12_66 VGND VGND VPWR VPWR sky130_fd_sc_hd__decap_3
XFILLER_12_88 VGND VGND VPWR VPWR sky130_fd_sc_hd__decap_3
XFILLER_46_513 VGND VGND VPWR VPWR sky130_fd_sc_hd__decap_3
XFILLER_58_362 VGND VGND VPWR VPWR sky130_fd_sc_hd__fill_2
XFILLER_18_259 VGND VGND VPWR VPWR sky130_fd_sc_hd__decap_3
XFILLER_37_52 VGND VGND VPWR VPWR sky130_fd_sc_hd__decap_3
XFILLER_37_63 VGND VGND VPWR VPWR sky130_fd_sc_hd__decap_3
XFILLER_46_546 VGND VGND VPWR VPWR sky130_fd_sc_hd__decap_3
XFILLER_73_343 VGND VGND VPWR VPWR sky130_fd_sc_hd__fill_2
XFILLER_61_505 VGND VGND VPWR VPWR sky130_fd_sc_hd__decap_3
XFILLER_14_421 VGND VGND VPWR VPWR sky130_fd_sc_hd__decap_3
XFILLER_26_281 VGND VGND VPWR VPWR sky130_fd_sc_hd__fill_2
XFILLER_73_398 VGND VGND VPWR VPWR sky130_fd_sc_hd__fill_2
XFILLER_14_454 VGND VGND VPWR VPWR sky130_fd_sc_hd__decap_3
XFILLER_41_240 VGND VGND VPWR VPWR sky130_fd_sc_hd__decap_3
XFILLER_53_40 VGND VGND VPWR VPWR sky130_fd_sc_hd__decap_3
XFILLER_41_262 VGND VGND VPWR VPWR sky130_fd_sc_hd__fill_2
XFILLER_41_284 VGND VGND VPWR VPWR sky130_fd_sc_hd__decap_3
XFILLER_53_73 VGND VGND VPWR VPWR sky130_fd_sc_hd__decap_3
XFILLER_5_152 VGND VGND VPWR VPWR sky130_fd_sc_hd__decap_3
XFILLER_78_81 VGND VGND VPWR VPWR sky130_fd_sc_hd__decap_3
XFILLER_1_391 VGND VGND VPWR VPWR sky130_fd_sc_hd__fill_1
XFILLER_49_340 VGND VGND VPWR VPWR sky130_fd_sc_hd__decap_3
X_4040_ _4040_/A _4040_/B VGND VGND VPWR VPWR _4041_/C sky130_fd_sc_hd__or2_2
XFILLER_49_373 VGND VGND VPWR VPWR sky130_fd_sc_hd__decap_3
XTAP_TAPCELL_ROW_67_839 VGND VPWR sky130_fd_sc_hd__tapvpwrvgnd_1
XFILLER_37_535 VGND VGND VPWR VPWR sky130_fd_sc_hd__decap_3
XFILLER_37_546 VGND VGND VPWR VPWR sky130_fd_sc_hd__decap_3
XFILLER_76_181 VGND VGND VPWR VPWR sky130_fd_sc_hd__decap_3
XFILLER_52_516 VGND VGND VPWR VPWR sky130_fd_sc_hd__decap_3
XFILLER_64_354 VGND VGND VPWR VPWR sky130_fd_sc_hd__fill_1
XFILLER_64_365 VGND VGND VPWR VPWR sky130_fd_sc_hd__decap_3
XFILLER_17_281 VGND VGND VPWR VPWR sky130_fd_sc_hd__decap_3
XFILLER_24_229 VGND VGND VPWR VPWR sky130_fd_sc_hd__fill_1
X_4942_ _5116_/CLK _4942_/D VGND VGND VPWR VPWR _4942_/Q sky130_fd_sc_hd__dfxtp_2
X_4873_ _5092_/CLK _4873_/D VGND VGND VPWR VPWR _4873_/Q sky130_fd_sc_hd__dfxtp_2
XTAP_TAPCELL_ROW_22_408 VGND VPWR sky130_fd_sc_hd__tapvpwrvgnd_1
XFILLER_20_435 VGND VGND VPWR VPWR sky130_fd_sc_hd__fill_1
X_3824_ _4445_/A _4397_/A VGND VGND VPWR VPWR _4611_/S sky130_fd_sc_hd__nor2_2
X_3755_ _3756_/B VGND VGND VPWR VPWR _4330_/B sky130_fd_sc_hd__inv_2
X_3686_ _3831_/A _3685_/X _5130_/Q VGND VGND VPWR VPWR _3686_/X sky130_fd_sc_hd__o21a_2
X_2706_ _5261_/Q _2705_/X _3442_/B VGND VGND VPWR VPWR _5261_/D sky130_fd_sc_hd__o21a_2
XTAP_TAPCELL_ROW_30_485 VGND VPWR sky130_fd_sc_hd__tapvpwrvgnd_1
X_2637_ _2638_/B VGND VGND VPWR VPWR _2652_/B sky130_fd_sc_hd__inv_2
XPHY_EDGE_ROW_12_Right_12 VGND VGND VPWR VPWR sky130_fd_sc_hd__decap_3
XFILLER_58_29 VGND VGND VPWR VPWR sky130_fd_sc_hd__decap_3
X_2568_ _4950_/Q _4934_/Q _4918_/Q _4902_/Q _2658_/S0 _2671_/S1 VGND VGND VPWR VPWR
+ _2568_/X sky130_fd_sc_hd__mux4_2
XFILLER_87_402 VGND VGND VPWR VPWR sky130_fd_sc_hd__decap_3
X_4307_ _5218_/Q _4700_/S _4306_/Y _3442_/B VGND VGND VPWR VPWR _5218_/D sky130_fd_sc_hd__o211a_2
X_2499_ _2493_/X _2495_/X _2498_/X _2435_/Y VGND VGND VPWR VPWR _4471_/A sky130_fd_sc_hd__a22o_2
XFILLER_87_435 VGND VGND VPWR VPWR sky130_fd_sc_hd__decap_3
X_4238_ _4284_/B _4716_/A VGND VGND VPWR VPWR _4285_/D sky130_fd_sc_hd__nor2_2
XFILLER_87_468 VGND VGND VPWR VPWR sky130_fd_sc_hd__decap_3
XFILLER_28_502 VGND VGND VPWR VPWR sky130_fd_sc_hd__decap_3
XFILLER_28_524 VGND VGND VPWR VPWR sky130_fd_sc_hd__decap_3
XFILLER_74_129 VGND VGND VPWR VPWR sky130_fd_sc_hd__decap_3
XFILLER_55_321 VGND VGND VPWR VPWR sky130_fd_sc_hd__decap_3
XFILLER_55_343 VGND VGND VPWR VPWR sky130_fd_sc_hd__fill_1
X_4169_ _5212_/Q _4168_/A _4168_/Y _3448_/B VGND VGND VPWR VPWR _5212_/D sky130_fd_sc_hd__o211a_2
XFILLER_43_505 VGND VGND VPWR VPWR sky130_fd_sc_hd__fill_2
XFILLER_55_376 VGND VGND VPWR VPWR sky130_fd_sc_hd__decap_3
XFILLER_70_302 VGND VGND VPWR VPWR sky130_fd_sc_hd__decap_3
XTAP_TAPCELL_ROW_38_563 VGND VPWR sky130_fd_sc_hd__tapvpwrvgnd_1
XPHY_EDGE_ROW_21_Right_21 VGND VGND VPWR VPWR sky130_fd_sc_hd__decap_3
XFILLER_43_549 VGND VGND VPWR VPWR sky130_fd_sc_hd__decap_3
XFILLER_70_324 VGND VGND VPWR VPWR sky130_fd_sc_hd__decap_3
XFILLER_82_195 VGND VGND VPWR VPWR sky130_fd_sc_hd__fill_1
XFILLER_70_357 VGND VGND VPWR VPWR sky130_fd_sc_hd__decap_3
XFILLER_70_368 VGND VGND VPWR VPWR sky130_fd_sc_hd__decap_3
XFILLER_23_284 VGND VGND VPWR VPWR sky130_fd_sc_hd__decap_3
XFILLER_23_32 VGND VGND VPWR VPWR sky130_fd_sc_hd__decap_3
XFILLER_23_98 VGND VGND VPWR VPWR sky130_fd_sc_hd__decap_3
XPHY_EDGE_ROW_30_Right_30 VGND VGND VPWR VPWR sky130_fd_sc_hd__decap_3
XFILLER_2_144 VGND VGND VPWR VPWR sky130_fd_sc_hd__fill_2
XFILLER_78_402 VGND VGND VPWR VPWR sky130_fd_sc_hd__decap_3
XFILLER_78_435 VGND VGND VPWR VPWR sky130_fd_sc_hd__decap_3
XFILLER_78_424 VGND VGND VPWR VPWR sky130_fd_sc_hd__decap_3
XFILLER_19_513 VGND VGND VPWR VPWR sky130_fd_sc_hd__fill_1
XFILLER_48_62 VGND VGND VPWR VPWR sky130_fd_sc_hd__decap_3
XFILLER_93_427 VGND VGND VPWR VPWR sky130_fd_sc_hd__decap_3
XFILLER_93_416 VGND VGND VPWR VPWR sky130_fd_sc_hd__decap_3
XFILLER_46_332 VGND VGND VPWR VPWR sky130_fd_sc_hd__decap_3
XFILLER_58_170 VGND VGND VPWR VPWR sky130_fd_sc_hd__fill_2
XFILLER_93_449 VGND VGND VPWR VPWR sky130_fd_sc_hd__decap_3
XFILLER_0_69 VGND VGND VPWR VPWR sky130_fd_sc_hd__decap_3
XFILLER_34_505 VGND VGND VPWR VPWR sky130_fd_sc_hd__decap_3
XFILLER_46_354 VGND VGND VPWR VPWR sky130_fd_sc_hd__decap_3
XFILLER_46_365 VGND VGND VPWR VPWR sky130_fd_sc_hd__decap_3
XFILLER_61_302 VGND VGND VPWR VPWR sky130_fd_sc_hd__decap_3
XFILLER_73_151 VGND VGND VPWR VPWR sky130_fd_sc_hd__decap_3
XTAP_TAPCELL_ROW_64_809 VGND VPWR sky130_fd_sc_hd__tapvpwrvgnd_1
XFILLER_34_538 VGND VGND VPWR VPWR sky130_fd_sc_hd__decap_3
XFILLER_64_50 VGND VGND VPWR VPWR sky130_fd_sc_hd__decap_3
XFILLER_73_195 VGND VGND VPWR VPWR sky130_fd_sc_hd__decap_3
XFILLER_64_94 VGND VGND VPWR VPWR sky130_fd_sc_hd__decap_3
XFILLER_14_262 VGND VGND VPWR VPWR sky130_fd_sc_hd__decap_3
XTAP_TAPCELL_ROW_72_886 VGND VPWR sky130_fd_sc_hd__tapvpwrvgnd_1
X_3540_ _3549_/A _3540_/B VGND VGND VPWR VPWR _3541_/B sky130_fd_sc_hd__nor2_2
XFILLER_6_494 VGND VGND VPWR VPWR sky130_fd_sc_hd__decap_3
X_5210_ _5210_/CLK _5210_/D VGND VGND VPWR VPWR _5210_/Q sky130_fd_sc_hd__dfxtp_2
X_3471_ _5175_/Q _3453_/X _4850_/B VGND VGND VPWR VPWR _3471_/X sky130_fd_sc_hd__a21o_2
X_2422_ _5200_/Q VGND VGND VPWR VPWR _2422_/Y sky130_fd_sc_hd__inv_2
XFILLER_69_435 VGND VGND VPWR VPWR sky130_fd_sc_hd__decap_3
X_5141_ _5200_/CLK _5141_/D VGND VGND VPWR VPWR _5141_/Q sky130_fd_sc_hd__dfxtp_2
X_5072_ clkload6/A _5072_/D VGND VGND VPWR VPWR _5072_/Q sky130_fd_sc_hd__dfxtp_2
X_4023_ _4361_/A _4022_/B _3874_/D VGND VGND VPWR VPWR _4023_/X sky130_fd_sc_hd__a21o_2
XFILLER_84_405 VGND VGND VPWR VPWR sky130_fd_sc_hd__fill_2
XFILLER_77_490 VGND VGND VPWR VPWR sky130_fd_sc_hd__decap_3
XFILLER_37_343 VGND VGND VPWR VPWR sky130_fd_sc_hd__decap_3
XFILLER_25_549 VGND VGND VPWR VPWR sky130_fd_sc_hd__decap_3
XFILLER_37_398 VGND VGND VPWR VPWR sky130_fd_sc_hd__decap_3
XFILLER_52_324 VGND VGND VPWR VPWR sky130_fd_sc_hd__decap_3
XFILLER_64_173 VGND VGND VPWR VPWR sky130_fd_sc_hd__decap_3
XFILLER_52_357 VGND VGND VPWR VPWR sky130_fd_sc_hd__decap_3
XFILLER_52_368 VGND VGND VPWR VPWR sky130_fd_sc_hd__decap_3
XTAP_TAPCELL_ROW_35_533 VGND VPWR sky130_fd_sc_hd__tapvpwrvgnd_1
X_4925_ _5007_/CLK _4925_/D VGND VGND VPWR VPWR _4925_/Q sky130_fd_sc_hd__dfxtp_2
XFILLER_60_390 VGND VGND VPWR VPWR sky130_fd_sc_hd__fill_1
X_4856_ _5165_/Q _3429_/C _3228_/Y _3239_/X VGND VGND VPWR VPWR _5165_/D sky130_fd_sc_hd__o22a_2
X_3807_ _4449_/A _4403_/A VGND VGND VPWR VPWR _4592_/S sky130_fd_sc_hd__nor2_2
X_4787_ _4551_/A _4471_/A _4787_/S VGND VGND VPWR VPWR _4787_/X sky130_fd_sc_hd__mux2_1
X_3738_ _4960_/Q _4944_/Q _4928_/Q _4912_/Q _5127_/Q _5128_/Q VGND VGND VPWR VPWR
+ _3738_/X sky130_fd_sc_hd__mux4_2
X_3669_ _4551_/A _4614_/A _4010_/S VGND VGND VPWR VPWR _3669_/X sky130_fd_sc_hd__mux2_1
XFILLER_87_210 VGND VGND VPWR VPWR sky130_fd_sc_hd__decap_3
XTAP_TAPCELL_ROW_7_269 VGND VPWR sky130_fd_sc_hd__tapvpwrvgnd_1
XFILLER_87_287 VGND VGND VPWR VPWR sky130_fd_sc_hd__decap_3
XFILLER_75_416 VGND VGND VPWR VPWR sky130_fd_sc_hd__decap_3
XFILLER_47_129 VGND VGND VPWR VPWR sky130_fd_sc_hd__fill_2
XFILLER_75_449 VGND VGND VPWR VPWR sky130_fd_sc_hd__decap_3
XFILLER_18_76 VGND VGND VPWR VPWR sky130_fd_sc_hd__decap_3
XTAP_TAPCELL_ROW_87_1030 VGND VPWR sky130_fd_sc_hd__tapvpwrvgnd_1
XFILLER_28_376 VGND VGND VPWR VPWR sky130_fd_sc_hd__decap_3
XFILLER_43_302 VGND VGND VPWR VPWR sky130_fd_sc_hd__decap_3
XFILLER_43_324 VGND VGND VPWR VPWR sky130_fd_sc_hd__decap_3
XFILLER_70_132 VGND VGND VPWR VPWR sky130_fd_sc_hd__decap_3
XFILLER_70_176 VGND VGND VPWR VPWR sky130_fd_sc_hd__decap_3
XFILLER_34_97 VGND VGND VPWR VPWR sky130_fd_sc_hd__decap_3
XFILLER_11_276 VGND VGND VPWR VPWR sky130_fd_sc_hd__decap_3
XFILLER_11_298 VGND VGND VPWR VPWR sky130_fd_sc_hd__decap_3
XFILLER_50_85 VGND VGND VPWR VPWR sky130_fd_sc_hd__fill_2
XFILLER_3_475 VGND VGND VPWR VPWR sky130_fd_sc_hd__fill_2
XFILLER_3_486 VGND VGND VPWR VPWR sky130_fd_sc_hd__decap_3
XFILLER_59_72 VGND VGND VPWR VPWR sky130_fd_sc_hd__decap_3
XFILLER_66_427 VGND VGND VPWR VPWR sky130_fd_sc_hd__decap_3
XFILLER_78_265 VGND VGND VPWR VPWR sky130_fd_sc_hd__decap_3
XFILLER_19_321 VGND VGND VPWR VPWR sky130_fd_sc_hd__decap_3
XFILLER_38_129 VGND VGND VPWR VPWR sky130_fd_sc_hd__decap_3
XTAP_TAPCELL_ROW_77_934 VGND VPWR sky130_fd_sc_hd__tapvpwrvgnd_1
XFILLER_19_343 VGND VGND VPWR VPWR sky130_fd_sc_hd__decap_3
XTAP_TAPCELL_ROW_49_669 VGND VPWR sky130_fd_sc_hd__tapvpwrvgnd_1
XFILLER_93_279 VGND VGND VPWR VPWR sky130_fd_sc_hd__fill_1
XFILLER_81_408 VGND VGND VPWR VPWR sky130_fd_sc_hd__decap_3
XFILLER_75_93 VGND VGND VPWR VPWR sky130_fd_sc_hd__decap_3
XFILLER_34_346 VGND VGND VPWR VPWR sky130_fd_sc_hd__decap_3
XFILLER_22_519 VGND VGND VPWR VPWR sky130_fd_sc_hd__decap_3
X_2971_ _2903_/X _2984_/A2 _2968_/Y _4901_/Q VGND VGND VPWR VPWR _4901_/D sky130_fd_sc_hd__a22o_2
XTAP_TAPCELL_ROW_32_503 VGND VPWR sky130_fd_sc_hd__tapvpwrvgnd_1
X_4710_ _4635_/Y _4706_/X _4709_/X _4786_/A VGND VGND VPWR VPWR _4712_/C sky130_fd_sc_hd__a22o_2
X_4641_ _4642_/A _4641_/B VGND VGND VPWR VPWR _4641_/X sky130_fd_sc_hd__or2_2
XTAP_TAPCELL_ROW_40_580 VGND VPWR sky130_fd_sc_hd__tapvpwrvgnd_1
X_4572_ _4572_/A _4572_/B VGND VGND VPWR VPWR _4573_/B sky130_fd_sc_hd__xnor2_2
X_3523_ _5159_/Q _5140_/Q VGND VGND VPWR VPWR _3524_/B sky130_fd_sc_hd__or2_2
XFILLER_6_291 VGND VGND VPWR VPWR sky130_fd_sc_hd__decap_3
X_3454_ _5172_/Q _3453_/X _4850_/B VGND VGND VPWR VPWR _3454_/X sky130_fd_sc_hd__a21o_2
XFILLER_69_243 VGND VGND VPWR VPWR sky130_fd_sc_hd__fill_2
X_3385_ _5166_/Q _3386_/B VGND VGND VPWR VPWR _3387_/A sky130_fd_sc_hd__nand2_2
XFILLER_57_405 VGND VGND VPWR VPWR sky130_fd_sc_hd__decap_3
XFILLER_69_254 VGND VGND VPWR VPWR sky130_fd_sc_hd__fill_2
XFILLER_69_265 VGND VGND VPWR VPWR sky130_fd_sc_hd__decap_3
XFILLER_69_287 VGND VGND VPWR VPWR sky130_fd_sc_hd__decap_3
X_5124_ clkload3/A _5124_/D VGND VGND VPWR VPWR _5124_/Q sky130_fd_sc_hd__dfxtp_4
XTAP_TAPCELL_ROW_4_239 VGND VPWR sky130_fd_sc_hd__tapvpwrvgnd_1
XFILLER_57_449 VGND VGND VPWR VPWR sky130_fd_sc_hd__decap_3
X_5055_ _5092_/CLK _5055_/D VGND VGND VPWR VPWR _5055_/Q sky130_fd_sc_hd__dfxtp_2
XFILLER_84_213 VGND VGND VPWR VPWR sky130_fd_sc_hd__decap_3
X_4006_ _4115_/A _2856_/B _4005_/X VGND VGND VPWR VPWR _4015_/C sky130_fd_sc_hd__o21ai_2
XFILLER_25_313 VGND VGND VPWR VPWR sky130_fd_sc_hd__decap_3
XFILLER_65_493 VGND VGND VPWR VPWR sky130_fd_sc_hd__fill_1
XFILLER_80_452 VGND VGND VPWR VPWR sky130_fd_sc_hd__decap_3
XFILLER_40_305 VGND VGND VPWR VPWR sky130_fd_sc_hd__decap_3
XFILLER_52_165 VGND VGND VPWR VPWR sky130_fd_sc_hd__decap_3
XFILLER_40_327 VGND VGND VPWR VPWR sky130_fd_sc_hd__decap_3
X_4908_ _5117_/CLK _4908_/D VGND VGND VPWR VPWR _4908_/Q sky130_fd_sc_hd__dfxtp_2
XFILLER_21_541 VGND VGND VPWR VPWR sky130_fd_sc_hd__decap_3
X_4839_ _5249_/Q _4847_/B VGND VGND VPWR VPWR _4839_/X sky130_fd_sc_hd__or2_2
XFILLER_88_541 VGND VGND VPWR VPWR sky130_fd_sc_hd__decap_3
XFILLER_0_489 VGND VGND VPWR VPWR sky130_fd_sc_hd__decap_3
XFILLER_48_416 VGND VGND VPWR VPWR sky130_fd_sc_hd__decap_3
XFILLER_48_449 VGND VGND VPWR VPWR sky130_fd_sc_hd__decap_3
XFILLER_29_97 VGND VGND VPWR VPWR sky130_fd_sc_hd__decap_3
XTAP_TAPCELL_ROW_74_904 VGND VPWR sky130_fd_sc_hd__tapvpwrvgnd_1
XPHY_EDGE_ROW_11_Left_105 VGND VGND VPWR VPWR sky130_fd_sc_hd__decap_3
XFILLER_90_205 VGND VGND VPWR VPWR sky130_fd_sc_hd__decap_3
XFILLER_16_302 VGND VGND VPWR VPWR sky130_fd_sc_hd__decap_3
XTAP_TAPCELL_ROW_46_639 VGND VPWR sky130_fd_sc_hd__tapvpwrvgnd_1
XFILLER_28_195 VGND VGND VPWR VPWR sky130_fd_sc_hd__fill_1
XFILLER_45_41 VGND VGND VPWR VPWR sky130_fd_sc_hd__decap_3
XFILLER_71_441 VGND VGND VPWR VPWR sky130_fd_sc_hd__decap_3
XFILLER_16_368 VGND VGND VPWR VPWR sky130_fd_sc_hd__fill_1
XFILLER_16_379 VGND VGND VPWR VPWR sky130_fd_sc_hd__fill_1
XFILLER_31_316 VGND VGND VPWR VPWR sky130_fd_sc_hd__decap_3
XTAP_TAPCELL_ROW_82_981 VGND VPWR sky130_fd_sc_hd__tapvpwrvgnd_1
XFILLER_12_541 VGND VGND VPWR VPWR sky130_fd_sc_hd__decap_3
XFILLER_8_545 VGND VGND VPWR VPWR sky130_fd_sc_hd__decap_3
XPHY_EDGE_ROW_20_Left_114 VGND VGND VPWR VPWR sky130_fd_sc_hd__decap_3
XFILLER_6_46 VGND VGND VPWR VPWR sky130_fd_sc_hd__decap_3
XFILLER_39_405 VGND VGND VPWR VPWR sky130_fd_sc_hd__decap_3
X_3170_ _2944_/X _3170_/A2 _3170_/B1 _5074_/Q VGND VGND VPWR VPWR _5074_/D sky130_fd_sc_hd__a22o_2
XFILLER_39_427 VGND VGND VPWR VPWR sky130_fd_sc_hd__decap_3
XFILLER_39_449 VGND VGND VPWR VPWR sky130_fd_sc_hd__decap_3
XFILLER_66_235 VGND VGND VPWR VPWR sky130_fd_sc_hd__decap_3
XFILLER_86_81 VGND VGND VPWR VPWR sky130_fd_sc_hd__decap_3
XFILLER_66_268 VGND VGND VPWR VPWR sky130_fd_sc_hd__decap_3
XTAP_TAPCELL_ROW_1_209 VGND VPWR sky130_fd_sc_hd__tapvpwrvgnd_1
XFILLER_19_195 VGND VGND VPWR VPWR sky130_fd_sc_hd__decap_3
XFILLER_34_121 VGND VGND VPWR VPWR sky130_fd_sc_hd__decap_3
XFILLER_62_441 VGND VGND VPWR VPWR sky130_fd_sc_hd__decap_3
XFILLER_81_249 VGND VGND VPWR VPWR sky130_fd_sc_hd__decap_3
XFILLER_62_485 VGND VGND VPWR VPWR sky130_fd_sc_hd__decap_3
XTAP_TAPCELL_ROW_17_363 VGND VPWR sky130_fd_sc_hd__tapvpwrvgnd_1
XFILLER_22_338 VGND VGND VPWR VPWR sky130_fd_sc_hd__decap_3
X_2954_ _2913_/X _2961_/A2 _2961_/B1 _4888_/Q VGND VGND VPWR VPWR _4888_/D sky130_fd_sc_hd__a22o_2
XFILLER_30_360 VGND VGND VPWR VPWR sky130_fd_sc_hd__decap_3
XFILLER_30_382 VGND VGND VPWR VPWR sky130_fd_sc_hd__decap_3
X_2885_ _2887_/B _2885_/B VGND VGND VPWR VPWR _2885_/Y sky130_fd_sc_hd__nor2_2
X_4624_ _4624_/A _4624_/B VGND VGND VPWR VPWR _4624_/Y sky130_fd_sc_hd__nand2_2
XPHY_EDGE_ROW_6_Right_6 VGND VGND VPWR VPWR sky130_fd_sc_hd__decap_3
X_4555_ _4588_/A _4554_/X _4588_/B VGND VGND VPWR VPWR _4556_/D sky130_fd_sc_hd__o21ba_2
X_3506_ _3501_/B _3503_/B _3499_/X VGND VGND VPWR VPWR _3511_/A sky130_fd_sc_hd__a21o_2
X_4486_ _3653_/X _3877_/A _4486_/C _4486_/D VGND VGND VPWR VPWR _4486_/X sky130_fd_sc_hd__and4bb_2
XFILLER_89_316 VGND VGND VPWR VPWR sky130_fd_sc_hd__decap_3
X_3437_ _5176_/Q _3429_/C _3228_/Y _3436_/X VGND VGND VPWR VPWR _5176_/D sky130_fd_sc_hd__o22a_2
XFILLER_89_349 VGND VGND VPWR VPWR sky130_fd_sc_hd__decap_3
X_3368_ _3369_/A _3369_/B VGND VGND VPWR VPWR _3368_/Y sky130_fd_sc_hd__nor2_2
XFILLER_57_213 VGND VGND VPWR VPWR sky130_fd_sc_hd__decap_3
XFILLER_57_235 VGND VGND VPWR VPWR sky130_fd_sc_hd__decap_3
XFILLER_66_29 VGND VGND VPWR VPWR sky130_fd_sc_hd__decap_3
X_5107_ _5112_/CLK _5107_/D VGND VGND VPWR VPWR _5107_/Q sky130_fd_sc_hd__dfxtp_2
XFILLER_45_408 VGND VGND VPWR VPWR sky130_fd_sc_hd__decap_3
X_3299_ _5185_/Q _3317_/C _3298_/Y _3265_/B _3296_/X VGND VGND VPWR VPWR _3300_/B
+ sky130_fd_sc_hd__o311a_2
XFILLER_38_460 VGND VGND VPWR VPWR sky130_fd_sc_hd__decap_3
XFILLER_72_205 VGND VGND VPWR VPWR sky130_fd_sc_hd__decap_3
X_5038_ _5100_/CLK _5038_/D VGND VGND VPWR VPWR _5038_/Q sky130_fd_sc_hd__dfxtp_2
XTAP_TAPCELL_ROW_84_1000 VGND VPWR sky130_fd_sc_hd__tapvpwrvgnd_1
XFILLER_65_290 VGND VGND VPWR VPWR sky130_fd_sc_hd__decap_3
XFILLER_72_238 VGND VGND VPWR VPWR sky130_fd_sc_hd__decap_3
XFILLER_13_305 VGND VGND VPWR VPWR sky130_fd_sc_hd__fill_1
XFILLER_25_143 VGND VGND VPWR VPWR sky130_fd_sc_hd__fill_1
XFILLER_25_165 VGND VGND VPWR VPWR sky130_fd_sc_hd__decap_3
XFILLER_53_452 VGND VGND VPWR VPWR sky130_fd_sc_hd__decap_3
XFILLER_53_485 VGND VGND VPWR VPWR sky130_fd_sc_hd__decap_3
XTAP_TAPCELL_ROW_43_609 VGND VPWR sky130_fd_sc_hd__tapvpwrvgnd_1
XFILLER_40_113 VGND VGND VPWR VPWR sky130_fd_sc_hd__fill_1
XTAP_TAPCELL_ROW_51_686 VGND VPWR sky130_fd_sc_hd__tapvpwrvgnd_1
XFILLER_21_393 VGND VGND VPWR VPWR sky130_fd_sc_hd__decap_3
XFILLER_31_76 VGND VGND VPWR VPWR sky130_fd_sc_hd__fill_1
Xoutput54 _5256_/Q VGND VGND VPWR VPWR EX_HALT sky130_fd_sc_hd__clkdlybuf4s25_1
Xoutput65 _5137_/Q VGND VGND VPWR VPWR INSTR_ADDR[4] sky130_fd_sc_hd__clkdlybuf4s25_1
Xoutput76 _2854_/X VGND VGND VPWR VPWR MEM_ADDR[0] sky130_fd_sc_hd__clkdlybuf4s25_1
XFILLER_0_231 VGND VGND VPWR VPWR sky130_fd_sc_hd__decap_3
XFILLER_0_253 VGND VGND VPWR VPWR sky130_fd_sc_hd__decap_3
Xoutput87 _2864_/Y VGND VGND VPWR VPWR MEM_ADDR[5] sky130_fd_sc_hd__clkdlybuf4s25_1
Xoutput98 _2851_/X VGND VGND VPWR VPWR MEM_STR_DATA[15] sky130_fd_sc_hd__clkdlybuf4s25_1
XFILLER_88_360 VGND VGND VPWR VPWR sky130_fd_sc_hd__decap_3
XTAP_TAPCELL_ROW_59_764 VGND VPWR sky130_fd_sc_hd__tapvpwrvgnd_1
XFILLER_91_503 VGND VGND VPWR VPWR sky130_fd_sc_hd__fill_1
XFILLER_29_471 VGND VGND VPWR VPWR sky130_fd_sc_hd__decap_3
XFILLER_36_419 VGND VGND VPWR VPWR sky130_fd_sc_hd__fill_1
XFILLER_48_279 VGND VGND VPWR VPWR sky130_fd_sc_hd__fill_1
XFILLER_56_62 VGND VGND VPWR VPWR sky130_fd_sc_hd__decap_3
XFILLER_44_430 VGND VGND VPWR VPWR sky130_fd_sc_hd__fill_1
XFILLER_91_547 VGND VGND VPWR VPWR sky130_fd_sc_hd__decap_3
XFILLER_72_50 VGND VGND VPWR VPWR sky130_fd_sc_hd__fill_2
XFILLER_72_83 VGND VGND VPWR VPWR sky130_fd_sc_hd__fill_1
XFILLER_72_94 VGND VGND VPWR VPWR sky130_fd_sc_hd__decap_3
XTAP_TAPCELL_ROW_14_333 VGND VPWR sky130_fd_sc_hd__tapvpwrvgnd_1
XPHY_EDGE_ROW_59_Right_59 VGND VGND VPWR VPWR sky130_fd_sc_hd__decap_3
X_2670_ _5117_/Q _5005_/Q _4989_/Q _4973_/Q _5123_/Q _2671_/S1 VGND VGND VPWR VPWR
+ _2670_/X sky130_fd_sc_hd__mux4_2
XFILLER_8_353 VGND VGND VPWR VPWR sky130_fd_sc_hd__decap_3
XFILLER_75_6 VGND VGND VPWR VPWR sky130_fd_sc_hd__decap_3
X_4340_ _4340_/A _4340_/B VGND VGND VPWR VPWR _4340_/Y sky130_fd_sc_hd__nand2_2
X_4271_ _3668_/B _4078_/X _4172_/X VGND VGND VPWR VPWR _4274_/C sky130_fd_sc_hd__o21ai_2
XFILLER_67_500 VGND VGND VPWR VPWR sky130_fd_sc_hd__decap_3
X_3222_ _2938_/X _3208_/B _3208_/Y _5120_/Q VGND VGND VPWR VPWR _5120_/D sky130_fd_sc_hd__a22o_2
XFILLER_67_511 VGND VGND VPWR VPWR sky130_fd_sc_hd__decap_3
X_3153_ _3207_/A _3153_/B VGND VGND VPWR VPWR _3154_/B sky130_fd_sc_hd__nor2_2
XPHY_EDGE_ROW_68_Right_68 VGND VGND VPWR VPWR sky130_fd_sc_hd__decap_3
XFILLER_79_371 VGND VGND VPWR VPWR sky130_fd_sc_hd__decap_3
XFILLER_67_544 VGND VGND VPWR VPWR sky130_fd_sc_hd__decap_3
XFILLER_54_227 VGND VGND VPWR VPWR sky130_fd_sc_hd__fill_1
X_3084_ _2906_/X _3093_/A2 _3096_/B1 _4998_/Q VGND VGND VPWR VPWR _4998_/D sky130_fd_sc_hd__a22o_2
XFILLER_82_536 VGND VGND VPWR VPWR sky130_fd_sc_hd__fill_2
XFILLER_82_525 VGND VGND VPWR VPWR sky130_fd_sc_hd__decap_3
XFILLER_35_452 VGND VGND VPWR VPWR sky130_fd_sc_hd__decap_3
XFILLER_22_102 VGND VGND VPWR VPWR sky130_fd_sc_hd__decap_3
XFILLER_50_411 VGND VGND VPWR VPWR sky130_fd_sc_hd__decap_3
XFILLER_50_433 VGND VGND VPWR VPWR sky130_fd_sc_hd__decap_3
XFILLER_62_282 VGND VGND VPWR VPWR sky130_fd_sc_hd__decap_3
XFILLER_22_135 VGND VGND VPWR VPWR sky130_fd_sc_hd__decap_3
X_3986_ _3999_/A _4003_/B VGND VGND VPWR VPWR _4001_/B sky130_fd_sc_hd__nor2_2
XPHY_EDGE_ROW_77_Right_77 VGND VGND VPWR VPWR sky130_fd_sc_hd__decap_3
XFILLER_50_477 VGND VGND VPWR VPWR sky130_fd_sc_hd__decap_3
X_2937_ _5235_/Q _4850_/A _3458_/B _5219_/Q VGND VGND VPWR VPWR _2937_/X sky130_fd_sc_hd__a22o_2
X_4607_ _4607_/A _4607_/B VGND VGND VPWR VPWR _4607_/Y sky130_fd_sc_hd__nand2_2
X_2868_ _3873_/B _2868_/B VGND VGND VPWR VPWR _2869_/B sky130_fd_sc_hd__xnor2_2
X_2799_ _5069_/Q _5053_/Q _5037_/Q _5021_/Q _2812_/S0 _2848_/S1 VGND VGND VPWR VPWR
+ _2799_/X sky130_fd_sc_hd__mux4_2
X_4538_ _4493_/B _4787_/S _3964_/Y VGND VGND VPWR VPWR _4541_/A sky130_fd_sc_hd__a21o_2
XFILLER_89_113 VGND VGND VPWR VPWR sky130_fd_sc_hd__decap_3
X_4469_ _4469_/A _4469_/B VGND VGND VPWR VPWR _4470_/B sky130_fd_sc_hd__and2_2
XFILLER_7_9 VGND VGND VPWR VPWR sky130_fd_sc_hd__decap_3
XPHY_EDGE_ROW_86_Right_86 VGND VGND VPWR VPWR sky130_fd_sc_hd__decap_3
XFILLER_77_39 VGND VGND VPWR VPWR sky130_fd_sc_hd__decap_3
XFILLER_77_308 VGND VGND VPWR VPWR sky130_fd_sc_hd__decap_3
XFILLER_58_533 VGND VGND VPWR VPWR sky130_fd_sc_hd__decap_3
XFILLER_18_419 VGND VGND VPWR VPWR sky130_fd_sc_hd__fill_1
XFILLER_45_216 VGND VGND VPWR VPWR sky130_fd_sc_hd__fill_1
XFILLER_73_514 VGND VGND VPWR VPWR sky130_fd_sc_hd__decap_3
XFILLER_93_38 VGND VGND VPWR VPWR sky130_fd_sc_hd__decap_3
XFILLER_93_27 VGND VGND VPWR VPWR sky130_fd_sc_hd__fill_1
XFILLER_85_396 VGND VGND VPWR VPWR sky130_fd_sc_hd__fill_1
XFILLER_73_547 VGND VGND VPWR VPWR sky130_fd_sc_hd__decap_3
XTAP_TAPCELL_ROW_56_734 VGND VPWR sky130_fd_sc_hd__tapvpwrvgnd_1
XTAP_TAPCELL_ROW_28_469 VGND VPWR sky130_fd_sc_hd__tapvpwrvgnd_1
XFILLER_13_113 VGND VGND VPWR VPWR sky130_fd_sc_hd__decap_3
XFILLER_41_411 VGND VGND VPWR VPWR sky130_fd_sc_hd__decap_3
XFILLER_53_271 VGND VGND VPWR VPWR sky130_fd_sc_hd__fill_1
XFILLER_41_444 VGND VGND VPWR VPWR sky130_fd_sc_hd__decap_3
XFILLER_9_106 VGND VGND VPWR VPWR sky130_fd_sc_hd__decap_3
XTAP_TAPCELL_ROW_11_303 VGND VPWR sky130_fd_sc_hd__tapvpwrvgnd_1
XFILLER_9_139 VGND VGND VPWR VPWR sky130_fd_sc_hd__decap_3
XFILLER_9_128 VGND VGND VPWR VPWR sky130_fd_sc_hd__decap_3
XFILLER_21_190 VGND VGND VPWR VPWR sky130_fd_sc_hd__decap_3
XFILLER_42_97 VGND VGND VPWR VPWR sky130_fd_sc_hd__decap_3
XFILLER_5_334 VGND VGND VPWR VPWR sky130_fd_sc_hd__fill_2
XFILLER_5_389 VGND VGND VPWR VPWR sky130_fd_sc_hd__decap_3
XFILLER_76_352 VGND VGND VPWR VPWR sky130_fd_sc_hd__decap_3
XFILLER_67_94 VGND VGND VPWR VPWR sky130_fd_sc_hd__fill_1
XFILLER_76_374 VGND VGND VPWR VPWR sky130_fd_sc_hd__decap_3
XFILLER_36_249 VGND VGND VPWR VPWR sky130_fd_sc_hd__decap_3
XFILLER_64_536 VGND VGND VPWR VPWR sky130_fd_sc_hd__decap_3
XFILLER_17_452 VGND VGND VPWR VPWR sky130_fd_sc_hd__decap_3
XFILLER_83_82 VGND VGND VPWR VPWR sky130_fd_sc_hd__decap_3
XFILLER_32_455 VGND VGND VPWR VPWR sky130_fd_sc_hd__decap_3
X_3840_ _4445_/B _4405_/B VGND VGND VPWR VPWR _3843_/A sky130_fd_sc_hd__and2_2
XFILLER_32_499 VGND VGND VPWR VPWR sky130_fd_sc_hd__decap_3
X_3771_ _5074_/Q _5058_/Q _5042_/Q _5026_/Q _5127_/Q _5128_/Q VGND VGND VPWR VPWR
+ _3771_/X sky130_fd_sc_hd__mux4_2
X_2722_ _5108_/Q _4996_/Q _4980_/Q _4964_/Q _5131_/Q _2848_/S1 VGND VGND VPWR VPWR
+ _2722_/X sky130_fd_sc_hd__mux4_2
XFILLER_73_3 VGND VGND VPWR VPWR sky130_fd_sc_hd__decap_3
X_2653_ _5070_/Q _5054_/Q _5038_/Q _5022_/Q _2658_/S0 _2671_/S1 VGND VGND VPWR VPWR
+ _2653_/X sky130_fd_sc_hd__mux4_2
X_2584_ _5154_/Q _4449_/A VGND VGND VPWR VPWR _2585_/B sky130_fd_sc_hd__nor2_2
X_4323_ _4800_/B _4323_/B _4323_/C _4320_/X VGND VGND VPWR VPWR _4324_/A sky130_fd_sc_hd__or4b_2
X_4254_ _3668_/B _4033_/X _4172_/X VGND VGND VPWR VPWR _4258_/C sky130_fd_sc_hd__o21ai_2
XFILLER_86_138 VGND VGND VPWR VPWR sky130_fd_sc_hd__fill_2
X_4185_ _3873_/B _3937_/X _4184_/Y VGND VGND VPWR VPWR _4189_/C sky130_fd_sc_hd__o21ai_2
X_3205_ _2941_/X _3190_/B _3190_/Y _5105_/Q VGND VGND VPWR VPWR _5105_/D sky130_fd_sc_hd__a22o_2
X_3136_ _4866_/A _3136_/B VGND VGND VPWR VPWR _3136_/Y sky130_fd_sc_hd__nor2_2
XFILLER_67_396 VGND VGND VPWR VPWR sky130_fd_sc_hd__decap_3
X_3067_ _2913_/X _3074_/A2 _3061_/Y _4984_/Q VGND VGND VPWR VPWR _4984_/D sky130_fd_sc_hd__a22o_2
XFILLER_82_333 VGND VGND VPWR VPWR sky130_fd_sc_hd__decap_3
XFILLER_70_517 VGND VGND VPWR VPWR sky130_fd_sc_hd__fill_1
XTAP_TAPCELL_ROW_53_704 VGND VPWR sky130_fd_sc_hd__tapvpwrvgnd_1
XTAP_TAPCELL_ROW_25_439 VGND VPWR sky130_fd_sc_hd__tapvpwrvgnd_1
XFILLER_82_388 VGND VGND VPWR VPWR sky130_fd_sc_hd__decap_3
XFILLER_23_433 VGND VGND VPWR VPWR sky130_fd_sc_hd__decap_3
XFILLER_23_455 VGND VGND VPWR VPWR sky130_fd_sc_hd__decap_3
XFILLER_35_293 VGND VGND VPWR VPWR sky130_fd_sc_hd__decap_3
XFILLER_50_230 VGND VGND VPWR VPWR sky130_fd_sc_hd__decap_3
XFILLER_50_285 VGND VGND VPWR VPWR sky130_fd_sc_hd__decap_3
XTAP_TAPCELL_ROW_61_781 VGND VPWR sky130_fd_sc_hd__tapvpwrvgnd_1
X_3969_ _4063_/A _3968_/X _3967_/Y _4346_/A VGND VGND VPWR VPWR _3969_/X sky130_fd_sc_hd__a211o_2
XFILLER_12_45 VGND VGND VPWR VPWR sky130_fd_sc_hd__decap_3
XFILLER_2_304 VGND VGND VPWR VPWR sky130_fd_sc_hd__decap_3
XFILLER_5_6 VGND VGND VPWR VPWR sky130_fd_sc_hd__fill_1
XFILLER_88_49 VGND VGND VPWR VPWR sky130_fd_sc_hd__decap_3
XFILLER_88_38 VGND VGND VPWR VPWR sky130_fd_sc_hd__decap_3
XFILLER_77_116 VGND VGND VPWR VPWR sky130_fd_sc_hd__decap_3
XFILLER_58_341 VGND VGND VPWR VPWR sky130_fd_sc_hd__decap_3
XFILLER_77_149 VGND VGND VPWR VPWR sky130_fd_sc_hd__fill_2
XFILLER_18_205 VGND VGND VPWR VPWR sky130_fd_sc_hd__decap_3
XFILLER_58_374 VGND VGND VPWR VPWR sky130_fd_sc_hd__decap_3
XFILLER_73_311 VGND VGND VPWR VPWR sky130_fd_sc_hd__decap_3
XFILLER_18_238 VGND VGND VPWR VPWR sky130_fd_sc_hd__decap_3
XFILLER_73_333 VGND VGND VPWR VPWR sky130_fd_sc_hd__decap_3
XFILLER_61_517 VGND VGND VPWR VPWR sky130_fd_sc_hd__decap_3
XFILLER_14_433 VGND VGND VPWR VPWR sky130_fd_sc_hd__fill_1
XFILLER_53_52 VGND VGND VPWR VPWR sky130_fd_sc_hd__decap_3
XFILLER_5_164 VGND VGND VPWR VPWR sky130_fd_sc_hd__decap_3
XFILLER_5_197 VGND VGND VPWR VPWR sky130_fd_sc_hd__decap_3
XFILLER_37_503 VGND VGND VPWR VPWR sky130_fd_sc_hd__fill_1
XFILLER_37_514 VGND VGND VPWR VPWR sky130_fd_sc_hd__decap_3
XFILLER_49_352 VGND VGND VPWR VPWR sky130_fd_sc_hd__decap_3
XFILLER_83_119 VGND VGND VPWR VPWR sky130_fd_sc_hd__decap_3
XFILLER_49_385 VGND VGND VPWR VPWR sky130_fd_sc_hd__decap_3
XFILLER_49_396 VGND VGND VPWR VPWR sky130_fd_sc_hd__decap_3
XFILLER_64_333 VGND VGND VPWR VPWR sky130_fd_sc_hd__decap_3
XFILLER_64_377 VGND VGND VPWR VPWR sky130_fd_sc_hd__decap_3
XFILLER_17_260 VGND VGND VPWR VPWR sky130_fd_sc_hd__decap_3
X_4941_ _5007_/CLK _4941_/D VGND VGND VPWR VPWR _4941_/Q sky130_fd_sc_hd__dfxtp_2
XFILLER_60_550 VGND VGND VPWR VPWR sky130_fd_sc_hd__decap_3
X_4872_ _5109_/CLK _4872_/D VGND VGND VPWR VPWR _4872_/Q sky130_fd_sc_hd__dfxtp_2
X_3823_ _4445_/A _4397_/A VGND VGND VPWR VPWR _4608_/B sky130_fd_sc_hd__and2_2
XTAP_TAPCELL_ROW_22_409 VGND VPWR sky130_fd_sc_hd__tapvpwrvgnd_1
X_3754_ _4471_/B _3911_/C VGND VGND VPWR VPWR _3756_/B sky130_fd_sc_hd__and2_2
X_3685_ _5067_/Q _5051_/Q _5035_/Q _5019_/Q _5127_/Q _5128_/Q VGND VGND VPWR VPWR
+ _3685_/X sky130_fd_sc_hd__mux4_2
X_2705_ _2465_/B _5263_/Q VGND VGND VPWR VPWR _2705_/X sky130_fd_sc_hd__and2b_2
XTAP_TAPCELL_ROW_30_486 VGND VPWR sky130_fd_sc_hd__tapvpwrvgnd_1
XFILLER_9_481 VGND VGND VPWR VPWR sky130_fd_sc_hd__decap_3
X_2636_ _5161_/Q _4468_/A VGND VGND VPWR VPWR _2638_/B sky130_fd_sc_hd__nor2_2
XFILLER_58_19 VGND VGND VPWR VPWR sky130_fd_sc_hd__decap_3
X_2567_ _2667_/A _2566_/X _5126_/Q VGND VGND VPWR VPWR _2567_/X sky130_fd_sc_hd__o21a_2
XFILLER_59_105 VGND VGND VPWR VPWR sky130_fd_sc_hd__decap_3
X_4306_ _4700_/S _4306_/B VGND VGND VPWR VPWR _4306_/Y sky130_fd_sc_hd__nand2_2
X_2498_ _2496_/X _2497_/X _5125_/Q VGND VGND VPWR VPWR _2498_/X sky130_fd_sc_hd__mux2_1
XFILLER_87_414 VGND VGND VPWR VPWR sky130_fd_sc_hd__decap_3
XFILLER_59_138 VGND VGND VPWR VPWR sky130_fd_sc_hd__decap_3
XFILLER_59_149 VGND VGND VPWR VPWR sky130_fd_sc_hd__decap_3
X_4237_ _5215_/Q _4700_/S _4219_/Y _4236_/Y _3442_/B VGND VGND VPWR VPWR _5215_/D
+ sky130_fd_sc_hd__o221a_2
XFILLER_87_447 VGND VGND VPWR VPWR sky130_fd_sc_hd__fill_1
XFILLER_28_514 VGND VGND VPWR VPWR sky130_fd_sc_hd__decap_3
XFILLER_28_547 VGND VGND VPWR VPWR sky130_fd_sc_hd__decap_3
X_4168_ _4168_/A _4168_/B VGND VGND VPWR VPWR _4168_/Y sky130_fd_sc_hd__nand2_2
XFILLER_43_517 VGND VGND VPWR VPWR sky130_fd_sc_hd__decap_3
X_4099_ _3864_/B _4098_/X _4339_/A VGND VGND VPWR VPWR _4100_/B sky130_fd_sc_hd__mux2_1
X_3119_ _2900_/X _3117_/B _3133_/B1 _5028_/Q VGND VGND VPWR VPWR _5028_/D sky130_fd_sc_hd__a22o_2
XTAP_TAPCELL_ROW_38_564 VGND VPWR sky130_fd_sc_hd__tapvpwrvgnd_1
XFILLER_82_141 VGND VGND VPWR VPWR sky130_fd_sc_hd__decap_3
XFILLER_82_130 VGND VGND VPWR VPWR sky130_fd_sc_hd__decap_3
XFILLER_55_399 VGND VGND VPWR VPWR sky130_fd_sc_hd__decap_3
XFILLER_70_336 VGND VGND VPWR VPWR sky130_fd_sc_hd__decap_3
XFILLER_82_163 VGND VGND VPWR VPWR sky130_fd_sc_hd__decap_3
XFILLER_23_274 VGND VGND VPWR VPWR sky130_fd_sc_hd__decap_3
XFILLER_23_77 VGND VGND VPWR VPWR sky130_fd_sc_hd__decap_3
XFILLER_3_3 VGND VGND VPWR VPWR sky130_fd_sc_hd__decap_3
XFILLER_48_41 VGND VGND VPWR VPWR sky130_fd_sc_hd__decap_3
XFILLER_78_447 VGND VGND VPWR VPWR sky130_fd_sc_hd__decap_3
XFILLER_19_503 VGND VGND VPWR VPWR sky130_fd_sc_hd__fill_1
XFILLER_46_300 VGND VGND VPWR VPWR sky130_fd_sc_hd__decap_3
XFILLER_48_85 VGND VGND VPWR VPWR sky130_fd_sc_hd__decap_3
XFILLER_65_119 VGND VGND VPWR VPWR sky130_fd_sc_hd__fill_2
XFILLER_0_26 VGND VGND VPWR VPWR sky130_fd_sc_hd__fill_2
XFILLER_93_439 VGND VGND VPWR VPWR sky130_fd_sc_hd__decap_3
XFILLER_34_517 VGND VGND VPWR VPWR sky130_fd_sc_hd__decap_3
XFILLER_64_62 VGND VGND VPWR VPWR sky130_fd_sc_hd__decap_3
XFILLER_73_163 VGND VGND VPWR VPWR sky130_fd_sc_hd__decap_3
XPHY_EDGE_ROW_85_Left_179 VGND VGND VPWR VPWR sky130_fd_sc_hd__decap_3
XTAP_TAPCELL_ROW_72_887 VGND VPWR sky130_fd_sc_hd__tapvpwrvgnd_1
XFILLER_9_68 VGND VGND VPWR VPWR sky130_fd_sc_hd__decap_3
X_3470_ _5188_/Q _4168_/A _3469_/X _3448_/B VGND VGND VPWR VPWR _5188_/D sky130_fd_sc_hd__o211a_2
X_2421_ _5201_/Q VGND VGND VPWR VPWR _2421_/Y sky130_fd_sc_hd__inv_2
X_5140_ _5164_/CLK _5140_/D VGND VGND VPWR VPWR _5140_/Q sky130_fd_sc_hd__dfxtp_2
XFILLER_69_447 VGND VGND VPWR VPWR sky130_fd_sc_hd__fill_1
X_5071_ _5098_/CLK _5071_/D VGND VGND VPWR VPWR _5071_/Q sky130_fd_sc_hd__dfxtp_2
X_4022_ _4361_/A _4022_/B VGND VGND VPWR VPWR _4022_/Y sky130_fd_sc_hd__nor2_2
XFILLER_37_322 VGND VGND VPWR VPWR sky130_fd_sc_hd__decap_3
XFILLER_37_355 VGND VGND VPWR VPWR sky130_fd_sc_hd__decap_3
XFILLER_37_366 VGND VGND VPWR VPWR sky130_fd_sc_hd__fill_1
XFILLER_52_303 VGND VGND VPWR VPWR sky130_fd_sc_hd__decap_3
XFILLER_92_483 VGND VGND VPWR VPWR sky130_fd_sc_hd__decap_3
XFILLER_92_472 VGND VGND VPWR VPWR sky130_fd_sc_hd__decap_3
XFILLER_52_336 VGND VGND VPWR VPWR sky130_fd_sc_hd__decap_3
X_4924_ _5117_/CLK _4924_/D VGND VGND VPWR VPWR _4924_/Q sky130_fd_sc_hd__dfxtp_2
XTAP_TAPCELL_ROW_35_534 VGND VPWR sky130_fd_sc_hd__tapvpwrvgnd_1
X_4855_ _5164_/Q _3450_/C _3228_/Y _3237_/X VGND VGND VPWR VPWR _5164_/D sky130_fd_sc_hd__o22a_2
X_4786_ _4786_/A _4786_/B VGND VGND VPWR VPWR _4786_/X sky130_fd_sc_hd__or2_2
X_3806_ _4191_/A VGND VGND VPWR VPWR _3806_/Y sky130_fd_sc_hd__inv_2
X_3737_ _5120_/Q _5008_/Q _4992_/Q _4976_/Q _5127_/Q _5128_/Q VGND VGND VPWR VPWR
+ _3737_/X sky130_fd_sc_hd__mux4_2
X_3668_ _4171_/A _3668_/B VGND VGND VPWR VPWR _4132_/A sky130_fd_sc_hd__and2b_2
X_3599_ _4806_/A _3643_/B VGND VGND VPWR VPWR _4107_/A sky130_fd_sc_hd__nand2_2
X_2619_ _3874_/A _2861_/B _3934_/C _2616_/X VGND VGND VPWR VPWR _2865_/A sky130_fd_sc_hd__a31o_2
XFILLER_87_222 VGND VGND VPWR VPWR sky130_fd_sc_hd__fill_2
XFILLER_47_108 VGND VGND VPWR VPWR sky130_fd_sc_hd__decap_3
XFILLER_75_428 VGND VGND VPWR VPWR sky130_fd_sc_hd__fill_1
XFILLER_68_491 VGND VGND VPWR VPWR sky130_fd_sc_hd__decap_3
XFILLER_87_299 VGND VGND VPWR VPWR sky130_fd_sc_hd__fill_1
XFILLER_18_66 VGND VGND VPWR VPWR sky130_fd_sc_hd__fill_1
XFILLER_55_130 VGND VGND VPWR VPWR sky130_fd_sc_hd__decap_3
XTAP_TAPCELL_ROW_87_1031 VGND VPWR sky130_fd_sc_hd__tapvpwrvgnd_1
XFILLER_16_539 VGND VGND VPWR VPWR sky130_fd_sc_hd__decap_3
XFILLER_18_88 VGND VGND VPWR VPWR sky130_fd_sc_hd__decap_3
XFILLER_55_185 VGND VGND VPWR VPWR sky130_fd_sc_hd__decap_3
XFILLER_83_483 VGND VGND VPWR VPWR sky130_fd_sc_hd__decap_3
XFILLER_24_550 VGND VGND VPWR VPWR sky130_fd_sc_hd__decap_3
XFILLER_43_369 VGND VGND VPWR VPWR sky130_fd_sc_hd__decap_3
XFILLER_70_155 VGND VGND VPWR VPWR sky130_fd_sc_hd__decap_3
XFILLER_11_211 VGND VGND VPWR VPWR sky130_fd_sc_hd__decap_3
XFILLER_11_233 VGND VGND VPWR VPWR sky130_fd_sc_hd__fill_2
XFILLER_11_255 VGND VGND VPWR VPWR sky130_fd_sc_hd__decap_3
XFILLER_50_53 VGND VGND VPWR VPWR sky130_fd_sc_hd__decap_3
XFILLER_3_421 VGND VGND VPWR VPWR sky130_fd_sc_hd__decap_3
XFILLER_3_443 VGND VGND VPWR VPWR sky130_fd_sc_hd__decap_3
XFILLER_78_200 VGND VGND VPWR VPWR sky130_fd_sc_hd__decap_3
XFILLER_22_9 VGND VGND VPWR VPWR sky130_fd_sc_hd__fill_1
XFILLER_93_203 VGND VGND VPWR VPWR sky130_fd_sc_hd__decap_3
XFILLER_59_480 VGND VGND VPWR VPWR sky130_fd_sc_hd__decap_3
XFILLER_66_439 VGND VGND VPWR VPWR sky130_fd_sc_hd__decap_3
XTAP_TAPCELL_ROW_77_935 VGND VPWR sky130_fd_sc_hd__tapvpwrvgnd_1
XFILLER_93_225 VGND VGND VPWR VPWR sky130_fd_sc_hd__fill_2
XFILLER_19_333 VGND VGND VPWR VPWR sky130_fd_sc_hd__decap_3
XFILLER_46_141 VGND VGND VPWR VPWR sky130_fd_sc_hd__decap_3
XFILLER_75_72 VGND VGND VPWR VPWR sky130_fd_sc_hd__decap_3
XFILLER_19_399 VGND VGND VPWR VPWR sky130_fd_sc_hd__decap_3
XFILLER_15_550 VGND VGND VPWR VPWR sky130_fd_sc_hd__decap_3
XFILLER_61_177 VGND VGND VPWR VPWR sky130_fd_sc_hd__decap_3
X_2970_ _2900_/X _2968_/B _2968_/Y _4900_/Q VGND VGND VPWR VPWR _4900_/D sky130_fd_sc_hd__a22o_2
XTAP_TAPCELL_ROW_32_504 VGND VPWR sky130_fd_sc_hd__tapvpwrvgnd_1
XFILLER_42_380 VGND VGND VPWR VPWR sky130_fd_sc_hd__decap_3
X_4640_ _3999_/B _4614_/X _4635_/Y _4639_/X _4109_/X VGND VGND VPWR VPWR _4640_/X
+ sky130_fd_sc_hd__o221a_2
X_4571_ _4572_/B _4572_/A VGND VGND VPWR VPWR _4571_/Y sky130_fd_sc_hd__nand2b_2
XTAP_TAPCELL_ROW_40_581 VGND VPWR sky130_fd_sc_hd__tapvpwrvgnd_1
X_3522_ _5159_/Q _5140_/Q VGND VGND VPWR VPWR _3522_/X sky130_fd_sc_hd__and2_2
X_3453_ _2889_/A _2889_/C _3456_/B _5255_/Q VGND VGND VPWR VPWR _3453_/X sky130_fd_sc_hd__a211o_2
XFILLER_69_200 VGND VGND VPWR VPWR sky130_fd_sc_hd__decap_3
XFILLER_69_222 VGND VGND VPWR VPWR sky130_fd_sc_hd__fill_2
X_5123_ clkload3/A _5123_/D VGND VGND VPWR VPWR _5123_/Q sky130_fd_sc_hd__dfxtp_4
X_3384_ _5146_/Q _3337_/A _3383_/X _3442_/B VGND VGND VPWR VPWR _5146_/D sky130_fd_sc_hd__o211a_2
XFILLER_57_417 VGND VGND VPWR VPWR sky130_fd_sc_hd__decap_3
XFILLER_69_277 VGND VGND VPWR VPWR sky130_fd_sc_hd__decap_3
XFILLER_84_203 VGND VGND VPWR VPWR sky130_fd_sc_hd__decap_3
XFILLER_29_119 VGND VGND VPWR VPWR sky130_fd_sc_hd__decap_3
X_5054_ _5100_/CLK _5054_/D VGND VGND VPWR VPWR _5054_/Q sky130_fd_sc_hd__dfxtp_2
XFILLER_84_225 VGND VGND VPWR VPWR sky130_fd_sc_hd__decap_3
XFILLER_37_130 VGND VGND VPWR VPWR sky130_fd_sc_hd__decap_3
X_4005_ _3992_/A _4380_/B _4136_/B _2607_/Y _4004_/X VGND VGND VPWR VPWR _4005_/X
+ sky130_fd_sc_hd__o221a_2
XFILLER_84_247 VGND VGND VPWR VPWR sky130_fd_sc_hd__decap_3
XFILLER_52_100 VGND VGND VPWR VPWR sky130_fd_sc_hd__decap_3
XFILLER_65_461 VGND VGND VPWR VPWR sky130_fd_sc_hd__fill_2
XFILLER_65_472 VGND VGND VPWR VPWR sky130_fd_sc_hd__decap_3
XFILLER_37_196 VGND VGND VPWR VPWR sky130_fd_sc_hd__decap_3
XFILLER_52_133 VGND VGND VPWR VPWR sky130_fd_sc_hd__decap_3
XFILLER_92_280 VGND VGND VPWR VPWR sky130_fd_sc_hd__decap_3
XFILLER_52_144 VGND VGND VPWR VPWR sky130_fd_sc_hd__decap_3
XFILLER_80_486 VGND VGND VPWR VPWR sky130_fd_sc_hd__decap_3
XFILLER_80_464 VGND VGND VPWR VPWR sky130_fd_sc_hd__decap_3
XFILLER_33_391 VGND VGND VPWR VPWR sky130_fd_sc_hd__fill_1
XFILLER_40_339 VGND VGND VPWR VPWR sky130_fd_sc_hd__fill_2
X_4907_ _5122_/CLK _4907_/D VGND VGND VPWR VPWR _4907_/Q sky130_fd_sc_hd__dfxtp_2
X_4838_ input34/X _4816_/Y _4837_/X _3442_/B VGND VGND VPWR VPWR _5248_/D sky130_fd_sc_hd__o211a_2
Xclkbuf_leaf_38_CLK clkbuf_leaf_8_CLK/A VGND VGND VPWR VPWR clkload9/A sky130_fd_sc_hd__clkbuf_8
X_4769_ _4419_/A _4643_/Y _4768_/X _4298_/X VGND VGND VPWR VPWR _4769_/X sky130_fd_sc_hd__o211a_2
XFILLER_20_12 VGND VGND VPWR VPWR sky130_fd_sc_hd__fill_1
XFILLER_20_67 VGND VGND VPWR VPWR sky130_fd_sc_hd__fill_1
XFILLER_0_424 VGND VGND VPWR VPWR sky130_fd_sc_hd__decap_3
XFILLER_0_446 VGND VGND VPWR VPWR sky130_fd_sc_hd__fill_2
XTAP_TAPCELL_ROW_93_1090 VGND VPWR sky130_fd_sc_hd__tapvpwrvgnd_1
XFILLER_88_531 VGND VGND VPWR VPWR sky130_fd_sc_hd__fill_1
XFILLER_29_76 VGND VGND VPWR VPWR sky130_fd_sc_hd__decap_3
XFILLER_63_409 VGND VGND VPWR VPWR sky130_fd_sc_hd__decap_3
XFILLER_75_269 VGND VGND VPWR VPWR sky130_fd_sc_hd__fill_2
XTAP_TAPCELL_ROW_74_905 VGND VPWR sky130_fd_sc_hd__tapvpwrvgnd_1
XFILLER_28_152 VGND VGND VPWR VPWR sky130_fd_sc_hd__decap_3
XFILLER_56_483 VGND VGND VPWR VPWR sky130_fd_sc_hd__decap_3
XFILLER_43_111 VGND VGND VPWR VPWR sky130_fd_sc_hd__fill_1
XFILLER_71_420 VGND VGND VPWR VPWR sky130_fd_sc_hd__decap_3
XTAP_TAPCELL_ROW_82_982 VGND VPWR sky130_fd_sc_hd__tapvpwrvgnd_1
XFILLER_61_41 VGND VGND VPWR VPWR sky130_fd_sc_hd__decap_3
XFILLER_61_52 VGND VGND VPWR VPWR sky130_fd_sc_hd__decap_3
XFILLER_8_513 VGND VGND VPWR VPWR sky130_fd_sc_hd__decap_3
XFILLER_61_63 VGND VGND VPWR VPWR sky130_fd_sc_hd__decap_3
Xclkbuf_leaf_29_CLK clkload1/A VGND VGND VPWR VPWR _5117_/CLK sky130_fd_sc_hd__clkbuf_8
XFILLER_6_69 VGND VGND VPWR VPWR sky130_fd_sc_hd__decap_3
XFILLER_3_284 VGND VGND VPWR VPWR sky130_fd_sc_hd__decap_3
XFILLER_79_520 VGND VGND VPWR VPWR sky130_fd_sc_hd__decap_3
XFILLER_20_6 VGND VGND VPWR VPWR sky130_fd_sc_hd__decap_3
XFILLER_39_439 VGND VGND VPWR VPWR sky130_fd_sc_hd__decap_3
XFILLER_66_214 VGND VGND VPWR VPWR sky130_fd_sc_hd__decap_3
XFILLER_54_409 VGND VGND VPWR VPWR sky130_fd_sc_hd__decap_3
XFILLER_86_93 VGND VGND VPWR VPWR sky130_fd_sc_hd__fill_1
XFILLER_34_100 VGND VGND VPWR VPWR sky130_fd_sc_hd__decap_3
XFILLER_81_228 VGND VGND VPWR VPWR sky130_fd_sc_hd__decap_3
XFILLER_81_206 VGND VGND VPWR VPWR sky130_fd_sc_hd__decap_3
XFILLER_34_133 VGND VGND VPWR VPWR sky130_fd_sc_hd__decap_3
XFILLER_74_280 VGND VGND VPWR VPWR sky130_fd_sc_hd__decap_3
XFILLER_34_144 VGND VGND VPWR VPWR sky130_fd_sc_hd__decap_3
XFILLER_62_453 VGND VGND VPWR VPWR sky130_fd_sc_hd__decap_3
XFILLER_22_317 VGND VGND VPWR VPWR sky130_fd_sc_hd__decap_3
XFILLER_62_497 VGND VGND VPWR VPWR sky130_fd_sc_hd__decap_3
X_2953_ _2910_/X _2961_/A2 _2961_/B1 _4887_/Q VGND VGND VPWR VPWR _4887_/D sky130_fd_sc_hd__a22o_2
XTAP_TAPCELL_ROW_17_364 VGND VPWR sky130_fd_sc_hd__tapvpwrvgnd_1
XFILLER_15_391 VGND VGND VPWR VPWR sky130_fd_sc_hd__fill_1
X_2884_ _2884_/A _3680_/B VGND VGND VPWR VPWR _2885_/B sky130_fd_sc_hd__xnor2_2
XFILLER_30_394 VGND VGND VPWR VPWR sky130_fd_sc_hd__decap_3
X_4623_ _4624_/A _4520_/X _4686_/S VGND VGND VPWR VPWR _4623_/X sky130_fd_sc_hd__a21o_2
X_4554_ _4468_/A _4477_/A _4553_/X _3917_/B _4479_/B VGND VGND VPWR VPWR _4554_/X
+ sky130_fd_sc_hd__o311a_2
X_3505_ _4866_/A _3505_/B VGND VGND VPWR VPWR _5194_/D sky130_fd_sc_hd__nor2_2
X_4485_ _4547_/A _2853_/B _3875_/B _4224_/A _4484_/X VGND VGND VPWR VPWR _4486_/D
+ sky130_fd_sc_hd__o221a_2
XFILLER_89_328 VGND VGND VPWR VPWR sky130_fd_sc_hd__decap_3
X_3436_ _5260_/Q _3442_/B _3436_/C VGND VGND VPWR VPWR _3436_/X sky130_fd_sc_hd__and3_2
X_3367_ _3378_/A _3367_/B VGND VGND VPWR VPWR _3369_/B sky130_fd_sc_hd__nor2_2
X_5106_ _5106_/CLK _5106_/D VGND VGND VPWR VPWR _5106_/Q sky130_fd_sc_hd__dfxtp_2
XFILLER_85_523 VGND VGND VPWR VPWR sky130_fd_sc_hd__fill_1
XFILLER_57_247 VGND VGND VPWR VPWR sky130_fd_sc_hd__decap_3
XFILLER_57_269 VGND VGND VPWR VPWR sky130_fd_sc_hd__decap_3
X_5037_ _5210_/CLK _5037_/D VGND VGND VPWR VPWR _5037_/Q sky130_fd_sc_hd__dfxtp_2
X_3298_ _5138_/Q _3298_/B VGND VGND VPWR VPWR _3298_/Y sky130_fd_sc_hd__nor2_2
XFILLER_38_472 VGND VGND VPWR VPWR sky130_fd_sc_hd__decap_3
XFILLER_53_420 VGND VGND VPWR VPWR sky130_fd_sc_hd__decap_3
XFILLER_53_442 VGND VGND VPWR VPWR sky130_fd_sc_hd__decap_3
XTAP_TAPCELL_ROW_84_1001 VGND VPWR sky130_fd_sc_hd__tapvpwrvgnd_1
XFILLER_82_29 VGND VGND VPWR VPWR sky130_fd_sc_hd__decap_3
XFILLER_15_12 VGND VGND VPWR VPWR sky130_fd_sc_hd__decap_3
XFILLER_15_23 VGND VGND VPWR VPWR sky130_fd_sc_hd__decap_3
XFILLER_53_464 VGND VGND VPWR VPWR sky130_fd_sc_hd__fill_2
XFILLER_80_261 VGND VGND VPWR VPWR sky130_fd_sc_hd__decap_3
XFILLER_80_250 VGND VGND VPWR VPWR sky130_fd_sc_hd__fill_2
XFILLER_80_283 VGND VGND VPWR VPWR sky130_fd_sc_hd__decap_3
XFILLER_80_272 VGND VGND VPWR VPWR sky130_fd_sc_hd__decap_3
XFILLER_15_67 VGND VGND VPWR VPWR sky130_fd_sc_hd__decap_3
XFILLER_40_147 VGND VGND VPWR VPWR sky130_fd_sc_hd__decap_3
XTAP_TAPCELL_ROW_51_687 VGND VPWR sky130_fd_sc_hd__tapvpwrvgnd_1
XFILLER_0_221 VGND VGND VPWR VPWR sky130_fd_sc_hd__decap_3
Xoutput55 _5149_/Q VGND VGND VPWR VPWR INSTR_ADDR[0] sky130_fd_sc_hd__clkdlybuf4s25_1
Xoutput66 _5138_/Q VGND VGND VPWR VPWR INSTR_ADDR[5] sky130_fd_sc_hd__clkdlybuf4s25_1
XFILLER_0_243 VGND VGND VPWR VPWR sky130_fd_sc_hd__decap_3
Xoutput77 _2877_/Y VGND VGND VPWR VPWR MEM_ADDR[10] sky130_fd_sc_hd__clkdlybuf4s25_1
Xoutput88 _2866_/Y VGND VGND VPWR VPWR MEM_ADDR[6] sky130_fd_sc_hd__clkdlybuf4s25_1
Xoutput99 _2725_/X VGND VGND VPWR VPWR MEM_STR_DATA[1] sky130_fd_sc_hd__clkdlybuf4s25_1
XFILLER_0_265 VGND VGND VPWR VPWR sky130_fd_sc_hd__decap_3
XFILLER_0_287 VGND VGND VPWR VPWR sky130_fd_sc_hd__decap_3
XFILLER_48_203 VGND VGND VPWR VPWR sky130_fd_sc_hd__decap_3
XFILLER_88_372 VGND VGND VPWR VPWR sky130_fd_sc_hd__decap_3
XFILLER_48_236 VGND VGND VPWR VPWR sky130_fd_sc_hd__decap_3
XFILLER_56_41 VGND VGND VPWR VPWR sky130_fd_sc_hd__decap_3
XTAP_TAPCELL_ROW_59_765 VGND VPWR sky130_fd_sc_hd__tapvpwrvgnd_1
XFILLER_76_545 VGND VGND VPWR VPWR sky130_fd_sc_hd__decap_3
XFILLER_29_461 VGND VGND VPWR VPWR sky130_fd_sc_hd__fill_2
XFILLER_56_74 VGND VGND VPWR VPWR sky130_fd_sc_hd__decap_3
XFILLER_91_515 VGND VGND VPWR VPWR sky130_fd_sc_hd__decap_3
XFILLER_16_100 VGND VGND VPWR VPWR sky130_fd_sc_hd__decap_3
XFILLER_29_483 VGND VGND VPWR VPWR sky130_fd_sc_hd__fill_1
XFILLER_29_494 VGND VGND VPWR VPWR sky130_fd_sc_hd__decap_3
XFILLER_56_280 VGND VGND VPWR VPWR sky130_fd_sc_hd__decap_3
XFILLER_56_85 VGND VGND VPWR VPWR sky130_fd_sc_hd__fill_1
XFILLER_44_442 VGND VGND VPWR VPWR sky130_fd_sc_hd__decap_3
XFILLER_44_475 VGND VGND VPWR VPWR sky130_fd_sc_hd__fill_1
XFILLER_71_261 VGND VGND VPWR VPWR sky130_fd_sc_hd__decap_3
XTAP_TAPCELL_ROW_14_334 VGND VPWR sky130_fd_sc_hd__tapvpwrvgnd_1
XFILLER_31_169 VGND VGND VPWR VPWR sky130_fd_sc_hd__decap_3
XFILLER_68_6 VGND VGND VPWR VPWR sky130_fd_sc_hd__decap_3
XFILLER_8_387 VGND VGND VPWR VPWR sky130_fd_sc_hd__decap_3
XFILLER_8_365 VGND VGND VPWR VPWR sky130_fd_sc_hd__decap_3
X_4270_ _4155_/A _4267_/Y _4268_/Y _4269_/X VGND VGND VPWR VPWR _4270_/X sky130_fd_sc_hd__o31a_2
X_3221_ _2935_/X _3221_/A2 _3208_/Y _5119_/Q VGND VGND VPWR VPWR _5119_/D sky130_fd_sc_hd__a22o_2
XFILLER_86_309 VGND VGND VPWR VPWR sky130_fd_sc_hd__decap_3
XFILLER_39_225 VGND VGND VPWR VPWR sky130_fd_sc_hd__decap_3
XFILLER_67_523 VGND VGND VPWR VPWR sky130_fd_sc_hd__decap_3
Xclkbuf_leaf_9_CLK clkload0/A VGND VGND VPWR VPWR _5241_/CLK sky130_fd_sc_hd__clkbuf_8
X_3152_ _2944_/X _3152_/A2 _3136_/Y _5058_/Q VGND VGND VPWR VPWR _5058_/D sky130_fd_sc_hd__a22o_2
XFILLER_54_206 VGND VGND VPWR VPWR sky130_fd_sc_hd__decap_3
X_3083_ _2903_/X _3093_/A2 _3096_/B1 _4997_/Q VGND VGND VPWR VPWR _4997_/D sky130_fd_sc_hd__a22o_2
XFILLER_35_420 VGND VGND VPWR VPWR sky130_fd_sc_hd__decap_3
XFILLER_22_114 VGND VGND VPWR VPWR sky130_fd_sc_hd__decap_3
XFILLER_35_486 VGND VGND VPWR VPWR sky130_fd_sc_hd__decap_3
XFILLER_35_497 VGND VGND VPWR VPWR sky130_fd_sc_hd__decap_3
XFILLER_62_261 VGND VGND VPWR VPWR sky130_fd_sc_hd__decap_3
XFILLER_62_294 VGND VGND VPWR VPWR sky130_fd_sc_hd__decap_3
X_3985_ _4155_/A _3985_/B VGND VGND VPWR VPWR _4556_/A sky130_fd_sc_hd__nor2_2
XFILLER_10_309 VGND VGND VPWR VPWR sky130_fd_sc_hd__decap_3
X_2936_ _4879_/Q _2936_/A2 _2935_/X _2936_/B2 VGND VGND VPWR VPWR _4879_/D sky130_fd_sc_hd__a22o_2
X_2867_ _2865_/A _4164_/A _2621_/A VGND VGND VPWR VPWR _2868_/B sky130_fd_sc_hd__a21bo_2
X_4606_ _4605_/X _4539_/Y _4802_/A VGND VGND VPWR VPWR _4607_/B sky130_fd_sc_hd__mux2_1
X_2798_ _4893_/Q _4877_/Q _5101_/Q _5085_/Q _2812_/S0 _2848_/S1 VGND VGND VPWR VPWR
+ _2798_/X sky130_fd_sc_hd__mux4_2
X_4537_ _4396_/Y _4535_/Y _4534_/X VGND VGND VPWR VPWR _4537_/X sky130_fd_sc_hd__a21o_2
X_4468_ _4468_/A _4477_/A VGND VGND VPWR VPWR _4468_/Y sky130_fd_sc_hd__nor2_2
XFILLER_89_125 VGND VGND VPWR VPWR sky130_fd_sc_hd__fill_1
XFILLER_77_18 VGND VGND VPWR VPWR sky130_fd_sc_hd__fill_1
X_3419_ _5156_/Q _3450_/C _3228_/Y _3418_/X VGND VGND VPWR VPWR _5156_/D sky130_fd_sc_hd__o22a_2
XFILLER_58_512 VGND VGND VPWR VPWR sky130_fd_sc_hd__decap_3
X_4399_ _4398_/Y _4396_/Y _4393_/Y _4391_/Y VGND VGND VPWR VPWR _4687_/A sky130_fd_sc_hd__o2bb2a_2
XTAP_TAPCELL_ROW_90_1060 VGND VPWR sky130_fd_sc_hd__tapvpwrvgnd_1
XFILLER_58_545 VGND VGND VPWR VPWR sky130_fd_sc_hd__decap_3
XFILLER_85_320 VGND VGND VPWR VPWR sky130_fd_sc_hd__decap_3
XFILLER_73_526 VGND VGND VPWR VPWR sky130_fd_sc_hd__decap_3
XTAP_TAPCELL_ROW_56_735 VGND VPWR sky130_fd_sc_hd__tapvpwrvgnd_1
XFILLER_60_209 VGND VGND VPWR VPWR sky130_fd_sc_hd__decap_3
XFILLER_26_475 VGND VGND VPWR VPWR sky130_fd_sc_hd__fill_1
XFILLER_41_423 VGND VGND VPWR VPWR sky130_fd_sc_hd__decap_3
XFILLER_53_261 VGND VGND VPWR VPWR sky130_fd_sc_hd__decap_3
XFILLER_13_169 VGND VGND VPWR VPWR sky130_fd_sc_hd__fill_1
XTAP_TAPCELL_ROW_11_304 VGND VPWR sky130_fd_sc_hd__tapvpwrvgnd_1
XFILLER_5_346 VGND VGND VPWR VPWR sky130_fd_sc_hd__decap_3
XFILLER_3_37 VGND VGND VPWR VPWR sky130_fd_sc_hd__fill_1
XFILLER_68_309 VGND VGND VPWR VPWR sky130_fd_sc_hd__decap_3
XFILLER_64_515 VGND VGND VPWR VPWR sky130_fd_sc_hd__decap_3
XFILLER_76_386 VGND VGND VPWR VPWR sky130_fd_sc_hd__decap_3
XFILLER_17_431 VGND VGND VPWR VPWR sky130_fd_sc_hd__decap_3
XFILLER_64_548 VGND VGND VPWR VPWR sky130_fd_sc_hd__decap_3
XFILLER_17_464 VGND VGND VPWR VPWR sky130_fd_sc_hd__fill_1
XFILLER_44_250 VGND VGND VPWR VPWR sky130_fd_sc_hd__fill_2
XFILLER_83_50 VGND VGND VPWR VPWR sky130_fd_sc_hd__decap_3
XFILLER_17_486 VGND VGND VPWR VPWR sky130_fd_sc_hd__decap_3
XFILLER_91_389 VGND VGND VPWR VPWR sky130_fd_sc_hd__decap_3
XFILLER_32_467 VGND VGND VPWR VPWR sky130_fd_sc_hd__decap_3
X_3770_ _5129_/Q _3770_/B VGND VGND VPWR VPWR _3770_/X sky130_fd_sc_hd__or2_2
X_2721_ _2831_/S _2721_/B VGND VGND VPWR VPWR _2721_/X sky130_fd_sc_hd__or2_2
XFILLER_12_191 VGND VGND VPWR VPWR sky130_fd_sc_hd__decap_3
X_2652_ _2652_/A _2652_/B _3682_/B VGND VGND VPWR VPWR _2679_/B sky130_fd_sc_hd__and3_2
X_2583_ _5154_/Q _4449_/A VGND VGND VPWR VPWR _2585_/A sky130_fd_sc_hd__and2_2
X_4322_ _4326_/A _3998_/Y _4000_/X _3680_/B _4321_/X VGND VGND VPWR VPWR _4323_/C
+ sky130_fd_sc_hd__a221o_2
XFILLER_59_309 VGND VGND VPWR VPWR sky130_fd_sc_hd__decap_3
X_4253_ _4155_/A _4248_/Y _4252_/Y _4047_/B _4200_/Y VGND VGND VPWR VPWR _4253_/X
+ sky130_fd_sc_hd__o32a_2
X_3204_ _2938_/X _3190_/B _3190_/Y _5104_/Q VGND VGND VPWR VPWR _5104_/D sky130_fd_sc_hd__a22o_2
XFILLER_67_342 VGND VGND VPWR VPWR sky130_fd_sc_hd__decap_3
X_4184_ _3873_/B _3937_/X _4224_/A VGND VGND VPWR VPWR _4184_/Y sky130_fd_sc_hd__a21oi_2
XFILLER_55_515 VGND VGND VPWR VPWR sky130_fd_sc_hd__decap_3
X_3135_ _3135_/A _3153_/B VGND VGND VPWR VPWR _3136_/B sky130_fd_sc_hd__nor2_2
XFILLER_82_301 VGND VGND VPWR VPWR sky130_fd_sc_hd__decap_3
XFILLER_55_548 VGND VGND VPWR VPWR sky130_fd_sc_hd__decap_3
X_3066_ _2910_/X _3074_/A2 _3061_/Y _4983_/Q VGND VGND VPWR VPWR _4983_/D sky130_fd_sc_hd__a22o_2
XFILLER_82_345 VGND VGND VPWR VPWR sky130_fd_sc_hd__decap_3
XFILLER_82_312 VGND VGND VPWR VPWR sky130_fd_sc_hd__decap_3
XTAP_TAPCELL_ROW_53_705 VGND VPWR sky130_fd_sc_hd__tapvpwrvgnd_1
XFILLER_23_412 VGND VGND VPWR VPWR sky130_fd_sc_hd__decap_3
XFILLER_35_272 VGND VGND VPWR VPWR sky130_fd_sc_hd__decap_3
XFILLER_23_445 VGND VGND VPWR VPWR sky130_fd_sc_hd__decap_3
XFILLER_50_253 VGND VGND VPWR VPWR sky130_fd_sc_hd__decap_3
X_3968_ _4493_/A _3934_/B _4787_/S VGND VGND VPWR VPWR _3968_/X sky130_fd_sc_hd__mux2_1
XFILLER_10_139 VGND VGND VPWR VPWR sky130_fd_sc_hd__fill_1
X_2919_ _5197_/Q _2455_/X _3456_/B _5245_/Q _2918_/X VGND VGND VPWR VPWR _2919_/X
+ sky130_fd_sc_hd__a221o_2
XTAP_TAPCELL_ROW_61_782 VGND VPWR sky130_fd_sc_hd__tapvpwrvgnd_1
X_3899_ _3806_/Y _3898_/A _3884_/X VGND VGND VPWR VPWR _3899_/Y sky130_fd_sc_hd__a21oi_2
XFILLER_77_128 VGND VGND VPWR VPWR sky130_fd_sc_hd__fill_1
XFILLER_58_353 VGND VGND VPWR VPWR sky130_fd_sc_hd__decap_3
XTAP_TAPCELL_ROW_69_860 VGND VPWR sky130_fd_sc_hd__tapvpwrvgnd_1
XFILLER_18_217 VGND VGND VPWR VPWR sky130_fd_sc_hd__decap_3
XFILLER_58_397 VGND VGND VPWR VPWR sky130_fd_sc_hd__fill_1
XFILLER_73_323 VGND VGND VPWR VPWR sky130_fd_sc_hd__decap_3
XFILLER_85_172 VGND VGND VPWR VPWR sky130_fd_sc_hd__fill_1
XFILLER_14_401 VGND VGND VPWR VPWR sky130_fd_sc_hd__decap_3
XFILLER_61_529 VGND VGND VPWR VPWR sky130_fd_sc_hd__decap_3
XFILLER_41_220 VGND VGND VPWR VPWR sky130_fd_sc_hd__decap_3
XFILLER_41_231 VGND VGND VPWR VPWR sky130_fd_sc_hd__decap_3
XFILLER_41_253 VGND VGND VPWR VPWR sky130_fd_sc_hd__decap_3
XFILLER_41_275 VGND VGND VPWR VPWR sky130_fd_sc_hd__decap_3
XFILLER_5_143 VGND VGND VPWR VPWR sky130_fd_sc_hd__decap_3
XFILLER_1_360 VGND VGND VPWR VPWR sky130_fd_sc_hd__decap_3
XFILLER_78_72 VGND VGND VPWR VPWR sky130_fd_sc_hd__decap_3
XFILLER_1_393 VGND VGND VPWR VPWR sky130_fd_sc_hd__fill_1
XFILLER_68_139 VGND VGND VPWR VPWR sky130_fd_sc_hd__fill_1
XFILLER_49_364 VGND VGND VPWR VPWR sky130_fd_sc_hd__decap_3
XFILLER_64_301 VGND VGND VPWR VPWR sky130_fd_sc_hd__fill_2
XFILLER_83_109 VGND VGND VPWR VPWR sky130_fd_sc_hd__decap_3
XFILLER_76_150 VGND VGND VPWR VPWR sky130_fd_sc_hd__fill_2
XFILLER_64_312 VGND VGND VPWR VPWR sky130_fd_sc_hd__decap_3
XFILLER_52_507 VGND VGND VPWR VPWR sky130_fd_sc_hd__decap_3
XFILLER_64_345 VGND VGND VPWR VPWR sky130_fd_sc_hd__decap_3
XFILLER_91_142 VGND VGND VPWR VPWR sky130_fd_sc_hd__fill_1
X_4940_ _5116_/CLK _4940_/D VGND VGND VPWR VPWR _4940_/Q sky130_fd_sc_hd__dfxtp_2
X_4871_ _5111_/CLK _4871_/D VGND VGND VPWR VPWR _4871_/Q sky130_fd_sc_hd__dfxtp_2
XFILLER_20_404 VGND VGND VPWR VPWR sky130_fd_sc_hd__decap_3
XFILLER_32_264 VGND VGND VPWR VPWR sky130_fd_sc_hd__decap_3
X_3822_ _4664_/S _4662_/B VGND VGND VPWR VPWR _3847_/B sky130_fd_sc_hd__nor2_2
X_3753_ _4471_/B _3911_/C VGND VGND VPWR VPWR _4766_/S sky130_fd_sc_hd__nor2_2
X_3684_ _5129_/Q _3684_/B VGND VGND VPWR VPWR _3684_/X sky130_fd_sc_hd__or2_2
X_2704_ _4866_/A _5258_/Q VGND VGND VPWR VPWR _5257_/D sky130_fd_sc_hd__or2_2
XTAP_TAPCELL_ROW_30_487 VGND VPWR sky130_fd_sc_hd__tapvpwrvgnd_1
XFILLER_9_493 VGND VGND VPWR VPWR sky130_fd_sc_hd__decap_3
X_2635_ _2652_/A VGND VGND VPWR VPWR _2638_/A sky130_fd_sc_hd__inv_2
X_4305_ _4110_/A _4289_/Y _4303_/X _4304_/X VGND VGND VPWR VPWR _4306_/B sky130_fd_sc_hd__a22o_2
X_2566_ _5062_/Q _5046_/Q _5030_/Q _5014_/Q _2658_/S0 _2671_/S1 VGND VGND VPWR VPWR
+ _2566_/X sky130_fd_sc_hd__mux4_2
X_2497_ _4960_/Q _4944_/Q _4928_/Q _4912_/Q _5123_/Q _2671_/S1 VGND VGND VPWR VPWR
+ _2497_/X sky130_fd_sc_hd__mux4_2
XFILLER_87_426 VGND VGND VPWR VPWR sky130_fd_sc_hd__decap_3
XFILLER_4_80 VGND VGND VPWR VPWR sky130_fd_sc_hd__decap_3
X_4236_ _3903_/Y _3905_/Y _4220_/X _4235_/X VGND VGND VPWR VPWR _4236_/Y sky130_fd_sc_hd__o31ai_2
X_4167_ _2452_/Y _4149_/X _4163_/X _4166_/X VGND VGND VPWR VPWR _4168_/B sky130_fd_sc_hd__a22o_2
XFILLER_55_312 VGND VGND VPWR VPWR sky130_fd_sc_hd__decap_3
XFILLER_67_194 VGND VGND VPWR VPWR sky130_fd_sc_hd__decap_3
X_3118_ _2891_/X _3117_/B _3133_/B1 _5027_/Q VGND VGND VPWR VPWR _5027_/D sky130_fd_sc_hd__a22o_2
XTAP_TAPCELL_ROW_66_830 VGND VPWR sky130_fd_sc_hd__tapvpwrvgnd_1
XFILLER_55_367 VGND VGND VPWR VPWR sky130_fd_sc_hd__decap_3
X_4098_ _4097_/A _4044_/X _4340_/A VGND VGND VPWR VPWR _4098_/X sky130_fd_sc_hd__mux2_1
XFILLER_55_389 VGND VGND VPWR VPWR sky130_fd_sc_hd__decap_3
XFILLER_70_315 VGND VGND VPWR VPWR sky130_fd_sc_hd__decap_3
X_3049_ _2913_/X _3056_/A2 _3043_/Y _4968_/Q VGND VGND VPWR VPWR _4968_/D sky130_fd_sc_hd__a22o_2
XTAP_TAPCELL_ROW_38_565 VGND VPWR sky130_fd_sc_hd__tapvpwrvgnd_1
XFILLER_82_186 VGND VGND VPWR VPWR sky130_fd_sc_hd__decap_3
XFILLER_23_220 VGND VGND VPWR VPWR sky130_fd_sc_hd__decap_3
XFILLER_23_231 VGND VGND VPWR VPWR sky130_fd_sc_hd__decap_3
XFILLER_51_540 VGND VGND VPWR VPWR sky130_fd_sc_hd__fill_1
XFILLER_70_348 VGND VGND VPWR VPWR sky130_fd_sc_hd__decap_3
XFILLER_82_197 VGND VGND VPWR VPWR sky130_fd_sc_hd__decap_3
XFILLER_90_29 VGND VGND VPWR VPWR sky130_fd_sc_hd__decap_3
XFILLER_23_89 VGND VGND VPWR VPWR sky130_fd_sc_hd__decap_3
XFILLER_93_407 VGND VGND VPWR VPWR sky130_fd_sc_hd__decap_3
XFILLER_58_161 VGND VGND VPWR VPWR sky130_fd_sc_hd__decap_3
XFILLER_0_49 VGND VGND VPWR VPWR sky130_fd_sc_hd__decap_3
XFILLER_73_131 VGND VGND VPWR VPWR sky130_fd_sc_hd__decap_3
XFILLER_46_389 VGND VGND VPWR VPWR sky130_fd_sc_hd__decap_3
XFILLER_73_186 VGND VGND VPWR VPWR sky130_fd_sc_hd__decap_3
XFILLER_61_337 VGND VGND VPWR VPWR sky130_fd_sc_hd__decap_3
XFILLER_61_359 VGND VGND VPWR VPWR sky130_fd_sc_hd__decap_3
XFILLER_64_85 VGND VGND VPWR VPWR sky130_fd_sc_hd__decap_3
XFILLER_14_253 VGND VGND VPWR VPWR sky130_fd_sc_hd__decap_3
XFILLER_42_551 VGND VGND VPWR VPWR sky130_fd_sc_hd__fill_2
XTAP_TAPCELL_ROW_72_888 VGND VPWR sky130_fd_sc_hd__tapvpwrvgnd_1
XFILLER_80_62 VGND VGND VPWR VPWR sky130_fd_sc_hd__decap_3
XFILLER_50_6 VGND VGND VPWR VPWR sky130_fd_sc_hd__fill_2
X_2420_ _5204_/Q VGND VGND VPWR VPWR _2420_/Y sky130_fd_sc_hd__inv_2
X_5070_ _5100_/CLK _5070_/D VGND VGND VPWR VPWR _5070_/Q sky130_fd_sc_hd__dfxtp_2
XTAP_TAPCELL_ROW_9_290 VGND VPWR sky130_fd_sc_hd__tapvpwrvgnd_1
XFILLER_29_3 VGND VGND VPWR VPWR sky130_fd_sc_hd__fill_2
X_4021_ _4360_/A _3916_/X _3914_/X VGND VGND VPWR VPWR _4021_/X sky130_fd_sc_hd__a21bo_2
XFILLER_84_418 VGND VGND VPWR VPWR sky130_fd_sc_hd__fill_2
XFILLER_49_172 VGND VGND VPWR VPWR sky130_fd_sc_hd__decap_3
XFILLER_77_481 VGND VGND VPWR VPWR sky130_fd_sc_hd__decap_3
XFILLER_37_334 VGND VGND VPWR VPWR sky130_fd_sc_hd__fill_2
XFILLER_64_131 VGND VGND VPWR VPWR sky130_fd_sc_hd__decap_3
XFILLER_92_440 VGND VGND VPWR VPWR sky130_fd_sc_hd__decap_3
XFILLER_52_315 VGND VGND VPWR VPWR sky130_fd_sc_hd__decap_3
XFILLER_64_164 VGND VGND VPWR VPWR sky130_fd_sc_hd__decap_3
XTAP_TAPCELL_ROW_63_800 VGND VPWR sky130_fd_sc_hd__tapvpwrvgnd_1
XFILLER_92_495 VGND VGND VPWR VPWR sky130_fd_sc_hd__decap_3
XFILLER_52_348 VGND VGND VPWR VPWR sky130_fd_sc_hd__decap_3
XFILLER_64_197 VGND VGND VPWR VPWR sky130_fd_sc_hd__fill_2
X_4923_ _5115_/CLK _4923_/D VGND VGND VPWR VPWR _4923_/Q sky130_fd_sc_hd__dfxtp_2
XTAP_TAPCELL_ROW_35_535 VGND VPWR sky130_fd_sc_hd__tapvpwrvgnd_1
XFILLER_33_551 VGND VGND VPWR VPWR sky130_fd_sc_hd__fill_2
X_4854_ _2455_/X _2458_/X _5258_/D _4716_/B _4853_/X VGND VGND VPWR VPWR _5256_/D
+ sky130_fd_sc_hd__a41o_2
XFILLER_20_234 VGND VGND VPWR VPWR sky130_fd_sc_hd__decap_3
XFILLER_20_256 VGND VGND VPWR VPWR sky130_fd_sc_hd__fill_2
X_4785_ _4772_/Y _4784_/X _4714_/A VGND VGND VPWR VPWR _5235_/D sky130_fd_sc_hd__a21oi_2
X_3805_ _3805_/A _4690_/S VGND VGND VPWR VPWR _4191_/A sky130_fd_sc_hd__nor2_2
X_3736_ _3831_/A _3735_/X _5130_/Q VGND VGND VPWR VPWR _3736_/X sky130_fd_sc_hd__o21a_2
XFILLER_9_290 VGND VGND VPWR VPWR sky130_fd_sc_hd__decap_3
XFILLER_69_19 VGND VGND VPWR VPWR sky130_fd_sc_hd__decap_3
X_3667_ _4173_/A _3660_/X _4172_/A _3666_/Y VGND VGND VPWR VPWR _3667_/X sky130_fd_sc_hd__o211a_2
X_3598_ _4397_/A _5155_/Q _4542_/S VGND VGND VPWR VPWR _3643_/B sky130_fd_sc_hd__mux2_1
X_2618_ _3934_/C VGND VGND VPWR VPWR _2618_/Y sky130_fd_sc_hd__inv_2
X_2549_ _5157_/Q _4466_/A VGND VGND VPWR VPWR _2617_/B sky130_fd_sc_hd__or2_2
XFILLER_87_201 VGND VGND VPWR VPWR sky130_fd_sc_hd__decap_3
XFILLER_87_234 VGND VGND VPWR VPWR sky130_fd_sc_hd__decap_3
XFILLER_75_407 VGND VGND VPWR VPWR sky130_fd_sc_hd__decap_3
X_4219_ _4546_/A _4219_/B VGND VGND VPWR VPWR _4219_/Y sky130_fd_sc_hd__nor2_2
XFILLER_87_256 VGND VGND VPWR VPWR sky130_fd_sc_hd__decap_3
XFILLER_68_470 VGND VGND VPWR VPWR sky130_fd_sc_hd__decap_3
X_5199_ _5200_/CLK _5199_/D VGND VGND VPWR VPWR _5199_/Q sky130_fd_sc_hd__dfxtp_2
XTAP_TAPCELL_ROW_87_1032 VGND VPWR sky130_fd_sc_hd__tapvpwrvgnd_1
XFILLER_55_153 VGND VGND VPWR VPWR sky130_fd_sc_hd__decap_3
XFILLER_43_337 VGND VGND VPWR VPWR sky130_fd_sc_hd__decap_3
XFILLER_55_197 VGND VGND VPWR VPWR sky130_fd_sc_hd__fill_2
XFILLER_70_123 VGND VGND VPWR VPWR sky130_fd_sc_hd__decap_3
XFILLER_83_495 VGND VGND VPWR VPWR sky130_fd_sc_hd__fill_1
XFILLER_11_201 VGND VGND VPWR VPWR sky130_fd_sc_hd__fill_2
XFILLER_34_66 VGND VGND VPWR VPWR sky130_fd_sc_hd__decap_3
XFILLER_34_88 VGND VGND VPWR VPWR sky130_fd_sc_hd__decap_3
XFILLER_11_267 VGND VGND VPWR VPWR sky130_fd_sc_hd__decap_3
XFILLER_11_289 VGND VGND VPWR VPWR sky130_fd_sc_hd__decap_3
XFILLER_50_65 VGND VGND VPWR VPWR sky130_fd_sc_hd__decap_3
XFILLER_3_433 VGND VGND VPWR VPWR sky130_fd_sc_hd__fill_2
XFILLER_59_30 VGND VGND VPWR VPWR sky130_fd_sc_hd__decap_3
XFILLER_59_63 VGND VGND VPWR VPWR sky130_fd_sc_hd__decap_3
XFILLER_66_407 VGND VGND VPWR VPWR sky130_fd_sc_hd__decap_3
XTAP_TAPCELL_ROW_6_260 VGND VPWR sky130_fd_sc_hd__tapvpwrvgnd_1
XFILLER_78_278 VGND VGND VPWR VPWR sky130_fd_sc_hd__decap_3
XFILLER_78_256 VGND VGND VPWR VPWR sky130_fd_sc_hd__decap_3
XFILLER_15_9 VGND VGND VPWR VPWR sky130_fd_sc_hd__decap_3
XTAP_TAPCELL_ROW_77_936 VGND VPWR sky130_fd_sc_hd__tapvpwrvgnd_1
XFILLER_46_120 VGND VGND VPWR VPWR sky130_fd_sc_hd__decap_3
XFILLER_74_440 VGND VGND VPWR VPWR sky130_fd_sc_hd__fill_2
XFILLER_34_304 VGND VGND VPWR VPWR sky130_fd_sc_hd__decap_3
XFILLER_75_84 VGND VGND VPWR VPWR sky130_fd_sc_hd__decap_3
XFILLER_34_337 VGND VGND VPWR VPWR sky130_fd_sc_hd__decap_3
XFILLER_46_186 VGND VGND VPWR VPWR sky130_fd_sc_hd__fill_2
XFILLER_61_156 VGND VGND VPWR VPWR sky130_fd_sc_hd__decap_3
XTAP_TAPCELL_ROW_32_505 VGND VPWR sky130_fd_sc_hd__tapvpwrvgnd_1
XFILLER_61_189 VGND VGND VPWR VPWR sky130_fd_sc_hd__decap_3
X_4570_ _4511_/A _4511_/B _4509_/X VGND VGND VPWR VPWR _4572_/B sky130_fd_sc_hd__a21oi_2
X_3521_ _4866_/A _3521_/B VGND VGND VPWR VPWR _5196_/D sky130_fd_sc_hd__nor2_2
XTAP_TAPCELL_ROW_40_582 VGND VPWR sky130_fd_sc_hd__tapvpwrvgnd_1
XFILLER_6_271 VGND VGND VPWR VPWR sky130_fd_sc_hd__decap_3
X_3452_ _4866_/A _3452_/B VGND VGND VPWR VPWR _5183_/D sky130_fd_sc_hd__nor2_2
X_3383_ _5185_/Q _3378_/X _3379_/Y _3382_/Y _3265_/Y VGND VGND VPWR VPWR _3383_/X
+ sky130_fd_sc_hd__a32o_2
XFILLER_69_212 VGND VGND VPWR VPWR sky130_fd_sc_hd__fill_1
X_5122_ _5122_/CLK _5122_/D VGND VGND VPWR VPWR _5122_/Q sky130_fd_sc_hd__dfxtp_2
XFILLER_29_109 VGND VGND VPWR VPWR sky130_fd_sc_hd__decap_3
X_5053_ _5210_/CLK _5053_/D VGND VGND VPWR VPWR _5053_/Q sky130_fd_sc_hd__dfxtp_2
XFILLER_84_237 VGND VGND VPWR VPWR sky130_fd_sc_hd__fill_2
X_4004_ _3729_/X _4371_/B _4632_/A _2594_/X _3847_/A VGND VGND VPWR VPWR _4004_/X
+ sky130_fd_sc_hd__o221a_2
XFILLER_25_304 VGND VGND VPWR VPWR sky130_fd_sc_hd__decap_3
XFILLER_37_164 VGND VGND VPWR VPWR sky130_fd_sc_hd__decap_3
XFILLER_37_175 VGND VGND VPWR VPWR sky130_fd_sc_hd__decap_3
XFILLER_65_484 VGND VGND VPWR VPWR sky130_fd_sc_hd__decap_3
XTAP_TAPCELL_ROW_48_660 VGND VPWR sky130_fd_sc_hd__tapvpwrvgnd_1
XFILLER_25_337 VGND VGND VPWR VPWR sky130_fd_sc_hd__decap_3
XFILLER_25_348 VGND VGND VPWR VPWR sky130_fd_sc_hd__decap_3
XFILLER_92_292 VGND VGND VPWR VPWR sky130_fd_sc_hd__decap_3
XFILLER_80_443 VGND VGND VPWR VPWR sky130_fd_sc_hd__decap_3
XFILLER_80_421 VGND VGND VPWR VPWR sky130_fd_sc_hd__decap_3
XFILLER_52_156 VGND VGND VPWR VPWR sky130_fd_sc_hd__decap_3
XFILLER_33_370 VGND VGND VPWR VPWR sky130_fd_sc_hd__decap_3
XFILLER_40_318 VGND VGND VPWR VPWR sky130_fd_sc_hd__decap_3
X_4906_ _5117_/CLK _4906_/D VGND VGND VPWR VPWR _4906_/Q sky130_fd_sc_hd__dfxtp_2
XFILLER_80_498 VGND VGND VPWR VPWR sky130_fd_sc_hd__fill_2
XFILLER_21_532 VGND VGND VPWR VPWR sky130_fd_sc_hd__decap_3
X_4837_ _5248_/Q _4847_/B VGND VGND VPWR VPWR _4837_/X sky130_fd_sc_hd__or2_2
X_4768_ _3636_/Y _4346_/A _4765_/X _4767_/X VGND VGND VPWR VPWR _4768_/X sky130_fd_sc_hd__o211a_2
XFILLER_20_24 VGND VGND VPWR VPWR sky130_fd_sc_hd__decap_3
X_4699_ _4181_/Y _4699_/B _4699_/C _4699_/D VGND VGND VPWR VPWR _4699_/X sky130_fd_sc_hd__and4b_2
X_3719_ _3831_/A _3718_/X _5130_/Q VGND VGND VPWR VPWR _3719_/X sky130_fd_sc_hd__o21a_2
XFILLER_20_46 VGND VGND VPWR VPWR sky130_fd_sc_hd__decap_3
XFILLER_0_403 VGND VGND VPWR VPWR sky130_fd_sc_hd__decap_3
XFILLER_88_510 VGND VGND VPWR VPWR sky130_fd_sc_hd__decap_3
XFILLER_29_11 VGND VGND VPWR VPWR sky130_fd_sc_hd__fill_2
XTAP_TAPCELL_ROW_93_1091 VGND VPWR sky130_fd_sc_hd__tapvpwrvgnd_1
XFILLER_0_458 VGND VGND VPWR VPWR sky130_fd_sc_hd__fill_1
XFILLER_29_33 VGND VGND VPWR VPWR sky130_fd_sc_hd__decap_3
XFILLER_48_407 VGND VGND VPWR VPWR sky130_fd_sc_hd__decap_3
XFILLER_75_237 VGND VGND VPWR VPWR sky130_fd_sc_hd__decap_3
XFILLER_29_88 VGND VGND VPWR VPWR sky130_fd_sc_hd__decap_3
XFILLER_56_440 VGND VGND VPWR VPWR sky130_fd_sc_hd__decap_3
XTAP_TAPCELL_ROW_74_906 VGND VPWR sky130_fd_sc_hd__tapvpwrvgnd_1
XTAP_TAPCELL_ROW_3_230 VGND VPWR sky130_fd_sc_hd__tapvpwrvgnd_1
XFILLER_28_164 VGND VGND VPWR VPWR sky130_fd_sc_hd__decap_3
XFILLER_90_218 VGND VGND VPWR VPWR sky130_fd_sc_hd__fill_1
XFILLER_45_54 VGND VGND VPWR VPWR sky130_fd_sc_hd__fill_2
XFILLER_16_359 VGND VGND VPWR VPWR sky130_fd_sc_hd__decap_3
XFILLER_31_307 VGND VGND VPWR VPWR sky130_fd_sc_hd__decap_3
XFILLER_43_145 VGND VGND VPWR VPWR sky130_fd_sc_hd__fill_1
XFILLER_71_465 VGND VGND VPWR VPWR sky130_fd_sc_hd__fill_1
XTAP_TAPCELL_ROW_82_983 VGND VPWR sky130_fd_sc_hd__tapvpwrvgnd_1
XFILLER_61_75 VGND VGND VPWR VPWR sky130_fd_sc_hd__fill_2
XFILLER_8_525 VGND VGND VPWR VPWR sky130_fd_sc_hd__fill_1
XFILLER_6_26 VGND VGND VPWR VPWR sky130_fd_sc_hd__fill_2
XFILLER_79_532 VGND VGND VPWR VPWR sky130_fd_sc_hd__decap_3
XFILLER_66_226 VGND VGND VPWR VPWR sky130_fd_sc_hd__decap_3
XFILLER_86_72 VGND VGND VPWR VPWR sky130_fd_sc_hd__decap_3
XFILLER_66_259 VGND VGND VPWR VPWR sky130_fd_sc_hd__decap_3
XFILLER_34_112 VGND VGND VPWR VPWR sky130_fd_sc_hd__decap_3
XFILLER_47_484 VGND VGND VPWR VPWR sky130_fd_sc_hd__decap_3
XFILLER_47_495 VGND VGND VPWR VPWR sky130_fd_sc_hd__decap_3
XFILLER_62_410 VGND VGND VPWR VPWR sky130_fd_sc_hd__fill_2
XFILLER_74_292 VGND VGND VPWR VPWR sky130_fd_sc_hd__fill_1
XTAP_TAPCELL_ROW_45_630 VGND VPWR sky130_fd_sc_hd__tapvpwrvgnd_1
XFILLER_15_370 VGND VGND VPWR VPWR sky130_fd_sc_hd__decap_3
XFILLER_22_329 VGND VGND VPWR VPWR sky130_fd_sc_hd__decap_3
XFILLER_34_189 VGND VGND VPWR VPWR sky130_fd_sc_hd__decap_3
X_2952_ _2906_/X _2961_/A2 _2961_/B1 _4886_/Q VGND VGND VPWR VPWR _4886_/D sky130_fd_sc_hd__a22o_2
XTAP_TAPCELL_ROW_17_365 VGND VPWR sky130_fd_sc_hd__tapvpwrvgnd_1
X_2883_ _2887_/B _2883_/B VGND VGND VPWR VPWR _2883_/Y sky130_fd_sc_hd__nor2_2
X_4622_ _4624_/A _4622_/B VGND VGND VPWR VPWR _4622_/Y sky130_fd_sc_hd__nor2_2
X_4553_ _4589_/B _4552_/X _4589_/A VGND VGND VPWR VPWR _4553_/X sky130_fd_sc_hd__o21ba_2
X_4484_ _3847_/A _3992_/B _3845_/C _4246_/A _4483_/Y VGND VGND VPWR VPWR _4484_/X
+ sky130_fd_sc_hd__o221a_2
X_3504_ _5194_/Q _4800_/B _3585_/A _3503_/Y VGND VGND VPWR VPWR _3505_/B sky130_fd_sc_hd__o2bb2a_2
X_3435_ _5163_/Q _3429_/C _3228_/Y _3434_/X VGND VGND VPWR VPWR _5163_/D sky130_fd_sc_hd__o22a_2
XFILLER_89_307 VGND VGND VPWR VPWR sky130_fd_sc_hd__decap_3
X_3366_ _5164_/Q _3366_/B VGND VGND VPWR VPWR _3367_/B sky130_fd_sc_hd__nor2_2
X_5105_ clkload3/A _5105_/D VGND VGND VPWR VPWR _5105_/Q sky130_fd_sc_hd__dfxtp_2
X_3297_ _5138_/Q _3298_/B VGND VGND VPWR VPWR _3317_/C sky130_fd_sc_hd__and2_2
X_5036_ _5085_/CLK _5036_/D VGND VGND VPWR VPWR _5036_/Q sky130_fd_sc_hd__dfxtp_2
XFILLER_38_451 VGND VGND VPWR VPWR sky130_fd_sc_hd__decap_3
XTAP_TAPCELL_ROW_0_200 VGND VPWR sky130_fd_sc_hd__tapvpwrvgnd_1
XFILLER_65_281 VGND VGND VPWR VPWR sky130_fd_sc_hd__decap_3
XTAP_TAPCELL_ROW_84_1002 VGND VPWR sky130_fd_sc_hd__tapvpwrvgnd_1
XFILLER_25_134 VGND VGND VPWR VPWR sky130_fd_sc_hd__fill_1
XFILLER_53_476 VGND VGND VPWR VPWR sky130_fd_sc_hd__decap_3
XFILLER_13_329 VGND VGND VPWR VPWR sky130_fd_sc_hd__decap_3
XFILLER_15_35 VGND VGND VPWR VPWR sky130_fd_sc_hd__decap_3
XFILLER_15_57 VGND VGND VPWR VPWR sky130_fd_sc_hd__fill_2
XFILLER_40_137 VGND VGND VPWR VPWR sky130_fd_sc_hd__decap_3
XFILLER_80_295 VGND VGND VPWR VPWR sky130_fd_sc_hd__fill_2
XFILLER_21_340 VGND VGND VPWR VPWR sky130_fd_sc_hd__fill_1
XTAP_TAPCELL_ROW_51_688 VGND VPWR sky130_fd_sc_hd__tapvpwrvgnd_1
XFILLER_0_200 VGND VGND VPWR VPWR sky130_fd_sc_hd__decap_3
Xoutput56 _5143_/Q VGND VGND VPWR VPWR INSTR_ADDR[10] sky130_fd_sc_hd__clkdlybuf4s25_1
Xoutput67 _5139_/Q VGND VGND VPWR VPWR INSTR_ADDR[6] sky130_fd_sc_hd__clkdlybuf4s25_1
Xoutput78 _2880_/Y VGND VGND VPWR VPWR MEM_ADDR[11] sky130_fd_sc_hd__clkdlybuf4s25_1
Xoutput89 _2869_/Y VGND VGND VPWR VPWR MEM_ADDR[7] sky130_fd_sc_hd__clkdlybuf4s25_1
XFILLER_88_351 VGND VGND VPWR VPWR sky130_fd_sc_hd__decap_3
XFILLER_0_277 VGND VGND VPWR VPWR sky130_fd_sc_hd__decap_3
XFILLER_48_215 VGND VGND VPWR VPWR sky130_fd_sc_hd__decap_3
XFILLER_88_384 VGND VGND VPWR VPWR sky130_fd_sc_hd__decap_3
XFILLER_56_53 VGND VGND VPWR VPWR sky130_fd_sc_hd__decap_3
XTAP_TAPCELL_ROW_59_766 VGND VPWR sky130_fd_sc_hd__tapvpwrvgnd_1
XFILLER_44_410 VGND VGND VPWR VPWR sky130_fd_sc_hd__fill_2
XFILLER_44_421 VGND VGND VPWR VPWR sky130_fd_sc_hd__decap_3
XFILLER_56_292 VGND VGND VPWR VPWR sky130_fd_sc_hd__decap_3
XFILLER_56_97 VGND VGND VPWR VPWR sky130_fd_sc_hd__decap_3
XFILLER_71_240 VGND VGND VPWR VPWR sky130_fd_sc_hd__decap_3
XFILLER_71_273 VGND VGND VPWR VPWR sky130_fd_sc_hd__fill_2
XTAP_TAPCELL_ROW_42_600 VGND VPWR sky130_fd_sc_hd__tapvpwrvgnd_1
XFILLER_72_85 VGND VGND VPWR VPWR sky130_fd_sc_hd__decap_3
XTAP_TAPCELL_ROW_14_335 VGND VPWR sky130_fd_sc_hd__tapvpwrvgnd_1
XFILLER_12_362 VGND VGND VPWR VPWR sky130_fd_sc_hd__fill_2
XFILLER_12_384 VGND VGND VPWR VPWR sky130_fd_sc_hd__decap_3
XFILLER_4_550 VGND VGND VPWR VPWR sky130_fd_sc_hd__decap_3
X_3220_ _2932_/X _3221_/A2 _3208_/Y _5118_/Q VGND VGND VPWR VPWR _5118_/D sky130_fd_sc_hd__a22o_2
XFILLER_39_215 VGND VGND VPWR VPWR sky130_fd_sc_hd__decap_3
X_3151_ _2941_/X _3136_/B _3136_/Y _5057_/Q VGND VGND VPWR VPWR _5057_/D sky130_fd_sc_hd__a22o_2
XFILLER_79_362 VGND VGND VPWR VPWR sky130_fd_sc_hd__decap_3
XFILLER_11_3 VGND VGND VPWR VPWR sky130_fd_sc_hd__decap_3
XFILLER_39_248 VGND VGND VPWR VPWR sky130_fd_sc_hd__decap_3
XFILLER_67_535 VGND VGND VPWR VPWR sky130_fd_sc_hd__decap_3
XFILLER_54_218 VGND VGND VPWR VPWR sky130_fd_sc_hd__fill_1
X_3082_ _2900_/X _3093_/A2 _3096_/B1 _4996_/Q VGND VGND VPWR VPWR _4996_/D sky130_fd_sc_hd__a22o_2
XFILLER_35_432 VGND VGND VPWR VPWR sky130_fd_sc_hd__decap_3
XFILLER_47_292 VGND VGND VPWR VPWR sky130_fd_sc_hd__decap_3
XFILLER_82_549 VGND VGND VPWR VPWR sky130_fd_sc_hd__decap_3
XFILLER_35_443 VGND VGND VPWR VPWR sky130_fd_sc_hd__decap_3
XFILLER_62_251 VGND VGND VPWR VPWR sky130_fd_sc_hd__fill_1
XFILLER_50_402 VGND VGND VPWR VPWR sky130_fd_sc_hd__decap_3
XFILLER_50_424 VGND VGND VPWR VPWR sky130_fd_sc_hd__decap_3
XFILLER_62_273 VGND VGND VPWR VPWR sky130_fd_sc_hd__decap_3
XFILLER_22_126 VGND VGND VPWR VPWR sky130_fd_sc_hd__decap_3
X_3984_ _4339_/A _3984_/B VGND VGND VPWR VPWR _3985_/B sky130_fd_sc_hd__nand2_2
X_2935_ _5202_/Q _2455_/X _3456_/B _5250_/Q _2934_/X VGND VGND VPWR VPWR _2935_/X
+ sky130_fd_sc_hd__a221o_2
X_2866_ _2887_/B _2866_/B VGND VGND VPWR VPWR _2866_/Y sky130_fd_sc_hd__nor2_2
X_4605_ _4445_/A _4787_/S _3966_/Y VGND VGND VPWR VPWR _4605_/X sky130_fd_sc_hd__o21a_2
X_2797_ _2851_/A _3332_/B VGND VGND VPWR VPWR _2797_/X sky130_fd_sc_hd__and2_2
X_4536_ _4396_/Y _4535_/Y _4534_/X VGND VGND VPWR VPWR _4786_/A sky130_fd_sc_hd__a21oi_2
X_4467_ _4589_/A _4477_/C _4589_/B VGND VGND VPWR VPWR _4470_/A sky130_fd_sc_hd__nor3_2
X_4398_ _4408_/S _4535_/B VGND VGND VPWR VPWR _4398_/Y sky130_fd_sc_hd__nor2_2
X_3418_ _5260_/Q _3448_/B _3418_/C VGND VGND VPWR VPWR _3418_/X sky130_fd_sc_hd__and3_2
XFILLER_58_524 VGND VGND VPWR VPWR sky130_fd_sc_hd__decap_3
X_3349_ _5185_/Q _3371_/C _3348_/Y _3337_/A VGND VGND VPWR VPWR _3349_/X sky130_fd_sc_hd__o31a_2
XTAP_TAPCELL_ROW_90_1061 VGND VPWR sky130_fd_sc_hd__tapvpwrvgnd_1
XFILLER_85_343 VGND VGND VPWR VPWR sky130_fd_sc_hd__decap_3
XFILLER_73_505 VGND VGND VPWR VPWR sky130_fd_sc_hd__decap_3
XFILLER_93_29 VGND VGND VPWR VPWR sky130_fd_sc_hd__decap_3
XFILLER_93_18 VGND VGND VPWR VPWR sky130_fd_sc_hd__decap_3
XFILLER_85_376 VGND VGND VPWR VPWR sky130_fd_sc_hd__decap_3
XFILLER_26_421 VGND VGND VPWR VPWR sky130_fd_sc_hd__fill_1
XFILLER_38_270 VGND VGND VPWR VPWR sky130_fd_sc_hd__fill_2
XFILLER_73_538 VGND VGND VPWR VPWR sky130_fd_sc_hd__decap_3
X_5019_ _5106_/CLK _5019_/D VGND VGND VPWR VPWR _5019_/Q sky130_fd_sc_hd__dfxtp_2
XTAP_TAPCELL_ROW_56_736 VGND VPWR sky130_fd_sc_hd__tapvpwrvgnd_1
XFILLER_53_240 VGND VGND VPWR VPWR sky130_fd_sc_hd__decap_3
XFILLER_26_487 VGND VGND VPWR VPWR sky130_fd_sc_hd__decap_3
XFILLER_41_402 VGND VGND VPWR VPWR sky130_fd_sc_hd__decap_3
XFILLER_53_284 VGND VGND VPWR VPWR sky130_fd_sc_hd__decap_3
XFILLER_41_435 VGND VGND VPWR VPWR sky130_fd_sc_hd__decap_3
XFILLER_9_119 VGND VGND VPWR VPWR sky130_fd_sc_hd__fill_1
XFILLER_42_77 VGND VGND VPWR VPWR sky130_fd_sc_hd__decap_3
XTAP_TAPCELL_ROW_11_305 VGND VPWR sky130_fd_sc_hd__tapvpwrvgnd_1
XFILLER_42_88 VGND VGND VPWR VPWR sky130_fd_sc_hd__decap_3
XFILLER_5_325 VGND VGND VPWR VPWR sky130_fd_sc_hd__decap_3
XFILLER_3_27 VGND VGND VPWR VPWR sky130_fd_sc_hd__fill_2
XFILLER_67_30 VGND VGND VPWR VPWR sky130_fd_sc_hd__decap_3
XFILLER_67_52 VGND VGND VPWR VPWR sky130_fd_sc_hd__decap_3
XFILLER_67_63 VGND VGND VPWR VPWR sky130_fd_sc_hd__fill_1
XFILLER_88_170 VGND VGND VPWR VPWR sky130_fd_sc_hd__decap_3
XFILLER_76_321 VGND VGND VPWR VPWR sky130_fd_sc_hd__fill_1
XFILLER_76_365 VGND VGND VPWR VPWR sky130_fd_sc_hd__decap_3
XFILLER_29_270 VGND VGND VPWR VPWR sky130_fd_sc_hd__decap_3
XFILLER_64_527 VGND VGND VPWR VPWR sky130_fd_sc_hd__decap_3
XFILLER_91_335 VGND VGND VPWR VPWR sky130_fd_sc_hd__fill_1
XFILLER_17_443 VGND VGND VPWR VPWR sky130_fd_sc_hd__decap_3
XFILLER_91_379 VGND VGND VPWR VPWR sky130_fd_sc_hd__fill_2
XFILLER_91_346 VGND VGND VPWR VPWR sky130_fd_sc_hd__decap_3
XFILLER_17_498 VGND VGND VPWR VPWR sky130_fd_sc_hd__decap_3
XFILLER_44_262 VGND VGND VPWR VPWR sky130_fd_sc_hd__fill_1
XTAP_TAPCELL_ROW_27_460 VGND VPWR sky130_fd_sc_hd__tapvpwrvgnd_1
XFILLER_83_73 VGND VGND VPWR VPWR sky130_fd_sc_hd__decap_3
XFILLER_32_435 VGND VGND VPWR VPWR sky130_fd_sc_hd__fill_2
XFILLER_44_295 VGND VGND VPWR VPWR sky130_fd_sc_hd__decap_3
XPHY_EDGE_ROW_17_Left_111 VGND VGND VPWR VPWR sky130_fd_sc_hd__decap_3
X_2720_ _4948_/Q _4932_/Q _4916_/Q _4900_/Q _5131_/Q _2848_/S1 VGND VGND VPWR VPWR
+ _2721_/B sky130_fd_sc_hd__mux4_2
XFILLER_80_6 VGND VGND VPWR VPWR sky130_fd_sc_hd__decap_3
X_2651_ _4198_/A _4702_/S VGND VGND VPWR VPWR _3682_/B sky130_fd_sc_hd__nor2_2
XFILLER_8_141 VGND VGND VPWR VPWR sky130_fd_sc_hd__fill_2
X_2582_ _2575_/X _2577_/X _2580_/X _2435_/Y VGND VGND VPWR VPWR _4449_/A sky130_fd_sc_hd__a22o_2
X_4321_ _3743_/Y _3869_/Y _4002_/Y _2886_/B VGND VGND VPWR VPWR _4321_/X sky130_fd_sc_hd__a22o_2
XPHY_EDGE_ROW_26_Left_120 VGND VGND VPWR VPWR sky130_fd_sc_hd__decap_3
X_4252_ _4297_/A _4339_/B VGND VGND VPWR VPWR _4252_/Y sky130_fd_sc_hd__nor2_2
X_3203_ _2935_/X _3203_/A2 _3203_/B1 _5103_/Q VGND VGND VPWR VPWR _5103_/D sky130_fd_sc_hd__a22o_2
XFILLER_86_107 VGND VGND VPWR VPWR sky130_fd_sc_hd__decap_3
X_4183_ _4191_/A _3998_/Y _4000_/X _3873_/B _4182_/Y VGND VGND VPWR VPWR _4183_/X
+ sky130_fd_sc_hd__a221o_2
X_3134_ _3134_/A _3134_/B VGND VGND VPWR VPWR _3153_/B sky130_fd_sc_hd__or2_2
X_3065_ _2906_/X _3074_/A2 _3061_/Y _4982_/Q VGND VGND VPWR VPWR _4982_/D sky130_fd_sc_hd__a22o_2
XFILLER_82_324 VGND VGND VPWR VPWR sky130_fd_sc_hd__decap_3
XTAP_TAPCELL_ROW_53_706 VGND VPWR sky130_fd_sc_hd__tapvpwrvgnd_1
XFILLER_35_251 VGND VGND VPWR VPWR sky130_fd_sc_hd__fill_1
XFILLER_82_379 VGND VGND VPWR VPWR sky130_fd_sc_hd__decap_3
XFILLER_23_424 VGND VGND VPWR VPWR sky130_fd_sc_hd__decap_3
XFILLER_35_284 VGND VGND VPWR VPWR sky130_fd_sc_hd__decap_3
XFILLER_50_210 VGND VGND VPWR VPWR sky130_fd_sc_hd__decap_3
XFILLER_50_276 VGND VGND VPWR VPWR sky130_fd_sc_hd__decap_3
X_3967_ _3965_/X _3966_/Y _4063_/A VGND VGND VPWR VPWR _3967_/Y sky130_fd_sc_hd__a21oi_2
XFILLER_10_118 VGND VGND VPWR VPWR sky130_fd_sc_hd__fill_1
X_2918_ _5229_/Q _4850_/A _3458_/B _5213_/Q VGND VGND VPWR VPWR _2918_/X sky130_fd_sc_hd__a22o_2
XTAP_TAPCELL_ROW_61_783 VGND VPWR sky130_fd_sc_hd__tapvpwrvgnd_1
XFILLER_31_490 VGND VGND VPWR VPWR sky130_fd_sc_hd__decap_3
X_3898_ _3898_/A _3898_/B VGND VGND VPWR VPWR _3898_/X sky130_fd_sc_hd__or2_2
X_2849_ _2847_/X _2848_/X _5133_/Q VGND VGND VPWR VPWR _2849_/X sky130_fd_sc_hd__mux2_1
X_4519_ _4655_/B _4654_/A _4686_/S VGND VGND VPWR VPWR _4715_/B sky130_fd_sc_hd__mux2_1
XFILLER_88_29 VGND VGND VPWR VPWR sky130_fd_sc_hd__decap_3
XFILLER_58_332 VGND VGND VPWR VPWR sky130_fd_sc_hd__decap_3
XFILLER_46_516 VGND VGND VPWR VPWR sky130_fd_sc_hd__decap_3
XFILLER_58_365 VGND VGND VPWR VPWR sky130_fd_sc_hd__decap_3
XFILLER_73_302 VGND VGND VPWR VPWR sky130_fd_sc_hd__decap_3
XTAP_TAPCELL_ROW_69_861 VGND VPWR sky130_fd_sc_hd__tapvpwrvgnd_1
XFILLER_37_55 VGND VGND VPWR VPWR sky130_fd_sc_hd__fill_1
XFILLER_37_66 VGND VGND VPWR VPWR sky130_fd_sc_hd__decap_3
XFILLER_46_549 VGND VGND VPWR VPWR sky130_fd_sc_hd__decap_3
XFILLER_85_195 VGND VGND VPWR VPWR sky130_fd_sc_hd__decap_3
XFILLER_61_508 VGND VGND VPWR VPWR sky130_fd_sc_hd__decap_3
XFILLER_14_424 VGND VGND VPWR VPWR sky130_fd_sc_hd__decap_3
XFILLER_53_43 VGND VGND VPWR VPWR sky130_fd_sc_hd__decap_3
XFILLER_14_457 VGND VGND VPWR VPWR sky130_fd_sc_hd__fill_2
XFILLER_41_243 VGND VGND VPWR VPWR sky130_fd_sc_hd__fill_2
XFILLER_53_76 VGND VGND VPWR VPWR sky130_fd_sc_hd__decap_3
XTAP_TAPCELL_ROW_24_430 VGND VPWR sky130_fd_sc_hd__tapvpwrvgnd_1
XFILLER_41_287 VGND VGND VPWR VPWR sky130_fd_sc_hd__decap_3
XFILLER_5_111 VGND VGND VPWR VPWR sky130_fd_sc_hd__fill_1
XFILLER_5_155 VGND VGND VPWR VPWR sky130_fd_sc_hd__decap_3
XFILLER_78_51 VGND VGND VPWR VPWR sky130_fd_sc_hd__fill_2
XFILLER_49_332 VGND VGND VPWR VPWR sky130_fd_sc_hd__decap_3
XFILLER_49_343 VGND VGND VPWR VPWR sky130_fd_sc_hd__decap_3
XFILLER_37_549 VGND VGND VPWR VPWR sky130_fd_sc_hd__decap_3
XFILLER_49_376 VGND VGND VPWR VPWR sky130_fd_sc_hd__decap_3
XFILLER_64_324 VGND VGND VPWR VPWR sky130_fd_sc_hd__decap_3
XFILLER_64_368 VGND VGND VPWR VPWR sky130_fd_sc_hd__decap_3
XFILLER_52_519 VGND VGND VPWR VPWR sky130_fd_sc_hd__decap_3
XFILLER_17_284 VGND VGND VPWR VPWR sky130_fd_sc_hd__decap_3
XFILLER_60_541 VGND VGND VPWR VPWR sky130_fd_sc_hd__decap_3
X_4870_ _5078_/CLK _4870_/D VGND VGND VPWR VPWR _4870_/Q sky130_fd_sc_hd__dfxtp_2
X_3821_ _4664_/S _4662_/B VGND VGND VPWR VPWR _4139_/A sky130_fd_sc_hd__or2_2
X_3752_ _3747_/X _3748_/X _3751_/X _2432_/Y VGND VGND VPWR VPWR _3911_/C sky130_fd_sc_hd__a22o_2
X_3683_ _4891_/Q _4875_/Q _5099_/Q _5083_/Q _5127_/Q _5128_/Q VGND VGND VPWR VPWR
+ _3684_/B sky130_fd_sc_hd__mux4_2
X_2703_ _4866_/A _2703_/B VGND VGND VPWR VPWR _5262_/D sky130_fd_sc_hd__nor2_2
XTAP_TAPCELL_ROW_30_488 VGND VPWR sky130_fd_sc_hd__tapvpwrvgnd_1
X_2634_ _5161_/Q _4468_/A VGND VGND VPWR VPWR _2652_/A sky130_fd_sc_hd__nand2_2
X_2565_ _5125_/Q _2565_/B VGND VGND VPWR VPWR _2565_/X sky130_fd_sc_hd__or2_2
X_4304_ _4115_/A _2883_/B _4311_/C _4293_/X VGND VGND VPWR VPWR _4304_/X sky130_fd_sc_hd__o22a_2
X_2496_ _5120_/Q _5008_/Q _4992_/Q _4976_/Q _5123_/Q _5124_/Q VGND VGND VPWR VPWR
+ _2496_/X sky130_fd_sc_hd__mux4_2
XFILLER_87_405 VGND VGND VPWR VPWR sky130_fd_sc_hd__decap_3
X_4235_ _4115_/A _2874_/B _4224_/X _4230_/X _4234_/X VGND VGND VPWR VPWR _4235_/X
+ sky130_fd_sc_hd__o2111a_2
XFILLER_87_449 VGND VGND VPWR VPWR sky130_fd_sc_hd__decap_3
XFILLER_87_438 VGND VGND VPWR VPWR sky130_fd_sc_hd__decap_3
XFILLER_28_505 VGND VGND VPWR VPWR sky130_fd_sc_hd__decap_3
XFILLER_67_151 VGND VGND VPWR VPWR sky130_fd_sc_hd__decap_3
X_4166_ _4224_/A _4164_/Y _4165_/X _3898_/B VGND VGND VPWR VPWR _4166_/X sky130_fd_sc_hd__o22a_2
XFILLER_28_527 VGND VGND VPWR VPWR sky130_fd_sc_hd__decap_3
XFILLER_55_324 VGND VGND VPWR VPWR sky130_fd_sc_hd__decap_3
X_3117_ _4866_/A _3117_/B VGND VGND VPWR VPWR _3117_/Y sky130_fd_sc_hd__nor2_2
XTAP_TAPCELL_ROW_66_831 VGND VPWR sky130_fd_sc_hd__tapvpwrvgnd_1
X_4097_ _4097_/A VGND VGND VPWR VPWR _4097_/Y sky130_fd_sc_hd__inv_2
XFILLER_55_379 VGND VGND VPWR VPWR sky130_fd_sc_hd__decap_3
XFILLER_70_305 VGND VGND VPWR VPWR sky130_fd_sc_hd__decap_3
XFILLER_70_327 VGND VGND VPWR VPWR sky130_fd_sc_hd__fill_1
X_3048_ _2910_/X _3056_/A2 _3043_/Y _4967_/Q VGND VGND VPWR VPWR _4967_/D sky130_fd_sc_hd__a22o_2
XTAP_TAPCELL_ROW_38_566 VGND VPWR sky130_fd_sc_hd__tapvpwrvgnd_1
XFILLER_82_154 VGND VGND VPWR VPWR sky130_fd_sc_hd__decap_3
XFILLER_51_552 VGND VGND VPWR VPWR sky130_fd_sc_hd__fill_1
XFILLER_23_287 VGND VGND VPWR VPWR sky130_fd_sc_hd__decap_3
XFILLER_23_35 VGND VGND VPWR VPWR sky130_fd_sc_hd__decap_3
X_4999_ _5111_/CLK _4999_/D VGND VGND VPWR VPWR _4999_/Q sky130_fd_sc_hd__dfxtp_2
XTAP_TAPCELL_ROW_21_400 VGND VPWR sky130_fd_sc_hd__tapvpwrvgnd_1
XFILLER_23_57 VGND VGND VPWR VPWR sky130_fd_sc_hd__decap_3
XFILLER_2_114 VGND VGND VPWR VPWR sky130_fd_sc_hd__fill_1
XFILLER_78_427 VGND VGND VPWR VPWR sky130_fd_sc_hd__fill_1
XFILLER_78_405 VGND VGND VPWR VPWR sky130_fd_sc_hd__decap_3
XFILLER_78_438 VGND VGND VPWR VPWR sky130_fd_sc_hd__decap_3
XFILLER_48_65 VGND VGND VPWR VPWR sky130_fd_sc_hd__decap_3
XFILLER_93_419 VGND VGND VPWR VPWR sky130_fd_sc_hd__fill_1
XFILLER_58_184 VGND VGND VPWR VPWR sky130_fd_sc_hd__decap_3
XFILLER_86_493 VGND VGND VPWR VPWR sky130_fd_sc_hd__decap_3
XFILLER_34_508 VGND VGND VPWR VPWR sky130_fd_sc_hd__decap_3
XFILLER_46_335 VGND VGND VPWR VPWR sky130_fd_sc_hd__decap_3
XFILLER_46_357 VGND VGND VPWR VPWR sky130_fd_sc_hd__decap_3
XFILLER_61_305 VGND VGND VPWR VPWR sky130_fd_sc_hd__decap_3
XFILLER_64_53 VGND VGND VPWR VPWR sky130_fd_sc_hd__decap_3
XFILLER_73_154 VGND VGND VPWR VPWR sky130_fd_sc_hd__decap_3
XFILLER_64_97 VGND VGND VPWR VPWR sky130_fd_sc_hd__decap_3
XFILLER_73_198 VGND VGND VPWR VPWR sky130_fd_sc_hd__decap_3
XFILLER_14_232 VGND VGND VPWR VPWR sky130_fd_sc_hd__decap_3
XFILLER_14_265 VGND VGND VPWR VPWR sky130_fd_sc_hd__decap_3
XTAP_TAPCELL_ROW_72_889 VGND VPWR sky130_fd_sc_hd__tapvpwrvgnd_1
XFILLER_80_41 VGND VGND VPWR VPWR sky130_fd_sc_hd__decap_3
XFILLER_80_85 VGND VGND VPWR VPWR sky130_fd_sc_hd__decap_3
XFILLER_6_453 VGND VGND VPWR VPWR sky130_fd_sc_hd__decap_3
XFILLER_89_83 VGND VGND VPWR VPWR sky130_fd_sc_hd__fill_1
XFILLER_69_405 VGND VGND VPWR VPWR sky130_fd_sc_hd__decap_3
XFILLER_69_438 VGND VGND VPWR VPWR sky130_fd_sc_hd__decap_3
XFILLER_69_449 VGND VGND VPWR VPWR sky130_fd_sc_hd__decap_3
XTAP_TAPCELL_ROW_9_291 VGND VPWR sky130_fd_sc_hd__tapvpwrvgnd_1
X_4020_ _5208_/Q _4850_/B VGND VGND VPWR VPWR _4020_/Y sky130_fd_sc_hd__nand2_2
XFILLER_77_493 VGND VGND VPWR VPWR sky130_fd_sc_hd__decap_3
XFILLER_37_346 VGND VGND VPWR VPWR sky130_fd_sc_hd__decap_3
XFILLER_64_121 VGND VGND VPWR VPWR sky130_fd_sc_hd__decap_3
XFILLER_64_176 VGND VGND VPWR VPWR sky130_fd_sc_hd__decap_3
XTAP_TAPCELL_ROW_63_801 VGND VPWR sky130_fd_sc_hd__tapvpwrvgnd_1
XFILLER_92_463 VGND VGND VPWR VPWR sky130_fd_sc_hd__decap_3
XFILLER_33_530 VGND VGND VPWR VPWR sky130_fd_sc_hd__decap_3
XFILLER_52_327 VGND VGND VPWR VPWR sky130_fd_sc_hd__decap_3
X_4922_ _5007_/CLK _4922_/D VGND VGND VPWR VPWR _4922_/Q sky130_fd_sc_hd__dfxtp_2
XTAP_TAPCELL_ROW_35_536 VGND VPWR sky130_fd_sc_hd__tapvpwrvgnd_1
X_4853_ _5256_/Q _4852_/X _3442_/B VGND VGND VPWR VPWR _4853_/X sky130_fd_sc_hd__o21a_2
X_4784_ _4318_/X _4778_/Y _4783_/X _4136_/Y VGND VGND VPWR VPWR _4784_/X sky130_fd_sc_hd__a31o_2
X_3804_ _4464_/A _3804_/B VGND VGND VPWR VPWR _4690_/S sky130_fd_sc_hd__nor2_2
X_3735_ _5072_/Q _5056_/Q _5040_/Q _5024_/Q _5127_/Q _5128_/Q VGND VGND VPWR VPWR
+ _3735_/X sky130_fd_sc_hd__mux4_2
X_3666_ _3665_/X _4173_/A VGND VGND VPWR VPWR _3666_/Y sky130_fd_sc_hd__nand2b_2
X_3597_ _3591_/X _3593_/X _3596_/X _2432_/Y VGND VGND VPWR VPWR _4397_/A sky130_fd_sc_hd__a22o_2
X_2617_ _2617_/A _2617_/B VGND VGND VPWR VPWR _3934_/C sky130_fd_sc_hd__and2_2
X_2548_ _5157_/Q _4466_/A VGND VGND VPWR VPWR _2617_/A sky130_fd_sc_hd__nand2_2
XFILLER_87_213 VGND VGND VPWR VPWR sky130_fd_sc_hd__decap_3
X_4218_ _4218_/A _4218_/B VGND VGND VPWR VPWR _4219_/B sky130_fd_sc_hd__xnor2_2
X_2479_ _2479_/A _2479_/B VGND VGND VPWR VPWR _4361_/A sky130_fd_sc_hd__and2_2
XFILLER_75_419 VGND VGND VPWR VPWR sky130_fd_sc_hd__decap_3
X_5198_ _5200_/CLK _5198_/D VGND VGND VPWR VPWR _5198_/Q sky130_fd_sc_hd__dfxtp_2
X_4149_ _4149_/A _4149_/B VGND VGND VPWR VPWR _4149_/X sky130_fd_sc_hd__xor2_2
XFILLER_83_452 VGND VGND VPWR VPWR sky130_fd_sc_hd__decap_3
XFILLER_18_79 VGND VGND VPWR VPWR sky130_fd_sc_hd__decap_3
XFILLER_28_379 VGND VGND VPWR VPWR sky130_fd_sc_hd__fill_2
XFILLER_43_305 VGND VGND VPWR VPWR sky130_fd_sc_hd__decap_3
XFILLER_43_327 VGND VGND VPWR VPWR sky130_fd_sc_hd__decap_3
XFILLER_24_541 VGND VGND VPWR VPWR sky130_fd_sc_hd__decap_3
XFILLER_34_78 VGND VGND VPWR VPWR sky130_fd_sc_hd__decap_3
XFILLER_51_360 VGND VGND VPWR VPWR sky130_fd_sc_hd__decap_3
XFILLER_70_179 VGND VGND VPWR VPWR sky130_fd_sc_hd__decap_3
XFILLER_51_393 VGND VGND VPWR VPWR sky130_fd_sc_hd__decap_3
XFILLER_11_279 VGND VGND VPWR VPWR sky130_fd_sc_hd__fill_1
Xclkload0 clkload0/A VGND VGND VPWR VPWR clkload0/Y sky130_fd_sc_hd__inv_6
XFILLER_50_44 VGND VGND VPWR VPWR sky130_fd_sc_hd__decap_3
XFILLER_59_42 VGND VGND VPWR VPWR sky130_fd_sc_hd__decap_3
XFILLER_3_489 VGND VGND VPWR VPWR sky130_fd_sc_hd__decap_3
XFILLER_59_75 VGND VGND VPWR VPWR sky130_fd_sc_hd__decap_3
XTAP_TAPCELL_ROW_6_261 VGND VPWR sky130_fd_sc_hd__tapvpwrvgnd_1
XFILLER_78_268 VGND VGND VPWR VPWR sky130_fd_sc_hd__decap_3
XFILLER_75_30 VGND VGND VPWR VPWR sky130_fd_sc_hd__decap_3
XTAP_TAPCELL_ROW_77_937 VGND VPWR sky130_fd_sc_hd__tapvpwrvgnd_1
XFILLER_19_324 VGND VGND VPWR VPWR sky130_fd_sc_hd__decap_3
XFILLER_19_346 VGND VGND VPWR VPWR sky130_fd_sc_hd__decap_3
XFILLER_46_132 VGND VGND VPWR VPWR sky130_fd_sc_hd__decap_3
XFILLER_75_52 VGND VGND VPWR VPWR sky130_fd_sc_hd__decap_3
XFILLER_75_96 VGND VGND VPWR VPWR sky130_fd_sc_hd__decap_3
XFILLER_15_530 VGND VGND VPWR VPWR sky130_fd_sc_hd__decap_3
XFILLER_34_327 VGND VGND VPWR VPWR sky130_fd_sc_hd__fill_2
XFILLER_34_349 VGND VGND VPWR VPWR sky130_fd_sc_hd__decap_3
XFILLER_61_113 VGND VGND VPWR VPWR sky130_fd_sc_hd__decap_3
XFILLER_15_541 VGND VGND VPWR VPWR sky130_fd_sc_hd__decap_3
XFILLER_30_511 VGND VGND VPWR VPWR sky130_fd_sc_hd__decap_3
XFILLER_42_360 VGND VGND VPWR VPWR sky130_fd_sc_hd__decap_3
XFILLER_42_371 VGND VGND VPWR VPWR sky130_fd_sc_hd__decap_3
XTAP_TAPCELL_ROW_32_506 VGND VPWR sky130_fd_sc_hd__tapvpwrvgnd_1
XFILLER_91_84 VGND VGND VPWR VPWR sky130_fd_sc_hd__fill_1
XFILLER_91_73 VGND VGND VPWR VPWR sky130_fd_sc_hd__decap_3
XFILLER_30_533 VGND VGND VPWR VPWR sky130_fd_sc_hd__decap_3
X_3520_ _5196_/Q _4800_/B _3585_/A _3519_/Y VGND VGND VPWR VPWR _3521_/B sky130_fd_sc_hd__o2bb2a_2
XTAP_TAPCELL_ROW_40_583 VGND VPWR sky130_fd_sc_hd__tapvpwrvgnd_1
X_3451_ _5183_/Q _3227_/X _3450_/X VGND VGND VPWR VPWR _3452_/B sky130_fd_sc_hd__a21oi_2
X_3382_ _3392_/B _3381_/Y _3337_/A VGND VGND VPWR VPWR _3382_/Y sky130_fd_sc_hd__o21ai_2
XFILLER_69_235 VGND VGND VPWR VPWR sky130_fd_sc_hd__fill_2
X_5121_ _5121_/CLK _5121_/D VGND VGND VPWR VPWR _5121_/Q sky130_fd_sc_hd__dfxtp_2
XFILLER_57_408 VGND VGND VPWR VPWR sky130_fd_sc_hd__decap_3
XFILLER_69_268 VGND VGND VPWR VPWR sky130_fd_sc_hd__decap_3
X_5052_ _5063_/CLK _5052_/D VGND VGND VPWR VPWR _5052_/Q sky130_fd_sc_hd__dfxtp_2
XFILLER_84_216 VGND VGND VPWR VPWR sky130_fd_sc_hd__decap_3
XFILLER_37_110 VGND VGND VPWR VPWR sky130_fd_sc_hd__fill_2
X_4003_ _4003_/A _4003_/B VGND VGND VPWR VPWR _4632_/A sky130_fd_sc_hd__or2_2
XFILLER_77_290 VGND VGND VPWR VPWR sky130_fd_sc_hd__decap_3
XFILLER_25_316 VGND VGND VPWR VPWR sky130_fd_sc_hd__fill_1
XTAP_TAPCELL_ROW_48_661 VGND VPWR sky130_fd_sc_hd__tapvpwrvgnd_1
XPHY_EDGE_ROW_9_Left_103 VGND VGND VPWR VPWR sky130_fd_sc_hd__decap_3
XFILLER_80_400 VGND VGND VPWR VPWR sky130_fd_sc_hd__decap_3
XFILLER_92_271 VGND VGND VPWR VPWR sky130_fd_sc_hd__decap_3
XFILLER_18_390 VGND VGND VPWR VPWR sky130_fd_sc_hd__decap_3
XFILLER_52_168 VGND VGND VPWR VPWR sky130_fd_sc_hd__decap_3
XFILLER_80_477 VGND VGND VPWR VPWR sky130_fd_sc_hd__decap_3
XFILLER_80_455 VGND VGND VPWR VPWR sky130_fd_sc_hd__decap_3
XFILLER_21_500 VGND VGND VPWR VPWR sky130_fd_sc_hd__decap_3
XFILLER_21_511 VGND VGND VPWR VPWR sky130_fd_sc_hd__fill_1
X_4905_ clkload9/A _4905_/D VGND VGND VPWR VPWR _4905_/Q sky130_fd_sc_hd__dfxtp_2
XFILLER_21_544 VGND VGND VPWR VPWR sky130_fd_sc_hd__decap_3
XFILLER_33_393 VGND VGND VPWR VPWR sky130_fd_sc_hd__fill_1
X_4836_ input48/X _4816_/Y _4835_/X _3442_/B VGND VGND VPWR VPWR _5247_/D sky130_fd_sc_hd__o211a_2
X_4767_ _4292_/A _4224_/A _4246_/A _4291_/A _4766_/X VGND VGND VPWR VPWR _4767_/X
+ sky130_fd_sc_hd__o221a_2
X_4698_ _3873_/B _4224_/A _4635_/Y _4695_/Y VGND VGND VPWR VPWR _4699_/D sky130_fd_sc_hd__o22a_2
X_3718_ _5069_/Q _5053_/Q _5037_/Q _5021_/Q _3834_/S0 _3834_/S1 VGND VGND VPWR VPWR
+ _3718_/X sky130_fd_sc_hd__mux4_2
XFILLER_20_58 VGND VGND VPWR VPWR sky130_fd_sc_hd__decap_3
X_3649_ _4464_/B _4787_/S _3648_/Y VGND VGND VPWR VPWR _3649_/Y sky130_fd_sc_hd__o21ai_2
XTAP_TAPCELL_ROW_93_1092 VGND VPWR sky130_fd_sc_hd__tapvpwrvgnd_1
XTAP_TAPCELL_ROW_93_1081 VGND VPWR sky130_fd_sc_hd__tapvpwrvgnd_1
XFILLER_88_544 VGND VGND VPWR VPWR sky130_fd_sc_hd__decap_3
XFILLER_88_522 VGND VGND VPWR VPWR sky130_fd_sc_hd__decap_3
XFILLER_48_419 VGND VGND VPWR VPWR sky130_fd_sc_hd__fill_1
XFILLER_28_132 VGND VGND VPWR VPWR sky130_fd_sc_hd__decap_3
XFILLER_68_290 VGND VGND VPWR VPWR sky130_fd_sc_hd__decap_3
XFILLER_75_249 VGND VGND VPWR VPWR sky130_fd_sc_hd__decap_3
XTAP_TAPCELL_ROW_74_907 VGND VPWR sky130_fd_sc_hd__tapvpwrvgnd_1
XTAP_TAPCELL_ROW_3_231 VGND VPWR sky130_fd_sc_hd__tapvpwrvgnd_1
XFILLER_16_305 VGND VGND VPWR VPWR sky130_fd_sc_hd__decap_3
XFILLER_45_11 VGND VGND VPWR VPWR sky130_fd_sc_hd__decap_3
XFILLER_56_452 VGND VGND VPWR VPWR sky130_fd_sc_hd__fill_2
XFILLER_43_113 VGND VGND VPWR VPWR sky130_fd_sc_hd__fill_1
XFILLER_45_44 VGND VGND VPWR VPWR sky130_fd_sc_hd__fill_2
XFILLER_71_411 VGND VGND VPWR VPWR sky130_fd_sc_hd__decap_3
XFILLER_45_99 VGND VGND VPWR VPWR sky130_fd_sc_hd__decap_3
XFILLER_71_444 VGND VGND VPWR VPWR sky130_fd_sc_hd__decap_3
XFILLER_12_500 VGND VGND VPWR VPWR sky130_fd_sc_hd__decap_3
XFILLER_24_371 VGND VGND VPWR VPWR sky130_fd_sc_hd__decap_3
XTAP_TAPCELL_ROW_82_984 VGND VPWR sky130_fd_sc_hd__tapvpwrvgnd_1
XFILLER_12_544 VGND VGND VPWR VPWR sky130_fd_sc_hd__decap_3
XFILLER_8_548 VGND VGND VPWR VPWR sky130_fd_sc_hd__decap_3
XFILLER_6_49 VGND VGND VPWR VPWR sky130_fd_sc_hd__fill_2
XFILLER_39_408 VGND VGND VPWR VPWR sky130_fd_sc_hd__decap_3
XFILLER_66_205 VGND VGND VPWR VPWR sky130_fd_sc_hd__decap_3
XFILLER_66_238 VGND VGND VPWR VPWR sky130_fd_sc_hd__decap_3
XFILLER_19_165 VGND VGND VPWR VPWR sky130_fd_sc_hd__decap_3
XFILLER_47_452 VGND VGND VPWR VPWR sky130_fd_sc_hd__decap_3
XFILLER_34_124 VGND VGND VPWR VPWR sky130_fd_sc_hd__decap_3
XFILLER_62_444 VGND VGND VPWR VPWR sky130_fd_sc_hd__fill_2
XFILLER_62_466 VGND VGND VPWR VPWR sky130_fd_sc_hd__decap_3
XTAP_TAPCELL_ROW_45_631 VGND VPWR sky130_fd_sc_hd__tapvpwrvgnd_1
XFILLER_62_488 VGND VGND VPWR VPWR sky130_fd_sc_hd__fill_1
X_2951_ _2903_/X _2961_/A2 _2961_/B1 _4885_/Q VGND VGND VPWR VPWR _4885_/D sky130_fd_sc_hd__a22o_2
XTAP_TAPCELL_ROW_17_366 VGND VPWR sky130_fd_sc_hd__tapvpwrvgnd_1
XFILLER_15_382 VGND VGND VPWR VPWR sky130_fd_sc_hd__fill_1
XFILLER_15_393 VGND VGND VPWR VPWR sky130_fd_sc_hd__decap_3
XFILLER_30_363 VGND VGND VPWR VPWR sky130_fd_sc_hd__fill_1
X_4621_ _4621_/A VGND VGND VPWR VPWR _4621_/Y sky130_fd_sc_hd__inv_2
X_2882_ _2882_/A _2882_/B VGND VGND VPWR VPWR _2883_/B sky130_fd_sc_hd__nand2_2
XFILLER_89_3 VGND VGND VPWR VPWR sky130_fd_sc_hd__fill_2
XFILLER_30_385 VGND VGND VPWR VPWR sky130_fd_sc_hd__decap_3
X_4552_ _4449_/B _4445_/B _4493_/A _4067_/A VGND VGND VPWR VPWR _4552_/X sky130_fd_sc_hd__o211a_2
X_4483_ _4333_/B _2853_/B _3678_/X _2855_/A _4482_/X VGND VGND VPWR VPWR _4483_/Y
+ sky130_fd_sc_hd__a221oi_2
X_3503_ _3503_/A _3503_/B VGND VGND VPWR VPWR _3503_/Y sky130_fd_sc_hd__xnor2_2
X_3434_ _5260_/Q _3442_/B input3/X VGND VGND VPWR VPWR _3434_/X sky130_fd_sc_hd__and3_2
XFILLER_89_319 VGND VGND VPWR VPWR sky130_fd_sc_hd__decap_3
X_3365_ _5164_/Q _3366_/B VGND VGND VPWR VPWR _3378_/A sky130_fd_sc_hd__and2_2
XFILLER_57_216 VGND VGND VPWR VPWR sky130_fd_sc_hd__fill_1
X_5104_ _5134_/CLK _5104_/D VGND VGND VPWR VPWR _5104_/Q sky130_fd_sc_hd__dfxtp_2
X_3296_ _3293_/Y _3294_/X _3295_/X VGND VGND VPWR VPWR _3296_/X sky130_fd_sc_hd__a21bo_2
XFILLER_85_514 VGND VGND VPWR VPWR sky130_fd_sc_hd__decap_3
XFILLER_57_238 VGND VGND VPWR VPWR sky130_fd_sc_hd__decap_3
X_5035_ _5106_/CLK _5035_/D VGND VGND VPWR VPWR _5035_/Q sky130_fd_sc_hd__dfxtp_2
XFILLER_85_547 VGND VGND VPWR VPWR sky130_fd_sc_hd__decap_3
XFILLER_38_463 VGND VGND VPWR VPWR sky130_fd_sc_hd__decap_3
XFILLER_72_208 VGND VGND VPWR VPWR sky130_fd_sc_hd__decap_3
XTAP_TAPCELL_ROW_0_201 VGND VPWR sky130_fd_sc_hd__tapvpwrvgnd_1
XFILLER_65_293 VGND VGND VPWR VPWR sky130_fd_sc_hd__fill_2
XTAP_TAPCELL_ROW_84_1003 VGND VPWR sky130_fd_sc_hd__tapvpwrvgnd_1
XFILLER_53_455 VGND VGND VPWR VPWR sky130_fd_sc_hd__decap_3
XFILLER_53_488 VGND VGND VPWR VPWR sky130_fd_sc_hd__decap_3
XTAP_TAPCELL_ROW_51_689 VGND VPWR sky130_fd_sc_hd__tapvpwrvgnd_1
XFILLER_21_396 VGND VGND VPWR VPWR sky130_fd_sc_hd__fill_2
X_4819_ _5239_/Q _4847_/B VGND VGND VPWR VPWR _4819_/X sky130_fd_sc_hd__or2_2
XFILLER_31_57 VGND VGND VPWR VPWR sky130_fd_sc_hd__decap_3
XFILLER_0_212 VGND VGND VPWR VPWR sky130_fd_sc_hd__fill_1
Xoutput57 _5144_/Q VGND VGND VPWR VPWR INSTR_ADDR[11] sky130_fd_sc_hd__clkdlybuf4s25_1
XFILLER_0_234 VGND VGND VPWR VPWR sky130_fd_sc_hd__decap_3
Xoutput68 _5140_/Q VGND VGND VPWR VPWR INSTR_ADDR[7] sky130_fd_sc_hd__clkdlybuf4s25_1
Xoutput79 _2883_/Y VGND VGND VPWR VPWR MEM_ADDR[12] sky130_fd_sc_hd__clkdlybuf4s25_1
XFILLER_0_256 VGND VGND VPWR VPWR sky130_fd_sc_hd__decap_3
XFILLER_88_363 VGND VGND VPWR VPWR sky130_fd_sc_hd__fill_1
XFILLER_56_32 VGND VGND VPWR VPWR sky130_fd_sc_hd__decap_3
XFILLER_29_452 VGND VGND VPWR VPWR sky130_fd_sc_hd__decap_3
XFILLER_56_65 VGND VGND VPWR VPWR sky130_fd_sc_hd__decap_3
XFILLER_63_208 VGND VGND VPWR VPWR sky130_fd_sc_hd__decap_3
XFILLER_29_474 VGND VGND VPWR VPWR sky130_fd_sc_hd__decap_3
XFILLER_56_271 VGND VGND VPWR VPWR sky130_fd_sc_hd__decap_3
XPHY_EDGE_ROW_19_Right_19 VGND VGND VPWR VPWR sky130_fd_sc_hd__decap_3
XFILLER_44_477 VGND VGND VPWR VPWR sky130_fd_sc_hd__fill_2
XTAP_TAPCELL_ROW_42_601 VGND VPWR sky130_fd_sc_hd__tapvpwrvgnd_1
XTAP_TAPCELL_ROW_14_336 VGND VPWR sky130_fd_sc_hd__tapvpwrvgnd_1
XFILLER_12_341 VGND VGND VPWR VPWR sky130_fd_sc_hd__decap_3
XFILLER_72_97 VGND VGND VPWR VPWR sky130_fd_sc_hd__decap_3
XFILLER_75_9 VGND VGND VPWR VPWR sky130_fd_sc_hd__decap_3
XFILLER_8_356 VGND VGND VPWR VPWR sky130_fd_sc_hd__decap_3
XPHY_EDGE_ROW_28_Right_28 VGND VGND VPWR VPWR sky130_fd_sc_hd__decap_3
XFILLER_67_503 VGND VGND VPWR VPWR sky130_fd_sc_hd__fill_1
XFILLER_67_514 VGND VGND VPWR VPWR sky130_fd_sc_hd__decap_3
X_3150_ _2938_/X _3136_/B _3136_/Y _5056_/Q VGND VGND VPWR VPWR _5056_/D sky130_fd_sc_hd__a22o_2
XFILLER_79_374 VGND VGND VPWR VPWR sky130_fd_sc_hd__decap_3
XFILLER_67_547 VGND VGND VPWR VPWR sky130_fd_sc_hd__decap_3
X_3081_ _2891_/X _3093_/A2 _3096_/B1 _4995_/Q VGND VGND VPWR VPWR _4995_/D sky130_fd_sc_hd__a22o_2
XFILLER_47_260 VGND VGND VPWR VPWR sky130_fd_sc_hd__decap_3
XPHY_EDGE_ROW_37_Right_37 VGND VGND VPWR VPWR sky130_fd_sc_hd__decap_3
XFILLER_82_528 VGND VGND VPWR VPWR sky130_fd_sc_hd__decap_3
XFILLER_35_455 VGND VGND VPWR VPWR sky130_fd_sc_hd__decap_3
XFILLER_90_550 VGND VGND VPWR VPWR sky130_fd_sc_hd__decap_3
XFILLER_22_105 VGND VGND VPWR VPWR sky130_fd_sc_hd__fill_2
XFILLER_35_477 VGND VGND VPWR VPWR sky130_fd_sc_hd__decap_3
XFILLER_50_414 VGND VGND VPWR VPWR sky130_fd_sc_hd__decap_3
XFILLER_22_138 VGND VGND VPWR VPWR sky130_fd_sc_hd__fill_2
XFILLER_50_436 VGND VGND VPWR VPWR sky130_fd_sc_hd__decap_3
XFILLER_62_285 VGND VGND VPWR VPWR sky130_fd_sc_hd__fill_1
X_3983_ _4340_/A _3983_/B VGND VGND VPWR VPWR _3984_/B sky130_fd_sc_hd__nor2_2
X_2934_ _5234_/Q _4850_/A _3458_/B _5218_/Q VGND VGND VPWR VPWR _2934_/X sky130_fd_sc_hd__a22o_2
X_2865_ _2865_/A _4164_/A VGND VGND VPWR VPWR _2866_/B sky130_fd_sc_hd__xnor2_2
X_4604_ _4571_/Y _4573_/Y _4603_/Y _4632_/A VGND VGND VPWR VPWR _4604_/X sky130_fd_sc_hd__a31o_2
XPHY_EDGE_ROW_46_Right_46 VGND VGND VPWR VPWR sky130_fd_sc_hd__decap_3
X_4535_ _4542_/S _4535_/B VGND VGND VPWR VPWR _4535_/Y sky130_fd_sc_hd__nor2_2
X_2796_ _2790_/X _2792_/X _2795_/X _2437_/Y VGND VGND VPWR VPWR _3332_/B sky130_fd_sc_hd__a22o_2
X_4466_ _4466_/A _4466_/B VGND VGND VPWR VPWR _4589_/B sky130_fd_sc_hd__or2_2
XFILLER_89_116 VGND VGND VPWR VPWR sky130_fd_sc_hd__fill_1
X_4397_ _4397_/A _4397_/B VGND VGND VPWR VPWR _4535_/B sky130_fd_sc_hd__nor2_2
X_3417_ _5155_/Q _3252_/C _3228_/Y _3416_/X VGND VGND VPWR VPWR _5155_/D sky130_fd_sc_hd__o22a_2
X_3348_ _5142_/Q _3347_/C _5143_/Q VGND VGND VPWR VPWR _3348_/Y sky130_fd_sc_hd__a21oi_2
XFILLER_58_536 VGND VGND VPWR VPWR sky130_fd_sc_hd__decap_3
XFILLER_73_517 VGND VGND VPWR VPWR sky130_fd_sc_hd__fill_1
X_3279_ _5156_/Q _3280_/B VGND VGND VPWR VPWR _3294_/A sky130_fd_sc_hd__and2_2
XPHY_EDGE_ROW_55_Right_55 VGND VGND VPWR VPWR sky130_fd_sc_hd__decap_3
X_5018_ _5085_/CLK _5018_/D VGND VGND VPWR VPWR _5018_/Q sky130_fd_sc_hd__dfxtp_2
XTAP_TAPCELL_ROW_56_737 VGND VPWR sky130_fd_sc_hd__tapvpwrvgnd_1
XFILLER_41_414 VGND VGND VPWR VPWR sky130_fd_sc_hd__decap_3
XFILLER_53_252 VGND VGND VPWR VPWR sky130_fd_sc_hd__decap_3
XFILLER_41_447 VGND VGND VPWR VPWR sky130_fd_sc_hd__fill_1
XFILLER_9_109 VGND VGND VPWR VPWR sky130_fd_sc_hd__decap_3
XTAP_TAPCELL_ROW_11_306 VGND VPWR sky130_fd_sc_hd__tapvpwrvgnd_1
XPHY_EDGE_ROW_64_Right_64 VGND VGND VPWR VPWR sky130_fd_sc_hd__decap_3
XFILLER_21_193 VGND VGND VPWR VPWR sky130_fd_sc_hd__fill_1
XFILLER_5_304 VGND VGND VPWR VPWR sky130_fd_sc_hd__fill_1
XFILLER_5_337 VGND VGND VPWR VPWR sky130_fd_sc_hd__decap_3
XFILLER_1_532 VGND VGND VPWR VPWR sky130_fd_sc_hd__fill_1
XPHY_EDGE_ROW_73_Right_73 VGND VGND VPWR VPWR sky130_fd_sc_hd__decap_3
XFILLER_88_193 VGND VGND VPWR VPWR sky130_fd_sc_hd__decap_3
XFILLER_76_377 VGND VGND VPWR VPWR sky130_fd_sc_hd__decap_3
XFILLER_76_355 VGND VGND VPWR VPWR sky130_fd_sc_hd__decap_3
XFILLER_64_539 VGND VGND VPWR VPWR sky130_fd_sc_hd__decap_3
XFILLER_17_455 VGND VGND VPWR VPWR sky130_fd_sc_hd__decap_3
XFILLER_17_477 VGND VGND VPWR VPWR sky130_fd_sc_hd__decap_3
XTAP_TAPCELL_ROW_27_461 VGND VPWR sky130_fd_sc_hd__tapvpwrvgnd_1
XFILLER_83_85 VGND VGND VPWR VPWR sky130_fd_sc_hd__decap_3
XFILLER_32_458 VGND VGND VPWR VPWR sky130_fd_sc_hd__decap_3
XPHY_EDGE_ROW_82_Right_82 VGND VGND VPWR VPWR sky130_fd_sc_hd__decap_3
XFILLER_40_480 VGND VGND VPWR VPWR sky130_fd_sc_hd__decap_3
XFILLER_12_182 VGND VGND VPWR VPWR sky130_fd_sc_hd__decap_3
XFILLER_73_6 VGND VGND VPWR VPWR sky130_fd_sc_hd__fill_2
X_2650_ _5160_/Q _4477_/A VGND VGND VPWR VPWR _4702_/S sky130_fd_sc_hd__nor2_2
XFILLER_8_197 VGND VGND VPWR VPWR sky130_fd_sc_hd__decap_3
X_2581_ _2575_/X _2577_/X _2580_/X _2435_/Y VGND VGND VPWR VPWR _4067_/A sky130_fd_sc_hd__a22oi_2
X_4320_ _4346_/A _4320_/B VGND VGND VPWR VPWR _4320_/X sky130_fd_sc_hd__or2_2
X_4251_ _4250_/X _4202_/X _4340_/A VGND VGND VPWR VPWR _4339_/B sky130_fd_sc_hd__mux2_1
X_3202_ _2932_/X _3203_/A2 _3203_/B1 _5102_/Q VGND VGND VPWR VPWR _5102_/D sky130_fd_sc_hd__a22o_2
XPHY_EDGE_ROW_91_Right_91 VGND VGND VPWR VPWR sky130_fd_sc_hd__decap_3
XFILLER_67_311 VGND VGND VPWR VPWR sky130_fd_sc_hd__decap_3
X_4182_ _3805_/A _4371_/B _4632_/A _2623_/A VGND VGND VPWR VPWR _4182_/Y sky130_fd_sc_hd__o22ai_2
XFILLER_79_182 VGND VGND VPWR VPWR sky130_fd_sc_hd__decap_3
X_3133_ _2944_/X _3117_/B _3133_/B1 _5042_/Q VGND VGND VPWR VPWR _5042_/D sky130_fd_sc_hd__a22o_2
XFILLER_67_399 VGND VGND VPWR VPWR sky130_fd_sc_hd__decap_3
X_3064_ _2903_/X _3074_/A2 _3061_/Y _4981_/Q VGND VGND VPWR VPWR _4981_/D sky130_fd_sc_hd__a22o_2
XFILLER_82_336 VGND VGND VPWR VPWR sky130_fd_sc_hd__decap_3
XFILLER_23_403 VGND VGND VPWR VPWR sky130_fd_sc_hd__fill_1
XFILLER_50_200 VGND VGND VPWR VPWR sky130_fd_sc_hd__fill_1
XFILLER_63_550 VGND VGND VPWR VPWR sky130_fd_sc_hd__decap_3
XTAP_TAPCELL_ROW_53_707 VGND VPWR sky130_fd_sc_hd__tapvpwrvgnd_1
XFILLER_23_436 VGND VGND VPWR VPWR sky130_fd_sc_hd__decap_3
XFILLER_35_296 VGND VGND VPWR VPWR sky130_fd_sc_hd__decap_3
XFILLER_50_233 VGND VGND VPWR VPWR sky130_fd_sc_hd__decap_3
XFILLER_23_458 VGND VGND VPWR VPWR sky130_fd_sc_hd__fill_1
X_3966_ _4067_/A _4787_/S VGND VGND VPWR VPWR _3966_/Y sky130_fd_sc_hd__nand2_2
XFILLER_50_288 VGND VGND VPWR VPWR sky130_fd_sc_hd__fill_2
X_2917_ _4873_/Q _2936_/A2 _2916_/X _2936_/B2 VGND VGND VPWR VPWR _4873_/D sky130_fd_sc_hd__a22o_2
XTAP_TAPCELL_ROW_61_784 VGND VPWR sky130_fd_sc_hd__tapvpwrvgnd_1
XFILLER_12_26 VGND VGND VPWR VPWR sky130_fd_sc_hd__fill_2
X_3897_ _3900_/B _3896_/Y _4149_/A VGND VGND VPWR VPWR _3898_/B sky130_fd_sc_hd__a21oi_2
XFILLER_12_48 VGND VGND VPWR VPWR sky130_fd_sc_hd__fill_1
X_2848_ _4962_/Q _4946_/Q _4930_/Q _4914_/Q _5131_/Q _2848_/S1 VGND VGND VPWR VPWR
+ _2848_/X sky130_fd_sc_hd__mux4_2
X_2779_ _2851_/A _3312_/B VGND VGND VPWR VPWR _2779_/X sky130_fd_sc_hd__and2_2
XFILLER_2_307 VGND VGND VPWR VPWR sky130_fd_sc_hd__fill_1
X_4518_ _4517_/X _4364_/Y _4624_/A VGND VGND VPWR VPWR _4654_/A sky130_fd_sc_hd__mux2_1
X_4449_ _4449_/A _4449_/B VGND VGND VPWR VPWR _4493_/C sky130_fd_sc_hd__nand2_2
XFILLER_77_119 VGND VGND VPWR VPWR sky130_fd_sc_hd__decap_3
XFILLER_58_344 VGND VGND VPWR VPWR sky130_fd_sc_hd__decap_3
XFILLER_18_208 VGND VGND VPWR VPWR sky130_fd_sc_hd__fill_1
XFILLER_58_377 VGND VGND VPWR VPWR sky130_fd_sc_hd__decap_3
XFILLER_73_314 VGND VGND VPWR VPWR sky130_fd_sc_hd__decap_3
XFILLER_85_163 VGND VGND VPWR VPWR sky130_fd_sc_hd__decap_3
XFILLER_26_230 VGND VGND VPWR VPWR sky130_fd_sc_hd__decap_3
XFILLER_53_55 VGND VGND VPWR VPWR sky130_fd_sc_hd__fill_1
XTAP_TAPCELL_ROW_24_431 VGND VPWR sky130_fd_sc_hd__tapvpwrvgnd_1
XFILLER_22_480 VGND VGND VPWR VPWR sky130_fd_sc_hd__decap_3
XFILLER_5_167 VGND VGND VPWR VPWR sky130_fd_sc_hd__fill_1
XFILLER_78_85 VGND VGND VPWR VPWR sky130_fd_sc_hd__decap_3
XFILLER_49_311 VGND VGND VPWR VPWR sky130_fd_sc_hd__decap_3
Xclkbuf_leaf_10_CLK clkload0/A VGND VGND VPWR VPWR _5263_/CLK sky130_fd_sc_hd__clkbuf_8
XFILLER_49_355 VGND VGND VPWR VPWR sky130_fd_sc_hd__decap_3
XFILLER_76_141 VGND VGND VPWR VPWR sky130_fd_sc_hd__decap_3
XFILLER_76_130 VGND VGND VPWR VPWR sky130_fd_sc_hd__fill_2
XFILLER_37_517 VGND VGND VPWR VPWR sky130_fd_sc_hd__decap_3
XFILLER_49_388 VGND VGND VPWR VPWR sky130_fd_sc_hd__decap_3
XFILLER_49_399 VGND VGND VPWR VPWR sky130_fd_sc_hd__decap_3
XFILLER_91_111 VGND VGND VPWR VPWR sky130_fd_sc_hd__fill_1
XFILLER_64_336 VGND VGND VPWR VPWR sky130_fd_sc_hd__decap_3
XFILLER_17_263 VGND VGND VPWR VPWR sky130_fd_sc_hd__decap_3
XFILLER_17_274 VGND VGND VPWR VPWR sky130_fd_sc_hd__decap_3
X_3820_ _4466_/A _3820_/B VGND VGND VPWR VPWR _4662_/B sky130_fd_sc_hd__and2_2
XFILLER_20_417 VGND VGND VPWR VPWR sky130_fd_sc_hd__decap_3
X_3751_ _3749_/X _3750_/X _3831_/A VGND VGND VPWR VPWR _3751_/X sky130_fd_sc_hd__mux2_1
X_2702_ _2887_/B _4168_/A _5259_/Q VGND VGND VPWR VPWR _2703_/B sky130_fd_sc_hd__a21oi_2
XFILLER_9_440 VGND VGND VPWR VPWR sky130_fd_sc_hd__decap_3
X_3682_ _3682_/A _3682_/B _3922_/A _3682_/D VGND VGND VPWR VPWR _3682_/Y sky130_fd_sc_hd__nor4_2
XTAP_TAPCELL_ROW_30_489 VGND VPWR sky130_fd_sc_hd__tapvpwrvgnd_1
XFILLER_9_484 VGND VGND VPWR VPWR sky130_fd_sc_hd__decap_3
X_2633_ _4468_/A VGND VGND VPWR VPWR _4249_/A sky130_fd_sc_hd__inv_2
X_2564_ _4886_/Q _4870_/Q _5094_/Q _5078_/Q _2658_/S0 _2671_/S1 VGND VGND VPWR VPWR
+ _2565_/B sky130_fd_sc_hd__mux4_2
X_4303_ _4246_/A _4290_/X _4291_/Y _4298_/X _4302_/Y VGND VGND VPWR VPWR _4303_/X
+ sky130_fd_sc_hd__o311a_2
XFILLER_59_108 VGND VGND VPWR VPWR sky130_fd_sc_hd__decap_3
X_2495_ _2667_/A _2494_/X _5126_/Q VGND VGND VPWR VPWR _2495_/X sky130_fd_sc_hd__o21a_2
XFILLER_87_417 VGND VGND VPWR VPWR sky130_fd_sc_hd__decap_3
X_4234_ _4255_/A _3959_/X _4231_/Y _4232_/X _4233_/X VGND VGND VPWR VPWR _4234_/X
+ sky130_fd_sc_hd__o2111a_2
X_4165_ _4149_/A _3900_/B _3896_/Y _4246_/A VGND VGND VPWR VPWR _4165_/X sky130_fd_sc_hd__a31o_2
XFILLER_28_517 VGND VGND VPWR VPWR sky130_fd_sc_hd__decap_3
XFILLER_55_303 VGND VGND VPWR VPWR sky130_fd_sc_hd__decap_3
X_3116_ _3189_/B _3134_/B VGND VGND VPWR VPWR _3116_/Y sky130_fd_sc_hd__nor2_2
XFILLER_82_100 VGND VGND VPWR VPWR sky130_fd_sc_hd__decap_3
X_4096_ _3934_/B _4493_/A _4523_/S VGND VGND VPWR VPWR _4097_/A sky130_fd_sc_hd__mux2_1
XTAP_TAPCELL_ROW_66_832 VGND VPWR sky130_fd_sc_hd__tapvpwrvgnd_1
XFILLER_82_144 VGND VGND VPWR VPWR sky130_fd_sc_hd__fill_2
XFILLER_82_133 VGND VGND VPWR VPWR sky130_fd_sc_hd__decap_3
X_3047_ _2906_/X _3056_/A2 _3043_/Y _4966_/Q VGND VGND VPWR VPWR _4966_/D sky130_fd_sc_hd__a22o_2
XTAP_TAPCELL_ROW_38_567 VGND VPWR sky130_fd_sc_hd__tapvpwrvgnd_1
XFILLER_82_166 VGND VGND VPWR VPWR sky130_fd_sc_hd__decap_3
XFILLER_70_339 VGND VGND VPWR VPWR sky130_fd_sc_hd__decap_3
XFILLER_11_428 VGND VGND VPWR VPWR sky130_fd_sc_hd__decap_3
XFILLER_23_277 VGND VGND VPWR VPWR sky130_fd_sc_hd__decap_3
X_4998_ _5112_/CLK _4998_/D VGND VGND VPWR VPWR _4998_/Q sky130_fd_sc_hd__dfxtp_2
XTAP_TAPCELL_ROW_21_401 VGND VPWR sky130_fd_sc_hd__tapvpwrvgnd_1
X_3949_ _3876_/B _4312_/B _4361_/B _4361_/A _3948_/X VGND VGND VPWR VPWR _4022_/B
+ sky130_fd_sc_hd__o221a_2
XFILLER_3_6 VGND VGND VPWR VPWR sky130_fd_sc_hd__decap_3
XFILLER_78_417 VGND VGND VPWR VPWR sky130_fd_sc_hd__decap_3
XFILLER_48_44 VGND VGND VPWR VPWR sky130_fd_sc_hd__decap_3
XFILLER_58_141 VGND VGND VPWR VPWR sky130_fd_sc_hd__fill_2
XFILLER_48_88 VGND VGND VPWR VPWR sky130_fd_sc_hd__fill_1
XFILLER_58_152 VGND VGND VPWR VPWR sky130_fd_sc_hd__decap_3
XPHY_EDGE_ROW_45_Left_139 VGND VGND VPWR VPWR sky130_fd_sc_hd__decap_3
XFILLER_73_122 VGND VGND VPWR VPWR sky130_fd_sc_hd__decap_3
XFILLER_61_317 VGND VGND VPWR VPWR sky130_fd_sc_hd__fill_2
XFILLER_64_32 VGND VGND VPWR VPWR sky130_fd_sc_hd__decap_3
XFILLER_73_166 VGND VGND VPWR VPWR sky130_fd_sc_hd__fill_2
XFILLER_73_177 VGND VGND VPWR VPWR sky130_fd_sc_hd__decap_3
XFILLER_54_391 VGND VGND VPWR VPWR sky130_fd_sc_hd__decap_3
XFILLER_64_65 VGND VGND VPWR VPWR sky130_fd_sc_hd__decap_3
XFILLER_42_542 VGND VGND VPWR VPWR sky130_fd_sc_hd__decap_3
XPHY_EDGE_ROW_54_Left_148 VGND VGND VPWR VPWR sky130_fd_sc_hd__decap_3
XFILLER_6_410 VGND VGND VPWR VPWR sky130_fd_sc_hd__fill_2
XFILLER_6_421 VGND VGND VPWR VPWR sky130_fd_sc_hd__decap_3
XFILLER_89_51 VGND VGND VPWR VPWR sky130_fd_sc_hd__decap_3
XPHY_EDGE_ROW_63_Left_157 VGND VGND VPWR VPWR sky130_fd_sc_hd__decap_3
XFILLER_49_130 VGND VGND VPWR VPWR sky130_fd_sc_hd__decap_3
XFILLER_64_100 VGND VGND VPWR VPWR sky130_fd_sc_hd__decap_3
XFILLER_77_461 VGND VGND VPWR VPWR sky130_fd_sc_hd__decap_3
XFILLER_37_325 VGND VGND VPWR VPWR sky130_fd_sc_hd__decap_3
XFILLER_37_358 VGND VGND VPWR VPWR sky130_fd_sc_hd__fill_1
XFILLER_52_306 VGND VGND VPWR VPWR sky130_fd_sc_hd__fill_2
XTAP_TAPCELL_ROW_63_802 VGND VPWR sky130_fd_sc_hd__tapvpwrvgnd_1
XFILLER_92_486 VGND VGND VPWR VPWR sky130_fd_sc_hd__decap_3
XFILLER_92_475 VGND VGND VPWR VPWR sky130_fd_sc_hd__fill_1
XFILLER_52_339 VGND VGND VPWR VPWR sky130_fd_sc_hd__decap_3
X_4921_ clkload9/A _4921_/D VGND VGND VPWR VPWR _4921_/Q sky130_fd_sc_hd__dfxtp_2
XTAP_TAPCELL_ROW_35_537 VGND VPWR sky130_fd_sc_hd__tapvpwrvgnd_1
XFILLER_33_542 VGND VGND VPWR VPWR sky130_fd_sc_hd__decap_3
XFILLER_45_391 VGND VGND VPWR VPWR sky130_fd_sc_hd__fill_1
X_4852_ _5262_/Q _5261_/Q VGND VGND VPWR VPWR _4852_/X sky130_fd_sc_hd__and2b_2
X_3803_ _4464_/A _3804_/B VGND VGND VPWR VPWR _3805_/A sky130_fd_sc_hd__and2_2
XPHY_EDGE_ROW_72_Left_166 VGND VGND VPWR VPWR sky130_fd_sc_hd__decap_3
X_4783_ _4419_/A _4654_/Y _4782_/X _4320_/X VGND VGND VPWR VPWR _4783_/X sky130_fd_sc_hd__o211a_2
X_3734_ _5129_/Q _3734_/B VGND VGND VPWR VPWR _3734_/X sky130_fd_sc_hd__or2_2
X_3665_ _3664_/X _3663_/X _4077_/S VGND VGND VPWR VPWR _3665_/X sky130_fd_sc_hd__mux2_1
X_2616_ _5156_/Q _2617_/B _4466_/B _2547_/X VGND VGND VPWR VPWR _2616_/X sky130_fd_sc_hd__a31o_2
X_3596_ _3594_/X _3595_/X _3831_/A VGND VGND VPWR VPWR _3596_/X sky130_fd_sc_hd__mux2_1
X_2547_ _5157_/Q _4466_/A VGND VGND VPWR VPWR _2547_/X sky130_fd_sc_hd__and2_2
XPHY_EDGE_ROW_81_Left_175 VGND VGND VPWR VPWR sky130_fd_sc_hd__decap_3
X_2478_ _5167_/Q _4614_/A VGND VGND VPWR VPWR _2479_/B sky130_fd_sc_hd__or2_2
XFILLER_87_225 VGND VGND VPWR VPWR sky130_fd_sc_hd__decap_3
X_4217_ _4196_/A _4196_/B _4284_/B VGND VGND VPWR VPWR _4218_/B sky130_fd_sc_hd__a21o_2
XFILLER_87_247 VGND VGND VPWR VPWR sky130_fd_sc_hd__decap_3
XFILLER_28_303 VGND VGND VPWR VPWR sky130_fd_sc_hd__decap_3
X_5197_ _5263_/CLK _5197_/D VGND VGND VPWR VPWR _5197_/Q sky130_fd_sc_hd__dfxtp_2
XFILLER_55_133 VGND VGND VPWR VPWR sky130_fd_sc_hd__decap_3
XFILLER_68_494 VGND VGND VPWR VPWR sky130_fd_sc_hd__decap_3
X_4148_ _4148_/A _4148_/B VGND VGND VPWR VPWR _4149_/B sky130_fd_sc_hd__nand2_2
X_4079_ _4172_/A _4075_/X _4078_/X _4132_/A VGND VGND VPWR VPWR _4087_/A sky130_fd_sc_hd__a22o_2
XFILLER_83_464 VGND VGND VPWR VPWR sky130_fd_sc_hd__decap_3
XFILLER_36_380 VGND VGND VPWR VPWR sky130_fd_sc_hd__decap_3
XFILLER_55_188 VGND VGND VPWR VPWR sky130_fd_sc_hd__decap_3
XFILLER_83_486 VGND VGND VPWR VPWR sky130_fd_sc_hd__decap_3
XFILLER_70_158 VGND VGND VPWR VPWR sky130_fd_sc_hd__fill_1
XPHY_EDGE_ROW_90_Left_184 VGND VGND VPWR VPWR sky130_fd_sc_hd__decap_3
XFILLER_11_214 VGND VGND VPWR VPWR sky130_fd_sc_hd__fill_2
XFILLER_51_372 VGND VGND VPWR VPWR sky130_fd_sc_hd__decap_3
XFILLER_11_258 VGND VGND VPWR VPWR sky130_fd_sc_hd__decap_3
Xclkload1 clkload1/A VGND VGND VPWR VPWR clkload1/Y sky130_fd_sc_hd__inv_12
XFILLER_50_56 VGND VGND VPWR VPWR sky130_fd_sc_hd__decap_3
XFILLER_50_78 VGND VGND VPWR VPWR sky130_fd_sc_hd__fill_1
XFILLER_3_424 VGND VGND VPWR VPWR sky130_fd_sc_hd__decap_3
XFILLER_1_3 VGND VGND VPWR VPWR sky130_fd_sc_hd__decap_3
XFILLER_3_446 VGND VGND VPWR VPWR sky130_fd_sc_hd__fill_2
XFILLER_59_54 VGND VGND VPWR VPWR sky130_fd_sc_hd__fill_2
XFILLER_78_236 VGND VGND VPWR VPWR sky130_fd_sc_hd__decap_3
XFILLER_78_225 VGND VGND VPWR VPWR sky130_fd_sc_hd__decap_3
XFILLER_78_203 VGND VGND VPWR VPWR sky130_fd_sc_hd__decap_3
XTAP_TAPCELL_ROW_6_262 VGND VPWR sky130_fd_sc_hd__tapvpwrvgnd_1
XFILLER_59_483 VGND VGND VPWR VPWR sky130_fd_sc_hd__decap_3
XPHY_EDGE_ROW_3_Left_97 VGND VGND VPWR VPWR sky130_fd_sc_hd__decap_3
XFILLER_93_206 VGND VGND VPWR VPWR sky130_fd_sc_hd__fill_2
XFILLER_46_111 VGND VGND VPWR VPWR sky130_fd_sc_hd__decap_3
XFILLER_86_291 VGND VGND VPWR VPWR sky130_fd_sc_hd__decap_3
XFILLER_75_75 VGND VGND VPWR VPWR sky130_fd_sc_hd__fill_1
XFILLER_46_177 VGND VGND VPWR VPWR sky130_fd_sc_hd__decap_3
XFILLER_74_486 VGND VGND VPWR VPWR sky130_fd_sc_hd__fill_2
XFILLER_74_497 VGND VGND VPWR VPWR sky130_fd_sc_hd__decap_3
XFILLER_91_30 VGND VGND VPWR VPWR sky130_fd_sc_hd__decap_3
XFILLER_30_501 VGND VGND VPWR VPWR sky130_fd_sc_hd__fill_2
XTAP_TAPCELL_ROW_32_507 VGND VPWR sky130_fd_sc_hd__tapvpwrvgnd_1
XFILLER_91_63 VGND VGND VPWR VPWR sky130_fd_sc_hd__decap_3
XFILLER_42_383 VGND VGND VPWR VPWR sky130_fd_sc_hd__decap_3
XTAP_TAPCELL_ROW_40_584 VGND VPWR sky130_fd_sc_hd__tapvpwrvgnd_1
XFILLER_10_291 VGND VGND VPWR VPWR sky130_fd_sc_hd__decap_3
XFILLER_6_251 VGND VGND VPWR VPWR sky130_fd_sc_hd__fill_1
XFILLER_6_262 VGND VGND VPWR VPWR sky130_fd_sc_hd__decap_3
X_3450_ _5260_/Q _3450_/B _3450_/C VGND VGND VPWR VPWR _3450_/X sky130_fd_sc_hd__and3_2
X_3381_ _5145_/Q _3380_/C _5146_/Q VGND VGND VPWR VPWR _3381_/Y sky130_fd_sc_hd__a21oi_2
XFILLER_69_203 VGND VGND VPWR VPWR sky130_fd_sc_hd__decap_3
X_5120_ _5122_/CLK _5120_/D VGND VGND VPWR VPWR _5120_/Q sky130_fd_sc_hd__dfxtp_2
X_5051_ _5106_/CLK _5051_/D VGND VGND VPWR VPWR _5051_/Q sky130_fd_sc_hd__dfxtp_2
X_4002_ _4003_/A _4003_/B VGND VGND VPWR VPWR _4002_/Y sky130_fd_sc_hd__nor2_2
XFILLER_84_228 VGND VGND VPWR VPWR sky130_fd_sc_hd__decap_3
XFILLER_65_420 VGND VGND VPWR VPWR sky130_fd_sc_hd__decap_3
XFILLER_65_442 VGND VGND VPWR VPWR sky130_fd_sc_hd__decap_3
XFILLER_65_475 VGND VGND VPWR VPWR sky130_fd_sc_hd__decap_3
XTAP_TAPCELL_ROW_48_662 VGND VPWR sky130_fd_sc_hd__tapvpwrvgnd_1
XFILLER_37_199 VGND VGND VPWR VPWR sky130_fd_sc_hd__decap_3
XFILLER_52_103 VGND VGND VPWR VPWR sky130_fd_sc_hd__decap_3
XFILLER_92_283 VGND VGND VPWR VPWR sky130_fd_sc_hd__decap_3
XFILLER_80_434 VGND VGND VPWR VPWR sky130_fd_sc_hd__decap_3
XFILLER_80_412 VGND VGND VPWR VPWR sky130_fd_sc_hd__decap_3
XFILLER_52_136 VGND VGND VPWR VPWR sky130_fd_sc_hd__decap_3
XFILLER_52_147 VGND VGND VPWR VPWR sky130_fd_sc_hd__fill_1
XFILLER_33_361 VGND VGND VPWR VPWR sky130_fd_sc_hd__decap_3
XFILLER_40_309 VGND VGND VPWR VPWR sky130_fd_sc_hd__decap_3
X_4904_ _4982_/CLK _4904_/D VGND VGND VPWR VPWR _4904_/Q sky130_fd_sc_hd__dfxtp_2
XFILLER_80_489 VGND VGND VPWR VPWR sky130_fd_sc_hd__decap_3
X_4835_ _5247_/Q _4847_/B VGND VGND VPWR VPWR _4835_/X sky130_fd_sc_hd__or2_2
X_4766_ _3457_/A _4546_/A _4766_/S VGND VGND VPWR VPWR _4766_/X sky130_fd_sc_hd__mux2_1
X_3717_ _5129_/Q _3717_/B VGND VGND VPWR VPWR _3717_/X sky130_fd_sc_hd__or2_2
X_4697_ _3806_/Y _4360_/B _4690_/X _4696_/X VGND VGND VPWR VPWR _4699_/C sky130_fd_sc_hd__a211oi_2
X_3648_ _4464_/A _4787_/S VGND VGND VPWR VPWR _3648_/Y sky130_fd_sc_hd__nand2b_2
X_3579_ _4866_/A _3579_/B VGND VGND VPWR VPWR _5204_/D sky130_fd_sc_hd__nor2_2
XFILLER_0_427 VGND VGND VPWR VPWR sky130_fd_sc_hd__decap_3
XTAP_TAPCELL_ROW_93_1093 VGND VPWR sky130_fd_sc_hd__tapvpwrvgnd_1
XTAP_TAPCELL_ROW_93_1082 VGND VPWR sky130_fd_sc_hd__tapvpwrvgnd_1
XFILLER_0_449 VGND VGND VPWR VPWR sky130_fd_sc_hd__decap_3
X_5249_ _5253_/CLK _5249_/D VGND VGND VPWR VPWR _5249_/Q sky130_fd_sc_hd__dfxtp_2
XFILLER_29_79 VGND VGND VPWR VPWR sky130_fd_sc_hd__decap_3
XTAP_TAPCELL_ROW_3_232 VGND VPWR sky130_fd_sc_hd__tapvpwrvgnd_1
XFILLER_28_155 VGND VGND VPWR VPWR sky130_fd_sc_hd__decap_3
XTAP_TAPCELL_ROW_74_908 VGND VPWR sky130_fd_sc_hd__tapvpwrvgnd_1
XFILLER_43_103 VGND VGND VPWR VPWR sky130_fd_sc_hd__fill_1
XFILLER_56_486 VGND VGND VPWR VPWR sky130_fd_sc_hd__decap_3
XFILLER_71_423 VGND VGND VPWR VPWR sky130_fd_sc_hd__decap_3
XFILLER_45_78 VGND VGND VPWR VPWR sky130_fd_sc_hd__decap_3
XFILLER_71_456 VGND VGND VPWR VPWR sky130_fd_sc_hd__decap_3
XFILLER_43_169 VGND VGND VPWR VPWR sky130_fd_sc_hd__decap_3
XTAP_TAPCELL_ROW_82_985 VGND VPWR sky130_fd_sc_hd__tapvpwrvgnd_1
XFILLER_61_44 VGND VGND VPWR VPWR sky130_fd_sc_hd__fill_2
XFILLER_61_55 VGND VGND VPWR VPWR sky130_fd_sc_hd__fill_1
XFILLER_61_66 VGND VGND VPWR VPWR sky130_fd_sc_hd__decap_3
XFILLER_8_516 VGND VGND VPWR VPWR sky130_fd_sc_hd__decap_3
XFILLER_79_501 VGND VGND VPWR VPWR sky130_fd_sc_hd__decap_3
XFILLER_10_81 VGND VGND VPWR VPWR sky130_fd_sc_hd__decap_3
XFILLER_3_287 VGND VGND VPWR VPWR sky130_fd_sc_hd__fill_1
XFILLER_79_523 VGND VGND VPWR VPWR sky130_fd_sc_hd__decap_3
XFILLER_79_545 VGND VGND VPWR VPWR sky130_fd_sc_hd__decap_3
XFILLER_20_9 VGND VGND VPWR VPWR sky130_fd_sc_hd__decap_3
XFILLER_66_217 VGND VGND VPWR VPWR sky130_fd_sc_hd__decap_3
XFILLER_86_52 VGND VGND VPWR VPWR sky130_fd_sc_hd__decap_3
XFILLER_34_103 VGND VGND VPWR VPWR sky130_fd_sc_hd__decap_3
XFILLER_47_475 VGND VGND VPWR VPWR sky130_fd_sc_hd__fill_2
XFILLER_62_401 VGND VGND VPWR VPWR sky130_fd_sc_hd__decap_3
XFILLER_74_283 VGND VGND VPWR VPWR sky130_fd_sc_hd__decap_3
XFILLER_34_136 VGND VGND VPWR VPWR sky130_fd_sc_hd__decap_3
XFILLER_34_147 VGND VGND VPWR VPWR sky130_fd_sc_hd__decap_3
XFILLER_62_456 VGND VGND VPWR VPWR sky130_fd_sc_hd__fill_1
XTAP_TAPCELL_ROW_45_632 VGND VPWR sky130_fd_sc_hd__tapvpwrvgnd_1
X_2950_ _2900_/X _2961_/A2 _2961_/B1 _4884_/Q VGND VGND VPWR VPWR _4884_/D sky130_fd_sc_hd__a22o_2
XTAP_TAPCELL_ROW_17_367 VGND VPWR sky130_fd_sc_hd__tapvpwrvgnd_1
X_2881_ _4292_/A _2881_/B _2881_/C VGND VGND VPWR VPWR _2882_/B sky130_fd_sc_hd__nand3b_2
X_4620_ _4618_/X _4619_/Y _4686_/S VGND VGND VPWR VPWR _4621_/A sky130_fd_sc_hd__mux2_1
XFILLER_30_397 VGND VGND VPWR VPWR sky130_fd_sc_hd__fill_2
X_4551_ _4551_/A _4551_/B VGND VGND VPWR VPWR _4588_/B sky130_fd_sc_hd__or2_2
X_4482_ _2449_/Y _4110_/A _4482_/S VGND VGND VPWR VPWR _4482_/X sky130_fd_sc_hd__mux2_1
X_3502_ _3496_/B _3496_/C _3496_/A VGND VGND VPWR VPWR _3503_/B sky130_fd_sc_hd__a21bo_2
X_3433_ _5162_/Q _3429_/C _3228_/Y _3432_/X VGND VGND VPWR VPWR _5162_/D sky130_fd_sc_hd__o22a_2
X_5103_ _5103_/CLK _5103_/D VGND VGND VPWR VPWR _5103_/Q sky130_fd_sc_hd__dfxtp_2
X_3364_ _3324_/B _3360_/X _3363_/X VGND VGND VPWR VPWR _3369_/A sky130_fd_sc_hd__a21o_2
X_3295_ _3293_/Y _3294_/X _5185_/Q VGND VGND VPWR VPWR _3295_/X sky130_fd_sc_hd__o21a_2
X_5034_ _5114_/CLK _5034_/D VGND VGND VPWR VPWR _5034_/Q sky130_fd_sc_hd__dfxtp_2
XFILLER_38_442 VGND VGND VPWR VPWR sky130_fd_sc_hd__decap_3
XTAP_TAPCELL_ROW_0_202 VGND VPWR sky130_fd_sc_hd__tapvpwrvgnd_1
XFILLER_38_475 VGND VGND VPWR VPWR sky130_fd_sc_hd__fill_1
XFILLER_53_423 VGND VGND VPWR VPWR sky130_fd_sc_hd__decap_3
XFILLER_65_272 VGND VGND VPWR VPWR sky130_fd_sc_hd__decap_3
XTAP_TAPCELL_ROW_84_1004 VGND VPWR sky130_fd_sc_hd__tapvpwrvgnd_1
XFILLER_53_445 VGND VGND VPWR VPWR sky130_fd_sc_hd__decap_3
XFILLER_80_220 VGND VGND VPWR VPWR sky130_fd_sc_hd__fill_1
XFILLER_15_26 VGND VGND VPWR VPWR sky130_fd_sc_hd__decap_3
XFILLER_80_275 VGND VGND VPWR VPWR sky130_fd_sc_hd__decap_3
XFILLER_80_264 VGND VGND VPWR VPWR sky130_fd_sc_hd__decap_3
XFILLER_40_128 VGND VGND VPWR VPWR sky130_fd_sc_hd__decap_3
XFILLER_80_286 VGND VGND VPWR VPWR sky130_fd_sc_hd__decap_3
X_4818_ input33/X _4816_/Y _4817_/X _3448_/B VGND VGND VPWR VPWR _5238_/D sky130_fd_sc_hd__o211a_2
XFILLER_31_36 VGND VGND VPWR VPWR sky130_fd_sc_hd__fill_2
X_4749_ _2665_/A _3874_/D _4224_/A _3922_/A VGND VGND VPWR VPWR _4749_/X sky130_fd_sc_hd__o22a_2
Xoutput58 _5145_/Q VGND VGND VPWR VPWR INSTR_ADDR[12] sky130_fd_sc_hd__clkdlybuf4s25_1
XFILLER_0_246 VGND VGND VPWR VPWR sky130_fd_sc_hd__decap_3
Xoutput69 _5141_/Q VGND VGND VPWR VPWR INSTR_ADDR[8] sky130_fd_sc_hd__clkdlybuf4s25_1
XFILLER_0_268 VGND VGND VPWR VPWR sky130_fd_sc_hd__decap_3
XFILLER_48_206 VGND VGND VPWR VPWR sky130_fd_sc_hd__decap_3
XFILLER_88_375 VGND VGND VPWR VPWR sky130_fd_sc_hd__decap_3
XFILLER_76_515 VGND VGND VPWR VPWR sky130_fd_sc_hd__decap_3
XFILLER_48_239 VGND VGND VPWR VPWR sky130_fd_sc_hd__decap_3
XFILLER_56_11 VGND VGND VPWR VPWR sky130_fd_sc_hd__fill_1
XFILLER_76_548 VGND VGND VPWR VPWR sky130_fd_sc_hd__decap_3
XFILLER_56_44 VGND VGND VPWR VPWR sky130_fd_sc_hd__decap_3
XFILLER_91_518 VGND VGND VPWR VPWR sky130_fd_sc_hd__decap_3
XFILLER_16_103 VGND VGND VPWR VPWR sky130_fd_sc_hd__fill_2
XFILLER_16_114 VGND VGND VPWR VPWR sky130_fd_sc_hd__decap_3
XFILLER_29_497 VGND VGND VPWR VPWR sky130_fd_sc_hd__decap_3
XFILLER_44_401 VGND VGND VPWR VPWR sky130_fd_sc_hd__decap_3
XFILLER_56_283 VGND VGND VPWR VPWR sky130_fd_sc_hd__decap_3
XFILLER_56_77 VGND VGND VPWR VPWR sky130_fd_sc_hd__decap_3
XFILLER_44_445 VGND VGND VPWR VPWR sky130_fd_sc_hd__decap_3
XFILLER_71_264 VGND VGND VPWR VPWR sky130_fd_sc_hd__decap_3
XFILLER_72_32 VGND VGND VPWR VPWR sky130_fd_sc_hd__fill_1
XTAP_TAPCELL_ROW_42_602 VGND VPWR sky130_fd_sc_hd__tapvpwrvgnd_1
XFILLER_12_320 VGND VGND VPWR VPWR sky130_fd_sc_hd__decap_3
XFILLER_71_297 VGND VGND VPWR VPWR sky130_fd_sc_hd__decap_3
XTAP_TAPCELL_ROW_14_337 VGND VPWR sky130_fd_sc_hd__tapvpwrvgnd_1
XFILLER_8_368 VGND VGND VPWR VPWR sky130_fd_sc_hd__fill_2
XFILLER_4_541 VGND VGND VPWR VPWR sky130_fd_sc_hd__decap_3
XFILLER_79_342 VGND VGND VPWR VPWR sky130_fd_sc_hd__decap_3
XFILLER_79_331 VGND VGND VPWR VPWR sky130_fd_sc_hd__decap_3
XFILLER_39_206 VGND VGND VPWR VPWR sky130_fd_sc_hd__decap_3
XFILLER_39_228 VGND VGND VPWR VPWR sky130_fd_sc_hd__decap_3
XFILLER_67_526 VGND VGND VPWR VPWR sky130_fd_sc_hd__decap_3
X_3080_ _4866_/A _3080_/B VGND VGND VPWR VPWR _3080_/Y sky130_fd_sc_hd__nor2_2
XFILLER_54_209 VGND VGND VPWR VPWR sky130_fd_sc_hd__decap_3
XFILLER_82_507 VGND VGND VPWR VPWR sky130_fd_sc_hd__decap_3
XFILLER_35_423 VGND VGND VPWR VPWR sky130_fd_sc_hd__decap_3
XFILLER_47_272 VGND VGND VPWR VPWR sky130_fd_sc_hd__fill_2
XFILLER_62_242 VGND VGND VPWR VPWR sky130_fd_sc_hd__decap_3
XFILLER_62_264 VGND VGND VPWR VPWR sky130_fd_sc_hd__decap_3
X_3982_ _4493_/B _4523_/S _3981_/Y VGND VGND VPWR VPWR _3983_/B sky130_fd_sc_hd__a21o_2
XFILLER_15_180 VGND VGND VPWR VPWR sky130_fd_sc_hd__decap_3
XFILLER_22_117 VGND VGND VPWR VPWR sky130_fd_sc_hd__decap_3
XFILLER_62_297 VGND VGND VPWR VPWR sky130_fd_sc_hd__decap_3
X_2933_ _4878_/Q _2936_/A2 _2932_/X _2936_/B2 VGND VGND VPWR VPWR _4878_/D sky130_fd_sc_hd__a22o_2
X_2864_ _2887_/B _2864_/B VGND VGND VPWR VPWR _2864_/Y sky130_fd_sc_hd__nor2_2
X_4603_ _4632_/B _4632_/C VGND VGND VPWR VPWR _4603_/Y sky130_fd_sc_hd__xnor2_2
X_2795_ _2793_/X _2794_/X _2831_/S VGND VGND VPWR VPWR _2795_/X sky130_fd_sc_hd__mux2_1
X_4534_ _4542_/S _4534_/B _4534_/C VGND VGND VPWR VPWR _4534_/X sky130_fd_sc_hd__and3_2
XFILLER_7_60 VGND VGND VPWR VPWR sky130_fd_sc_hd__decap_3
XFILLER_7_390 VGND VGND VPWR VPWR sky130_fd_sc_hd__fill_2
X_4465_ _4465_/A _4465_/B VGND VGND VPWR VPWR _4477_/C sky130_fd_sc_hd__nand2_2
X_4396_ _4397_/A _4397_/B VGND VGND VPWR VPWR _4396_/Y sky130_fd_sc_hd__nand2_2
X_3416_ _5260_/Q _3448_/B _3416_/C VGND VGND VPWR VPWR _3416_/X sky130_fd_sc_hd__and3_2
XFILLER_58_515 VGND VGND VPWR VPWR sky130_fd_sc_hd__decap_3
X_3347_ _5143_/Q _5142_/Q _3347_/C VGND VGND VPWR VPWR _3371_/C sky130_fd_sc_hd__and3_2
XTAP_TAPCELL_ROW_90_1052 VGND VPWR sky130_fd_sc_hd__tapvpwrvgnd_1
XFILLER_58_548 VGND VGND VPWR VPWR sky130_fd_sc_hd__decap_3
XFILLER_85_323 VGND VGND VPWR VPWR sky130_fd_sc_hd__decap_3
X_5017_ clkload7/A _5017_/D VGND VGND VPWR VPWR _5017_/Q sky130_fd_sc_hd__dfxtp_2
X_3278_ _5136_/Q _3265_/B _3277_/Y _3448_/B VGND VGND VPWR VPWR _5136_/D sky130_fd_sc_hd__o211a_2
XFILLER_85_367 VGND VGND VPWR VPWR sky130_fd_sc_hd__decap_3
XFILLER_73_529 VGND VGND VPWR VPWR sky130_fd_sc_hd__decap_3
XTAP_TAPCELL_ROW_56_738 VGND VPWR sky130_fd_sc_hd__tapvpwrvgnd_1
XFILLER_85_389 VGND VGND VPWR VPWR sky130_fd_sc_hd__decap_3
XFILLER_53_231 VGND VGND VPWR VPWR sky130_fd_sc_hd__decap_3
XFILLER_53_264 VGND VGND VPWR VPWR sky130_fd_sc_hd__fill_2
XFILLER_81_551 VGND VGND VPWR VPWR sky130_fd_sc_hd__fill_2
XFILLER_41_426 VGND VGND VPWR VPWR sky130_fd_sc_hd__fill_1
XFILLER_21_172 VGND VGND VPWR VPWR sky130_fd_sc_hd__decap_3
XFILLER_42_68 VGND VGND VPWR VPWR sky130_fd_sc_hd__decap_3
XTAP_TAPCELL_ROW_11_307 VGND VPWR sky130_fd_sc_hd__tapvpwrvgnd_1
XFILLER_5_316 VGND VGND VPWR VPWR sky130_fd_sc_hd__decap_3
XFILLER_5_349 VGND VGND VPWR VPWR sky130_fd_sc_hd__decap_3
XFILLER_67_43 VGND VGND VPWR VPWR sky130_fd_sc_hd__decap_3
XFILLER_88_161 VGND VGND VPWR VPWR sky130_fd_sc_hd__decap_3
XFILLER_76_312 VGND VGND VPWR VPWR sky130_fd_sc_hd__decap_3
XFILLER_29_261 VGND VGND VPWR VPWR sky130_fd_sc_hd__decap_3
XFILLER_64_518 VGND VGND VPWR VPWR sky130_fd_sc_hd__decap_3
XFILLER_76_389 VGND VGND VPWR VPWR sky130_fd_sc_hd__decap_3
XFILLER_17_434 VGND VGND VPWR VPWR sky130_fd_sc_hd__decap_3
XFILLER_91_337 VGND VGND VPWR VPWR sky130_fd_sc_hd__fill_2
XFILLER_83_53 VGND VGND VPWR VPWR sky130_fd_sc_hd__decap_3
XFILLER_17_489 VGND VGND VPWR VPWR sky130_fd_sc_hd__decap_3
XFILLER_32_415 VGND VGND VPWR VPWR sky130_fd_sc_hd__decap_3
XFILLER_44_253 VGND VGND VPWR VPWR sky130_fd_sc_hd__decap_3
XFILLER_72_551 VGND VGND VPWR VPWR sky130_fd_sc_hd__fill_2
XTAP_TAPCELL_ROW_27_462 VGND VPWR sky130_fd_sc_hd__tapvpwrvgnd_1
XFILLER_16_91 VGND VGND VPWR VPWR sky130_fd_sc_hd__decap_3
XFILLER_12_194 VGND VGND VPWR VPWR sky130_fd_sc_hd__fill_2
XFILLER_40_492 VGND VGND VPWR VPWR sky130_fd_sc_hd__decap_3
X_2580_ _2578_/X _2579_/X _2667_/A VGND VGND VPWR VPWR _2580_/X sky130_fd_sc_hd__mux2_1
X_4250_ _4432_/B _4523_/S _4249_/Y VGND VGND VPWR VPWR _4250_/X sky130_fd_sc_hd__o21a_2
X_4181_ _4155_/A _4178_/X _4180_/X VGND VGND VPWR VPWR _4181_/Y sky130_fd_sc_hd__o21ai_2
X_3201_ _2929_/X _3203_/A2 _3203_/B1 _5101_/Q VGND VGND VPWR VPWR _5101_/D sky130_fd_sc_hd__a22o_2
X_3132_ _2941_/X _3116_/Y _3133_/B1 _5041_/Q VGND VGND VPWR VPWR _5041_/D sky130_fd_sc_hd__a22o_2
XFILLER_67_345 VGND VGND VPWR VPWR sky130_fd_sc_hd__decap_3
XFILLER_55_518 VGND VGND VPWR VPWR sky130_fd_sc_hd__decap_3
X_3063_ _2900_/X _3074_/A2 _3061_/Y _4980_/Q VGND VGND VPWR VPWR _4980_/D sky130_fd_sc_hd__a22o_2
XFILLER_82_315 VGND VGND VPWR VPWR sky130_fd_sc_hd__decap_3
XFILLER_82_304 VGND VGND VPWR VPWR sky130_fd_sc_hd__decap_3
XFILLER_82_348 VGND VGND VPWR VPWR sky130_fd_sc_hd__decap_3
XTAP_TAPCELL_ROW_53_708 VGND VPWR sky130_fd_sc_hd__tapvpwrvgnd_1
XFILLER_23_415 VGND VGND VPWR VPWR sky130_fd_sc_hd__decap_3
XFILLER_35_275 VGND VGND VPWR VPWR sky130_fd_sc_hd__decap_3
XFILLER_90_381 VGND VGND VPWR VPWR sky130_fd_sc_hd__decap_3
XFILLER_50_256 VGND VGND VPWR VPWR sky130_fd_sc_hd__decap_3
X_3965_ _4449_/B _4787_/S VGND VGND VPWR VPWR _3965_/X sky130_fd_sc_hd__or2_2
X_3896_ _4139_/A _4112_/A VGND VGND VPWR VPWR _3896_/Y sky130_fd_sc_hd__nand2_2
X_2916_ _5196_/Q _2455_/X _3456_/B _5244_/Q _2915_/X VGND VGND VPWR VPWR _2916_/X
+ sky130_fd_sc_hd__a221o_2
XTAP_TAPCELL_ROW_61_785 VGND VPWR sky130_fd_sc_hd__tapvpwrvgnd_1
XFILLER_31_481 VGND VGND VPWR VPWR sky130_fd_sc_hd__fill_2
X_2847_ _5122_/Q _5010_/Q _4994_/Q _4978_/Q _5131_/Q _5132_/Q VGND VGND VPWR VPWR
+ _2847_/X sky130_fd_sc_hd__mux4_2
X_2778_ _5134_/Q _2773_/X _2775_/X _2777_/X VGND VGND VPWR VPWR _3312_/B sky130_fd_sc_hd__a22o_2
X_4517_ _4471_/A _4551_/A _4523_/S VGND VGND VPWR VPWR _4517_/X sky130_fd_sc_hd__mux2_1
X_4448_ _4449_/A _4449_/B VGND VGND VPWR VPWR _4465_/B sky130_fd_sc_hd__nor2_2
XFILLER_58_301 VGND VGND VPWR VPWR sky130_fd_sc_hd__fill_2
XFILLER_58_312 VGND VGND VPWR VPWR sky130_fd_sc_hd__decap_3
X_4379_ _5222_/Q _4850_/B VGND VGND VPWR VPWR _4379_/Y sky130_fd_sc_hd__nand2_2
XFILLER_58_356 VGND VGND VPWR VPWR sky130_fd_sc_hd__decap_3
XFILLER_37_57 VGND VGND VPWR VPWR sky130_fd_sc_hd__decap_3
XFILLER_54_540 VGND VGND VPWR VPWR sky130_fd_sc_hd__decap_3
XFILLER_73_337 VGND VGND VPWR VPWR sky130_fd_sc_hd__decap_3
XFILLER_14_404 VGND VGND VPWR VPWR sky130_fd_sc_hd__decap_3
XFILLER_26_253 VGND VGND VPWR VPWR sky130_fd_sc_hd__decap_3
XFILLER_26_275 VGND VGND VPWR VPWR sky130_fd_sc_hd__decap_3
XFILLER_41_223 VGND VGND VPWR VPWR sky130_fd_sc_hd__fill_1
XFILLER_81_370 VGND VGND VPWR VPWR sky130_fd_sc_hd__decap_3
XFILLER_41_234 VGND VGND VPWR VPWR sky130_fd_sc_hd__decap_3
XFILLER_41_256 VGND VGND VPWR VPWR sky130_fd_sc_hd__decap_3
XTAP_TAPCELL_ROW_24_432 VGND VPWR sky130_fd_sc_hd__tapvpwrvgnd_1
XFILLER_22_470 VGND VGND VPWR VPWR sky130_fd_sc_hd__decap_3
XFILLER_41_278 VGND VGND VPWR VPWR sky130_fd_sc_hd__fill_2
XFILLER_53_89 VGND VGND VPWR VPWR sky130_fd_sc_hd__decap_3
XFILLER_5_113 VGND VGND VPWR VPWR sky130_fd_sc_hd__fill_1
XFILLER_5_146 VGND VGND VPWR VPWR sky130_fd_sc_hd__decap_3
XFILLER_78_42 VGND VGND VPWR VPWR sky130_fd_sc_hd__decap_3
XFILLER_78_75 VGND VGND VPWR VPWR sky130_fd_sc_hd__decap_3
XFILLER_49_323 VGND VGND VPWR VPWR sky130_fd_sc_hd__decap_3
XFILLER_49_367 VGND VGND VPWR VPWR sky130_fd_sc_hd__decap_3
XFILLER_64_315 VGND VGND VPWR VPWR sky130_fd_sc_hd__decap_3
XFILLER_64_348 VGND VGND VPWR VPWR sky130_fd_sc_hd__decap_3
XFILLER_91_167 VGND VGND VPWR VPWR sky130_fd_sc_hd__fill_1
XFILLER_20_407 VGND VGND VPWR VPWR sky130_fd_sc_hd__fill_2
XFILLER_20_429 VGND VGND VPWR VPWR sky130_fd_sc_hd__decap_3
XFILLER_32_267 VGND VGND VPWR VPWR sky130_fd_sc_hd__fill_1
X_3750_ _5119_/Q _5007_/Q _4991_/Q _4975_/Q _5127_/Q _3834_/S1 VGND VGND VPWR VPWR
+ _3750_/X sky130_fd_sc_hd__mux4_2
XFILLER_13_492 VGND VGND VPWR VPWR sky130_fd_sc_hd__decap_3
X_2701_ _4546_/A _2701_/B VGND VGND VPWR VPWR _2701_/Y sky130_fd_sc_hd__nor2_2
X_3681_ _4361_/A _3681_/B _4312_/A VGND VGND VPWR VPWR _3876_/B sky130_fd_sc_hd__or3_2
X_2632_ _2627_/X _2628_/X _2631_/X _2435_/Y VGND VGND VPWR VPWR _4468_/A sky130_fd_sc_hd__a22o_2
X_2563_ _3874_/A VGND VGND VPWR VPWR _3932_/A sky130_fd_sc_hd__inv_2
X_4302_ _4108_/A _4369_/A _4299_/X _4301_/X _4110_/A VGND VGND VPWR VPWR _4302_/Y
+ sky130_fd_sc_hd__a2111oi_2
XFILLER_4_190 VGND VGND VPWR VPWR sky130_fd_sc_hd__decap_3
X_4233_ _4223_/A _4136_/B _4632_/A _2638_/A _4700_/S VGND VGND VPWR VPWR _4233_/X
+ sky130_fd_sc_hd__o221a_2
X_2494_ _5072_/Q _5056_/Q _5040_/Q _5024_/Q _5123_/Q _2671_/S1 VGND VGND VPWR VPWR
+ _2494_/X sky130_fd_sc_hd__mux4_2
XFILLER_4_83 VGND VGND VPWR VPWR sky130_fd_sc_hd__fill_1
XFILLER_87_429 VGND VGND VPWR VPWR sky130_fd_sc_hd__decap_3
XFILLER_67_142 VGND VGND VPWR VPWR sky130_fd_sc_hd__decap_3
X_4164_ _4164_/A _4164_/B VGND VGND VPWR VPWR _4164_/Y sky130_fd_sc_hd__xnor2_2
XFILLER_55_315 VGND VGND VPWR VPWR sky130_fd_sc_hd__decap_3
X_4095_ _4095_/A _4095_/B VGND VGND VPWR VPWR _4095_/X sky130_fd_sc_hd__xor2_2
X_3115_ _2944_/X _3099_/B _3099_/Y _5026_/Q VGND VGND VPWR VPWR _5026_/D sky130_fd_sc_hd__a22o_2
XFILLER_55_337 VGND VGND VPWR VPWR sky130_fd_sc_hd__decap_3
XFILLER_67_197 VGND VGND VPWR VPWR sky130_fd_sc_hd__decap_3
X_3046_ _2903_/X _3056_/A2 _3043_/Y _4965_/Q VGND VGND VPWR VPWR _4965_/D sky130_fd_sc_hd__a22o_2
XTAP_TAPCELL_ROW_66_833 VGND VPWR sky130_fd_sc_hd__tapvpwrvgnd_1
XFILLER_82_112 VGND VGND VPWR VPWR sky130_fd_sc_hd__fill_1
XFILLER_70_318 VGND VGND VPWR VPWR sky130_fd_sc_hd__decap_3
XFILLER_23_223 VGND VGND VPWR VPWR sky130_fd_sc_hd__fill_1
XFILLER_82_189 VGND VGND VPWR VPWR sky130_fd_sc_hd__decap_3
XFILLER_23_234 VGND VGND VPWR VPWR sky130_fd_sc_hd__fill_2
XFILLER_23_26 VGND VGND VPWR VPWR sky130_fd_sc_hd__decap_3
X_4997_ _5109_/CLK _4997_/D VGND VGND VPWR VPWR _4997_/Q sky130_fd_sc_hd__dfxtp_2
XTAP_TAPCELL_ROW_21_402 VGND VPWR sky130_fd_sc_hd__tapvpwrvgnd_1
X_3948_ _4361_/A _3681_/B _3947_/X _3943_/X VGND VGND VPWR VPWR _3948_/X sky130_fd_sc_hd__o31a_2
X_3879_ _4132_/A _3677_/X _3653_/X _3667_/X VGND VGND VPWR VPWR _3880_/D sky130_fd_sc_hd__a211o_2
XFILLER_86_451 VGND VGND VPWR VPWR sky130_fd_sc_hd__fill_1
XFILLER_48_78 VGND VGND VPWR VPWR sky130_fd_sc_hd__decap_3
XFILLER_58_164 VGND VGND VPWR VPWR sky130_fd_sc_hd__decap_3
XFILLER_86_484 VGND VGND VPWR VPWR sky130_fd_sc_hd__fill_1
XFILLER_64_44 VGND VGND VPWR VPWR sky130_fd_sc_hd__decap_3
XFILLER_64_88 VGND VGND VPWR VPWR sky130_fd_sc_hd__decap_3
XFILLER_73_189 VGND VGND VPWR VPWR sky130_fd_sc_hd__decap_3
XFILLER_14_223 VGND VGND VPWR VPWR sky130_fd_sc_hd__decap_3
XFILLER_14_256 VGND VGND VPWR VPWR sky130_fd_sc_hd__decap_3
XFILLER_80_32 VGND VGND VPWR VPWR sky130_fd_sc_hd__fill_1
XFILLER_80_21 VGND VGND VPWR VPWR sky130_fd_sc_hd__decap_3
XFILLER_80_65 VGND VGND VPWR VPWR sky130_fd_sc_hd__fill_1
XFILLER_49_175 VGND VGND VPWR VPWR sky130_fd_sc_hd__fill_1
XFILLER_92_410 VGND VGND VPWR VPWR sky130_fd_sc_hd__decap_3
XFILLER_77_484 VGND VGND VPWR VPWR sky130_fd_sc_hd__decap_3
XFILLER_37_337 VGND VGND VPWR VPWR sky130_fd_sc_hd__decap_3
XFILLER_64_112 VGND VGND VPWR VPWR sky130_fd_sc_hd__decap_3
XFILLER_64_134 VGND VGND VPWR VPWR sky130_fd_sc_hd__fill_1
XFILLER_92_443 VGND VGND VPWR VPWR sky130_fd_sc_hd__decap_3
XFILLER_92_421 VGND VGND VPWR VPWR sky130_fd_sc_hd__decap_3
XFILLER_64_167 VGND VGND VPWR VPWR sky130_fd_sc_hd__decap_3
XTAP_TAPCELL_ROW_63_803 VGND VPWR sky130_fd_sc_hd__tapvpwrvgnd_1
XFILLER_45_370 VGND VGND VPWR VPWR sky130_fd_sc_hd__decap_3
XFILLER_52_318 VGND VGND VPWR VPWR sky130_fd_sc_hd__decap_3
X_4920_ _4982_/CLK _4920_/D VGND VGND VPWR VPWR _4920_/Q sky130_fd_sc_hd__dfxtp_2
XTAP_TAPCELL_ROW_35_538 VGND VPWR sky130_fd_sc_hd__tapvpwrvgnd_1
XFILLER_92_498 VGND VGND VPWR VPWR sky130_fd_sc_hd__fill_1
X_4851_ _5255_/Q _4168_/A _4850_/X _3448_/B VGND VGND VPWR VPWR _5255_/D sky130_fd_sc_hd__o211a_2
XFILLER_60_351 VGND VGND VPWR VPWR sky130_fd_sc_hd__decap_3
X_3802_ _3796_/X _3798_/X _3801_/X _2432_/Y VGND VGND VPWR VPWR _3804_/B sky130_fd_sc_hd__a22o_2
XFILLER_20_237 VGND VGND VPWR VPWR sky130_fd_sc_hd__decap_3
X_4782_ _3847_/A _3743_/Y _4326_/A _4246_/A _4781_/X VGND VGND VPWR VPWR _4782_/X
+ sky130_fd_sc_hd__o221a_2
XTAP_TAPCELL_ROW_71_880 VGND VPWR sky130_fd_sc_hd__tapvpwrvgnd_1
X_3733_ _4896_/Q _4880_/Q _5104_/Q _5088_/Q _5127_/Q _5128_/Q VGND VGND VPWR VPWR
+ _3734_/B sky130_fd_sc_hd__mux4_2
X_3664_ _4466_/B _4466_/A _4010_/S VGND VGND VPWR VPWR _3664_/X sky130_fd_sc_hd__mux2_1
XFILLER_9_293 VGND VGND VPWR VPWR sky130_fd_sc_hd__decap_3
Xclkload30 _5094_/CLK VGND VGND VPWR VPWR clkload30/Y sky130_fd_sc_hd__bufinv_16
X_2615_ _3874_/A _2861_/B _2562_/A VGND VGND VPWR VPWR _2863_/A sky130_fd_sc_hd__a21o_2
X_3595_ _5110_/Q _4998_/Q _4982_/Q _4966_/Q _3834_/S0 _3834_/S1 VGND VGND VPWR VPWR
+ _3595_/X sky130_fd_sc_hd__mux4_2
X_2546_ _2539_/X _2541_/X _2544_/X _2435_/Y VGND VGND VPWR VPWR _4466_/A sky130_fd_sc_hd__a22o_2
X_2477_ _5167_/Q _4614_/A VGND VGND VPWR VPWR _2479_/A sky130_fd_sc_hd__nand2_2
XFILLER_87_204 VGND VGND VPWR VPWR sky130_fd_sc_hd__decap_3
XFILLER_68_440 VGND VGND VPWR VPWR sky130_fd_sc_hd__fill_1
X_4216_ _5214_/Q _4700_/S _4215_/Y _3442_/B VGND VGND VPWR VPWR _5214_/D sky130_fd_sc_hd__o211a_2
X_5196_ _5262_/CLK _5196_/D VGND VGND VPWR VPWR _5196_/Q sky130_fd_sc_hd__dfxtp_2
XFILLER_87_259 VGND VGND VPWR VPWR sky130_fd_sc_hd__decap_3
XFILLER_87_237 VGND VGND VPWR VPWR sky130_fd_sc_hd__fill_2
XFILLER_68_473 VGND VGND VPWR VPWR sky130_fd_sc_hd__decap_3
X_4147_ _4095_/A _4095_/B _4662_/B _3839_/B VGND VGND VPWR VPWR _4148_/B sky130_fd_sc_hd__a211o_2
XFILLER_18_37 VGND VGND VPWR VPWR sky130_fd_sc_hd__decap_3
XTAP_TAPCELL_ROW_87_1024 VGND VPWR sky130_fd_sc_hd__tapvpwrvgnd_1
XFILLER_55_156 VGND VGND VPWR VPWR sky130_fd_sc_hd__fill_2
XFILLER_55_167 VGND VGND VPWR VPWR sky130_fd_sc_hd__fill_1
X_4078_ _4173_/A _4077_/X _4076_/Y VGND VGND VPWR VPWR _4078_/X sky130_fd_sc_hd__o21a_2
XFILLER_24_510 VGND VGND VPWR VPWR sky130_fd_sc_hd__fill_2
XFILLER_70_126 VGND VGND VPWR VPWR sky130_fd_sc_hd__decap_3
X_3029_ _2910_/X _3024_/B _3024_/Y _4951_/Q VGND VGND VPWR VPWR _4951_/D sky130_fd_sc_hd__a22o_2
XFILLER_34_25 VGND VGND VPWR VPWR sky130_fd_sc_hd__decap_3
XFILLER_34_69 VGND VGND VPWR VPWR sky130_fd_sc_hd__decap_3
XFILLER_51_351 VGND VGND VPWR VPWR sky130_fd_sc_hd__decap_3
Xwire128 _3023_/Y VGND VGND VPWR VPWR _3024_/B sky130_fd_sc_hd__clkbuf_8
Xclkload2 clkload2/A VGND VGND VPWR VPWR clkload2/Y sky130_fd_sc_hd__inv_8
XFILLER_7_219 VGND VGND VPWR VPWR sky130_fd_sc_hd__decap_3
XFILLER_50_68 VGND VGND VPWR VPWR sky130_fd_sc_hd__decap_3
XFILLER_59_33 VGND VGND VPWR VPWR sky130_fd_sc_hd__decap_3
XFILLER_59_66 VGND VGND VPWR VPWR sky130_fd_sc_hd__decap_3
XFILLER_78_259 VGND VGND VPWR VPWR sky130_fd_sc_hd__decap_3
XFILLER_75_21 VGND VGND VPWR VPWR sky130_fd_sc_hd__fill_1
XTAP_TAPCELL_ROW_6_263 VGND VPWR sky130_fd_sc_hd__tapvpwrvgnd_1
XFILLER_19_337 VGND VGND VPWR VPWR sky130_fd_sc_hd__decap_3
XFILLER_46_101 VGND VGND VPWR VPWR sky130_fd_sc_hd__fill_2
XFILLER_46_123 VGND VGND VPWR VPWR sky130_fd_sc_hd__decap_3
XFILLER_74_421 VGND VGND VPWR VPWR sky130_fd_sc_hd__decap_3
XFILLER_34_307 VGND VGND VPWR VPWR sky130_fd_sc_hd__fill_1
XFILLER_75_87 VGND VGND VPWR VPWR sky130_fd_sc_hd__decap_3
XFILLER_27_370 VGND VGND VPWR VPWR sky130_fd_sc_hd__decap_3
XFILLER_42_351 VGND VGND VPWR VPWR sky130_fd_sc_hd__decap_3
XTAP_TAPCELL_ROW_32_508 VGND VPWR sky130_fd_sc_hd__tapvpwrvgnd_1
XTAP_TAPCELL_ROW_40_585 VGND VPWR sky130_fd_sc_hd__tapvpwrvgnd_1
XFILLER_6_274 VGND VGND VPWR VPWR sky130_fd_sc_hd__decap_3
X_3380_ _5146_/Q _5145_/Q _3380_/C VGND VGND VPWR VPWR _3392_/B sky130_fd_sc_hd__and3_2
X_5050_ _5114_/CLK _5050_/D VGND VGND VPWR VPWR _5050_/Q sky130_fd_sc_hd__dfxtp_2
XFILLER_27_3 VGND VGND VPWR VPWR sky130_fd_sc_hd__decap_3
X_4001_ _5178_/Q _4001_/B VGND VGND VPWR VPWR _4136_/B sky130_fd_sc_hd__nand2_2
XFILLER_77_281 VGND VGND VPWR VPWR sky130_fd_sc_hd__decap_3
XFILLER_25_307 VGND VGND VPWR VPWR sky130_fd_sc_hd__decap_3
XFILLER_37_167 VGND VGND VPWR VPWR sky130_fd_sc_hd__fill_1
XFILLER_37_178 VGND VGND VPWR VPWR sky130_fd_sc_hd__fill_1
XFILLER_65_487 VGND VGND VPWR VPWR sky130_fd_sc_hd__decap_3
XFILLER_92_262 VGND VGND VPWR VPWR sky130_fd_sc_hd__decap_3
XFILLER_80_424 VGND VGND VPWR VPWR sky130_fd_sc_hd__decap_3
XFILLER_52_159 VGND VGND VPWR VPWR sky130_fd_sc_hd__decap_3
X_4903_ _5116_/CLK _4903_/D VGND VGND VPWR VPWR _4903_/Q sky130_fd_sc_hd__dfxtp_2
XFILLER_92_295 VGND VGND VPWR VPWR sky130_fd_sc_hd__decap_3
XFILLER_80_446 VGND VGND VPWR VPWR sky130_fd_sc_hd__decap_3
XFILLER_33_340 VGND VGND VPWR VPWR sky130_fd_sc_hd__decap_3
XFILLER_33_373 VGND VGND VPWR VPWR sky130_fd_sc_hd__decap_3
XFILLER_21_535 VGND VGND VPWR VPWR sky130_fd_sc_hd__decap_3
X_4834_ input47/X _4816_/Y _4833_/X _3442_/B VGND VGND VPWR VPWR _5246_/D sky130_fd_sc_hd__o211a_2
X_4765_ _2684_/A _3874_/D _3847_/A _4330_/B _4764_/X VGND VGND VPWR VPWR _4765_/X
+ sky130_fd_sc_hd__o221a_2
X_3716_ _4893_/Q _4877_/Q _5101_/Q _5085_/Q _3834_/S0 _3834_/S1 VGND VGND VPWR VPWR
+ _3717_/B sky130_fd_sc_hd__mux4_2
X_4696_ _2623_/A _3678_/X _4662_/A _3805_/A _4689_/X VGND VGND VPWR VPWR _4696_/X
+ sky130_fd_sc_hd__a221o_2
XFILLER_20_27 VGND VGND VPWR VPWR sky130_fd_sc_hd__fill_1
XFILLER_20_49 VGND VGND VPWR VPWR sky130_fd_sc_hd__fill_1
X_3647_ _3934_/B _3924_/B _4787_/S VGND VGND VPWR VPWR _3647_/X sky130_fd_sc_hd__mux2_1
X_3578_ _3585_/A _3576_/X _3577_/Y _4168_/A _2420_/Y VGND VGND VPWR VPWR _3579_/B
+ sky130_fd_sc_hd__o32a_2
XFILLER_0_406 VGND VGND VPWR VPWR sky130_fd_sc_hd__decap_3
X_2529_ _5125_/Q _2529_/B VGND VGND VPWR VPWR _2529_/X sky130_fd_sc_hd__or2_2
XTAP_TAPCELL_ROW_93_1094 VGND VPWR sky130_fd_sc_hd__tapvpwrvgnd_1
XTAP_TAPCELL_ROW_93_1083 VGND VPWR sky130_fd_sc_hd__tapvpwrvgnd_1
XFILLER_88_513 VGND VGND VPWR VPWR sky130_fd_sc_hd__decap_3
XFILLER_29_36 VGND VGND VPWR VPWR sky130_fd_sc_hd__fill_2
X_5248_ _5253_/CLK _5248_/D VGND VGND VPWR VPWR _5248_/Q sky130_fd_sc_hd__dfxtp_2
XFILLER_28_112 VGND VGND VPWR VPWR sky130_fd_sc_hd__decap_3
XFILLER_56_410 VGND VGND VPWR VPWR sky130_fd_sc_hd__decap_3
XFILLER_56_421 VGND VGND VPWR VPWR sky130_fd_sc_hd__decap_3
X_5179_ _5251_/CLK _5179_/D VGND VGND VPWR VPWR _5179_/Q sky130_fd_sc_hd__dfxtp_2
XTAP_TAPCELL_ROW_3_233 VGND VPWR sky130_fd_sc_hd__tapvpwrvgnd_1
XTAP_TAPCELL_ROW_74_909 VGND VPWR sky130_fd_sc_hd__tapvpwrvgnd_1
XFILLER_28_167 VGND VGND VPWR VPWR sky130_fd_sc_hd__fill_2
XFILLER_71_402 VGND VGND VPWR VPWR sky130_fd_sc_hd__decap_3
XFILLER_83_273 VGND VGND VPWR VPWR sky130_fd_sc_hd__decap_3
XFILLER_45_57 VGND VGND VPWR VPWR sky130_fd_sc_hd__fill_1
XFILLER_71_435 VGND VGND VPWR VPWR sky130_fd_sc_hd__decap_3
XFILLER_24_351 VGND VGND VPWR VPWR sky130_fd_sc_hd__fill_2
XFILLER_51_181 VGND VGND VPWR VPWR sky130_fd_sc_hd__decap_3
XFILLER_6_29 VGND VGND VPWR VPWR sky130_fd_sc_hd__decap_3
XFILLER_3_222 VGND VGND VPWR VPWR sky130_fd_sc_hd__fill_2
XFILLER_79_535 VGND VGND VPWR VPWR sky130_fd_sc_hd__fill_1
XFILLER_47_421 VGND VGND VPWR VPWR sky130_fd_sc_hd__decap_3
XFILLER_59_270 VGND VGND VPWR VPWR sky130_fd_sc_hd__decap_3
XFILLER_59_281 VGND VGND VPWR VPWR sky130_fd_sc_hd__decap_3
XFILLER_66_229 VGND VGND VPWR VPWR sky130_fd_sc_hd__decap_3
XFILLER_86_75 VGND VGND VPWR VPWR sky130_fd_sc_hd__decap_3
XFILLER_19_145 VGND VGND VPWR VPWR sky130_fd_sc_hd__fill_1
XFILLER_74_240 VGND VGND VPWR VPWR sky130_fd_sc_hd__decap_3
XFILLER_34_115 VGND VGND VPWR VPWR sky130_fd_sc_hd__decap_3
XFILLER_47_498 VGND VGND VPWR VPWR sky130_fd_sc_hd__decap_3
XTAP_TAPCELL_ROW_45_633 VGND VPWR sky130_fd_sc_hd__tapvpwrvgnd_1
XFILLER_15_373 VGND VGND VPWR VPWR sky130_fd_sc_hd__decap_3
X_2880_ _2887_/B _2880_/B VGND VGND VPWR VPWR _2880_/Y sky130_fd_sc_hd__nor2_2
X_4550_ _2449_/Y _4546_/B _4313_/B _2607_/Y _4549_/X VGND VGND VPWR VPWR _4556_/C
+ sky130_fd_sc_hd__a221o_2
X_4481_ _4476_/X _4479_/X _4480_/X _4371_/B VGND VGND VPWR VPWR _4481_/X sky130_fd_sc_hd__a31o_2
X_3501_ _3499_/X _3501_/B VGND VGND VPWR VPWR _3503_/A sky130_fd_sc_hd__and2b_2
X_3432_ _5260_/Q _3442_/B input2/X VGND VGND VPWR VPWR _3432_/X sky130_fd_sc_hd__and3_2
X_3363_ _5163_/Q _3352_/B _3361_/X _3362_/X VGND VGND VPWR VPWR _3363_/X sky130_fd_sc_hd__a211o_2
X_5102_ _5114_/CLK _5102_/D VGND VGND VPWR VPWR _5102_/Q sky130_fd_sc_hd__dfxtp_2
XFILLER_57_207 VGND VGND VPWR VPWR sky130_fd_sc_hd__decap_3
X_3294_ _3294_/A _3294_/B VGND VGND VPWR VPWR _3294_/X sky130_fd_sc_hd__or2_2
X_5033_ clkload6/A _5033_/D VGND VGND VPWR VPWR _5033_/Q sky130_fd_sc_hd__dfxtp_2
XFILLER_38_432 VGND VGND VPWR VPWR sky130_fd_sc_hd__fill_1
XFILLER_38_454 VGND VGND VPWR VPWR sky130_fd_sc_hd__decap_3
XTAP_TAPCELL_ROW_0_203 VGND VPWR sky130_fd_sc_hd__tapvpwrvgnd_1
XFILLER_53_402 VGND VGND VPWR VPWR sky130_fd_sc_hd__decap_3
XFILLER_65_284 VGND VGND VPWR VPWR sky130_fd_sc_hd__decap_3
XFILLER_53_479 VGND VGND VPWR VPWR sky130_fd_sc_hd__decap_3
X_4817_ _5238_/Q _4847_/B VGND VGND VPWR VPWR _4817_/X sky130_fd_sc_hd__or2_2
X_4748_ _4786_/A _4743_/Y _4747_/X _4607_/Y _4635_/Y VGND VGND VPWR VPWR _4748_/X
+ sky130_fd_sc_hd__a32o_2
X_4679_ _2443_/Y _2621_/B _4164_/A _4224_/A VGND VGND VPWR VPWR _4679_/X sky130_fd_sc_hd__o2bb2a_2
XPHY_EDGE_ROW_1_Right_1 VGND VGND VPWR VPWR sky130_fd_sc_hd__decap_3
XFILLER_0_203 VGND VGND VPWR VPWR sky130_fd_sc_hd__decap_3
XFILLER_0_225 VGND VGND VPWR VPWR sky130_fd_sc_hd__decap_3
Xoutput59 _5146_/Q VGND VGND VPWR VPWR INSTR_ADDR[13] sky130_fd_sc_hd__clkdlybuf4s25_1
XFILLER_88_354 VGND VGND VPWR VPWR sky130_fd_sc_hd__decap_3
XFILLER_76_505 VGND VGND VPWR VPWR sky130_fd_sc_hd__decap_3
XFILLER_48_218 VGND VGND VPWR VPWR sky130_fd_sc_hd__decap_3
XFILLER_88_387 VGND VGND VPWR VPWR sky130_fd_sc_hd__decap_3
XFILLER_56_56 VGND VGND VPWR VPWR sky130_fd_sc_hd__decap_3
XTAP_TAPCELL_ROW_59_758 VGND VPWR sky130_fd_sc_hd__tapvpwrvgnd_1
XFILLER_56_251 VGND VGND VPWR VPWR sky130_fd_sc_hd__fill_1
XFILLER_56_262 VGND VGND VPWR VPWR sky130_fd_sc_hd__decap_3
XFILLER_44_424 VGND VGND VPWR VPWR sky130_fd_sc_hd__fill_1
XFILLER_56_295 VGND VGND VPWR VPWR sky130_fd_sc_hd__decap_3
XFILLER_71_243 VGND VGND VPWR VPWR sky130_fd_sc_hd__decap_3
XTAP_TAPCELL_ROW_42_603 VGND VPWR sky130_fd_sc_hd__tapvpwrvgnd_1
XFILLER_12_332 VGND VGND VPWR VPWR sky130_fd_sc_hd__decap_3
XFILLER_72_88 VGND VGND VPWR VPWR sky130_fd_sc_hd__decap_3
XTAP_TAPCELL_ROW_14_338 VGND VPWR sky130_fd_sc_hd__tapvpwrvgnd_1
XFILLER_12_365 VGND VGND VPWR VPWR sky130_fd_sc_hd__fill_2
XFILLER_12_387 VGND VGND VPWR VPWR sky130_fd_sc_hd__fill_2
XTAP_TAPCELL_ROW_50_680 VGND VPWR sky130_fd_sc_hd__tapvpwrvgnd_1
XFILLER_79_310 VGND VGND VPWR VPWR sky130_fd_sc_hd__decap_3
XFILLER_67_505 VGND VGND VPWR VPWR sky130_fd_sc_hd__decap_3
XFILLER_79_365 VGND VGND VPWR VPWR sky130_fd_sc_hd__decap_3
XFILLER_39_218 VGND VGND VPWR VPWR sky130_fd_sc_hd__fill_1
XFILLER_67_538 VGND VGND VPWR VPWR sky130_fd_sc_hd__decap_3
XFILLER_11_6 VGND VGND VPWR VPWR sky130_fd_sc_hd__fill_2
XFILLER_47_240 VGND VGND VPWR VPWR sky130_fd_sc_hd__fill_2
XFILLER_35_402 VGND VGND VPWR VPWR sky130_fd_sc_hd__decap_3
XFILLER_47_251 VGND VGND VPWR VPWR sky130_fd_sc_hd__decap_3
XFILLER_35_446 VGND VGND VPWR VPWR sky130_fd_sc_hd__fill_2
XFILLER_47_295 VGND VGND VPWR VPWR sky130_fd_sc_hd__decap_3
XFILLER_62_210 VGND VGND VPWR VPWR sky130_fd_sc_hd__fill_2
XFILLER_50_405 VGND VGND VPWR VPWR sky130_fd_sc_hd__decap_3
X_3981_ _4449_/B _4523_/S VGND VGND VPWR VPWR _3981_/Y sky130_fd_sc_hd__nor2_2
XFILLER_22_129 VGND VGND VPWR VPWR sky130_fd_sc_hd__decap_3
XFILLER_50_427 VGND VGND VPWR VPWR sky130_fd_sc_hd__decap_3
XFILLER_62_276 VGND VGND VPWR VPWR sky130_fd_sc_hd__decap_3
X_2932_ _5201_/Q _2455_/X _3456_/B _5249_/Q _2931_/X VGND VGND VPWR VPWR _2932_/X
+ sky130_fd_sc_hd__a221o_2
X_2863_ _2863_/A _3934_/C VGND VGND VPWR VPWR _2864_/B sky130_fd_sc_hd__xnor2_2
XFILLER_30_195 VGND VGND VPWR VPWR sky130_fd_sc_hd__fill_1
X_4602_ _4492_/A _4569_/B _4568_/A VGND VGND VPWR VPWR _4632_/C sky130_fd_sc_hd__a21oi_2
X_2794_ _5116_/Q _5004_/Q _4988_/Q _4972_/Q _5131_/Q _2848_/S1 VGND VGND VPWR VPWR
+ _2794_/X sky130_fd_sc_hd__mux4_2
X_4533_ _4473_/X _4531_/X _4532_/X _4371_/B VGND VGND VPWR VPWR _4558_/C sky130_fd_sc_hd__a31o_2
X_4464_ _4464_/A _4464_/B VGND VGND VPWR VPWR _4589_/A sky130_fd_sc_hd__or2_2
X_4395_ _4403_/A _4405_/A _4405_/B VGND VGND VPWR VPWR _4397_/B sky130_fd_sc_hd__or3_2
X_3415_ _5154_/Q _3252_/C _3228_/Y _3414_/X VGND VGND VPWR VPWR _5154_/D sky130_fd_sc_hd__o22a_2
X_3346_ _3361_/B _3345_/B _5185_/Q VGND VGND VPWR VPWR _3346_/Y sky130_fd_sc_hd__o21ai_2
XTAP_TAPCELL_ROW_90_1053 VGND VPWR sky130_fd_sc_hd__tapvpwrvgnd_1
XFILLER_58_527 VGND VGND VPWR VPWR sky130_fd_sc_hd__decap_3
XFILLER_85_335 VGND VGND VPWR VPWR sky130_fd_sc_hd__fill_1
XFILLER_73_508 VGND VGND VPWR VPWR sky130_fd_sc_hd__decap_3
X_5016_ _5118_/CLK _5016_/D VGND VGND VPWR VPWR _5016_/Q sky130_fd_sc_hd__dfxtp_2
X_3277_ _2425_/Y _3273_/Y _3276_/X VGND VGND VPWR VPWR _3277_/Y sky130_fd_sc_hd__o21ai_2
XFILLER_85_346 VGND VGND VPWR VPWR sky130_fd_sc_hd__decap_3
XFILLER_38_251 VGND VGND VPWR VPWR sky130_fd_sc_hd__fill_1
XFILLER_85_379 VGND VGND VPWR VPWR sky130_fd_sc_hd__fill_1
XFILLER_26_37 VGND VGND VPWR VPWR sky130_fd_sc_hd__fill_1
XFILLER_53_210 VGND VGND VPWR VPWR sky130_fd_sc_hd__decap_3
XFILLER_81_530 VGND VGND VPWR VPWR sky130_fd_sc_hd__decap_3
XFILLER_26_457 VGND VGND VPWR VPWR sky130_fd_sc_hd__decap_3
XFILLER_41_405 VGND VGND VPWR VPWR sky130_fd_sc_hd__decap_3
XFILLER_53_243 VGND VGND VPWR VPWR sky130_fd_sc_hd__decap_3
XFILLER_41_438 VGND VGND VPWR VPWR sky130_fd_sc_hd__decap_3
XFILLER_41_449 VGND VGND VPWR VPWR sky130_fd_sc_hd__fill_1
XFILLER_53_287 VGND VGND VPWR VPWR sky130_fd_sc_hd__decap_3
XFILLER_42_25 VGND VGND VPWR VPWR sky130_fd_sc_hd__decap_3
XFILLER_42_47 VGND VGND VPWR VPWR sky130_fd_sc_hd__decap_3
XTAP_TAPCELL_ROW_11_308 VGND VPWR sky130_fd_sc_hd__tapvpwrvgnd_1
XFILLER_5_328 VGND VGND VPWR VPWR sky130_fd_sc_hd__decap_3
XFILLER_1_523 VGND VGND VPWR VPWR sky130_fd_sc_hd__decap_3
XFILLER_67_33 VGND VGND VPWR VPWR sky130_fd_sc_hd__decap_3
XFILLER_67_55 VGND VGND VPWR VPWR sky130_fd_sc_hd__fill_1
XFILLER_76_302 VGND VGND VPWR VPWR sky130_fd_sc_hd__decap_3
XFILLER_76_368 VGND VGND VPWR VPWR sky130_fd_sc_hd__decap_3
XFILLER_29_273 VGND VGND VPWR VPWR sky130_fd_sc_hd__decap_3
XFILLER_91_305 VGND VGND VPWR VPWR sky130_fd_sc_hd__decap_3
XFILLER_17_446 VGND VGND VPWR VPWR sky130_fd_sc_hd__fill_2
XFILLER_44_210 VGND VGND VPWR VPWR sky130_fd_sc_hd__decap_3
XFILLER_91_349 VGND VGND VPWR VPWR sky130_fd_sc_hd__decap_3
XFILLER_83_76 VGND VGND VPWR VPWR sky130_fd_sc_hd__decap_3
XFILLER_44_298 VGND VGND VPWR VPWR sky130_fd_sc_hd__decap_3
XFILLER_40_460 VGND VGND VPWR VPWR sky130_fd_sc_hd__fill_1
XFILLER_80_9 VGND VGND VPWR VPWR sky130_fd_sc_hd__decap_3
XFILLER_8_122 VGND VGND VPWR VPWR sky130_fd_sc_hd__decap_3
XFILLER_4_350 VGND VGND VPWR VPWR sky130_fd_sc_hd__decap_3
XFILLER_4_394 VGND VGND VPWR VPWR sky130_fd_sc_hd__decap_3
X_4180_ _4346_/A _4058_/X _4062_/X _3651_/Y _4179_/Y VGND VGND VPWR VPWR _4180_/X
+ sky130_fd_sc_hd__o221a_2
X_3200_ _2926_/X _3203_/A2 _3203_/B1 _5100_/Q VGND VGND VPWR VPWR _5100_/D sky130_fd_sc_hd__a22o_2
XFILLER_79_151 VGND VGND VPWR VPWR sky130_fd_sc_hd__decap_3
XFILLER_79_140 VGND VGND VPWR VPWR sky130_fd_sc_hd__decap_3
XFILLER_67_302 VGND VGND VPWR VPWR sky130_fd_sc_hd__decap_3
X_3131_ _2938_/X _3116_/Y _3133_/B1 _5040_/Q VGND VGND VPWR VPWR _5040_/D sky130_fd_sc_hd__a22o_2
XFILLER_67_335 VGND VGND VPWR VPWR sky130_fd_sc_hd__fill_1
X_3062_ _2891_/X _3074_/A2 _3061_/Y _4979_/Q VGND VGND VPWR VPWR _4979_/D sky130_fd_sc_hd__a22o_2
XFILLER_82_327 VGND VGND VPWR VPWR sky130_fd_sc_hd__decap_3
XFILLER_63_541 VGND VGND VPWR VPWR sky130_fd_sc_hd__decap_3
XTAP_TAPCELL_ROW_53_709 VGND VPWR sky130_fd_sc_hd__tapvpwrvgnd_1
XFILLER_23_427 VGND VGND VPWR VPWR sky130_fd_sc_hd__decap_3
XFILLER_35_287 VGND VGND VPWR VPWR sky130_fd_sc_hd__decap_3
XFILLER_50_213 VGND VGND VPWR VPWR sky130_fd_sc_hd__decap_3
XFILLER_50_224 VGND VGND VPWR VPWR sky130_fd_sc_hd__decap_3
XFILLER_23_449 VGND VGND VPWR VPWR sky130_fd_sc_hd__decap_3
X_3964_ _4449_/B _4787_/S VGND VGND VPWR VPWR _3964_/Y sky130_fd_sc_hd__nor2_2
XFILLER_50_279 VGND VGND VPWR VPWR sky130_fd_sc_hd__decap_3
X_3895_ _4139_/A _3886_/Y _3924_/B _3820_/B VGND VGND VPWR VPWR _3900_/B sky130_fd_sc_hd__o2bb2a_2
X_2915_ _5228_/Q _4850_/A _3458_/B _5212_/Q VGND VGND VPWR VPWR _2915_/X sky130_fd_sc_hd__a22o_2
XFILLER_31_493 VGND VGND VPWR VPWR sky130_fd_sc_hd__decap_3
X_2846_ _2831_/S _2845_/X _5134_/Q VGND VGND VPWR VPWR _2846_/X sky130_fd_sc_hd__o21a_2
X_2777_ _5133_/Q _2776_/X _2437_/Y VGND VGND VPWR VPWR _2777_/X sky130_fd_sc_hd__o21a_2
XFILLER_2_309 VGND VGND VPWR VPWR sky130_fd_sc_hd__fill_1
X_4516_ _4624_/B _4515_/X _4624_/A VGND VGND VPWR VPWR _4655_/B sky130_fd_sc_hd__mux2_1
X_4447_ _4465_/A _4447_/B VGND VGND VPWR VPWR _4451_/A sky130_fd_sc_hd__nor2_2
X_4378_ _4358_/X _4375_/X _4376_/Y _4377_/X _3442_/B VGND VGND VPWR VPWR _5221_/D
+ sky130_fd_sc_hd__o311a_2
XFILLER_58_335 VGND VGND VPWR VPWR sky130_fd_sc_hd__decap_3
X_3329_ _3324_/X _3325_/X _3328_/X VGND VGND VPWR VPWR _3329_/Y sky130_fd_sc_hd__o21ai_2
XTAP_TAPCELL_ROW_69_853 VGND VPWR sky130_fd_sc_hd__tapvpwrvgnd_1
XFILLER_37_36 VGND VGND VPWR VPWR sky130_fd_sc_hd__fill_2
XFILLER_46_519 VGND VGND VPWR VPWR sky130_fd_sc_hd__decap_3
XFILLER_58_368 VGND VGND VPWR VPWR sky130_fd_sc_hd__decap_3
XFILLER_73_305 VGND VGND VPWR VPWR sky130_fd_sc_hd__decap_3
XFILLER_26_221 VGND VGND VPWR VPWR sky130_fd_sc_hd__decap_3
XFILLER_37_69 VGND VGND VPWR VPWR sky130_fd_sc_hd__fill_2
XFILLER_54_530 VGND VGND VPWR VPWR sky130_fd_sc_hd__fill_2
XFILLER_66_390 VGND VGND VPWR VPWR sky130_fd_sc_hd__decap_3
XFILLER_85_198 VGND VGND VPWR VPWR sky130_fd_sc_hd__decap_3
XFILLER_14_416 VGND VGND VPWR VPWR sky130_fd_sc_hd__decap_3
XFILLER_14_427 VGND VGND VPWR VPWR sky130_fd_sc_hd__decap_3
XFILLER_53_46 VGND VGND VPWR VPWR sky130_fd_sc_hd__decap_3
XFILLER_53_57 VGND VGND VPWR VPWR sky130_fd_sc_hd__fill_1
XFILLER_53_79 VGND VGND VPWR VPWR sky130_fd_sc_hd__fill_2
XTAP_TAPCELL_ROW_24_433 VGND VPWR sky130_fd_sc_hd__tapvpwrvgnd_1
XFILLER_81_393 VGND VGND VPWR VPWR sky130_fd_sc_hd__decap_3
XFILLER_22_460 VGND VGND VPWR VPWR sky130_fd_sc_hd__decap_3
XFILLER_5_158 VGND VGND VPWR VPWR sky130_fd_sc_hd__decap_3
XFILLER_5_169 VGND VGND VPWR VPWR sky130_fd_sc_hd__decap_3
XFILLER_78_32 VGND VGND VPWR VPWR sky130_fd_sc_hd__fill_2
XFILLER_49_302 VGND VGND VPWR VPWR sky130_fd_sc_hd__decap_3
XFILLER_49_335 VGND VGND VPWR VPWR sky130_fd_sc_hd__fill_1
XFILLER_49_346 VGND VGND VPWR VPWR sky130_fd_sc_hd__decap_3
XFILLER_76_121 VGND VGND VPWR VPWR sky130_fd_sc_hd__decap_3
XFILLER_49_379 VGND VGND VPWR VPWR sky130_fd_sc_hd__decap_3
XFILLER_64_327 VGND VGND VPWR VPWR sky130_fd_sc_hd__decap_3
XFILLER_91_113 VGND VGND VPWR VPWR sky130_fd_sc_hd__fill_1
XFILLER_27_80 VGND VGND VPWR VPWR sky130_fd_sc_hd__decap_3
XFILLER_17_287 VGND VGND VPWR VPWR sky130_fd_sc_hd__fill_2
XFILLER_72_382 VGND VGND VPWR VPWR sky130_fd_sc_hd__fill_2
XFILLER_60_544 VGND VGND VPWR VPWR sky130_fd_sc_hd__decap_3
XFILLER_13_460 VGND VGND VPWR VPWR sky130_fd_sc_hd__decap_3
X_2700_ _3457_/A _2701_/B VGND VGND VPWR VPWR _2700_/Y sky130_fd_sc_hd__nor2_2
XFILLER_9_431 VGND VGND VPWR VPWR sky130_fd_sc_hd__fill_1
XFILLER_40_290 VGND VGND VPWR VPWR sky130_fd_sc_hd__decap_3
X_3680_ _4292_/A _3680_/B VGND VGND VPWR VPWR _4312_/A sky130_fd_sc_hd__or2_2
X_2631_ _2629_/X _2630_/X _5125_/Q VGND VGND VPWR VPWR _2631_/X sky130_fd_sc_hd__mux2_1
X_2562_ _2562_/A _2562_/B VGND VGND VPWR VPWR _3874_/A sky130_fd_sc_hd__nor2_2
X_4301_ _4291_/A _3998_/Y _4000_/X _4292_/A _4300_/X VGND VGND VPWR VPWR _4301_/X
+ sky130_fd_sc_hd__a221o_2
X_4232_ _5176_/Q _4717_/S _4716_/A _3999_/B VGND VGND VPWR VPWR _4232_/X sky130_fd_sc_hd__a211o_2
X_2493_ _5125_/Q _2493_/B VGND VGND VPWR VPWR _2493_/X sky130_fd_sc_hd__or2_2
XFILLER_87_408 VGND VGND VPWR VPWR sky130_fd_sc_hd__decap_3
X_4163_ _4115_/A _2866_/B _4156_/X _4162_/Y VGND VGND VPWR VPWR _4163_/X sky130_fd_sc_hd__o211a_2
XFILLER_28_508 VGND VGND VPWR VPWR sky130_fd_sc_hd__decap_3
XFILLER_67_154 VGND VGND VPWR VPWR sky130_fd_sc_hd__decap_3
X_4094_ _4091_/A _4091_/B _4608_/B VGND VGND VPWR VPWR _4095_/B sky130_fd_sc_hd__a21o_2
X_3114_ _2941_/X _3098_/Y _3099_/Y _5025_/Q VGND VGND VPWR VPWR _5025_/D sky130_fd_sc_hd__a22o_2
XFILLER_55_327 VGND VGND VPWR VPWR sky130_fd_sc_hd__decap_3
X_3045_ _2900_/X _3056_/A2 _3043_/Y _4964_/Q VGND VGND VPWR VPWR _4964_/D sky130_fd_sc_hd__a22o_2
XFILLER_36_552 VGND VGND VPWR VPWR sky130_fd_sc_hd__fill_1
XTAP_TAPCELL_ROW_38_558 VGND VPWR sky130_fd_sc_hd__tapvpwrvgnd_1
XFILLER_82_157 VGND VGND VPWR VPWR sky130_fd_sc_hd__decap_3
XFILLER_51_500 VGND VGND VPWR VPWR sky130_fd_sc_hd__decap_3
XFILLER_63_393 VGND VGND VPWR VPWR sky130_fd_sc_hd__decap_3
X_4996_ _5119_/CLK _4996_/D VGND VGND VPWR VPWR _4996_/Q sky130_fd_sc_hd__dfxtp_2
XFILLER_23_268 VGND VGND VPWR VPWR sky130_fd_sc_hd__decap_3
X_3947_ _5165_/Q _4341_/A _4313_/A VGND VGND VPWR VPWR _3947_/X sky130_fd_sc_hd__o21a_2
XTAP_TAPCELL_ROW_21_403 VGND VPWR sky130_fd_sc_hd__tapvpwrvgnd_1
X_3878_ _3992_/B _3866_/Y _3868_/B _3877_/X VGND VGND VPWR VPWR _3880_/C sky130_fd_sc_hd__a31o_2
X_2829_ _4960_/Q _4944_/Q _4928_/Q _4912_/Q _5131_/Q _2848_/S1 VGND VGND VPWR VPWR
+ _2829_/X sky130_fd_sc_hd__mux4_2
XFILLER_78_408 VGND VGND VPWR VPWR sky130_fd_sc_hd__fill_1
XFILLER_86_430 VGND VGND VPWR VPWR sky130_fd_sc_hd__decap_3
XFILLER_48_68 VGND VGND VPWR VPWR sky130_fd_sc_hd__fill_2
XFILLER_46_338 VGND VGND VPWR VPWR sky130_fd_sc_hd__decap_3
XFILLER_58_187 VGND VGND VPWR VPWR sky130_fd_sc_hd__fill_1
XFILLER_73_113 VGND VGND VPWR VPWR sky130_fd_sc_hd__decap_3
XFILLER_27_552 VGND VGND VPWR VPWR sky130_fd_sc_hd__fill_1
XFILLER_73_157 VGND VGND VPWR VPWR sky130_fd_sc_hd__decap_3
XFILLER_54_371 VGND VGND VPWR VPWR sky130_fd_sc_hd__decap_3
XFILLER_64_56 VGND VGND VPWR VPWR sky130_fd_sc_hd__decap_3
XFILLER_14_235 VGND VGND VPWR VPWR sky130_fd_sc_hd__fill_1
XFILLER_42_533 VGND VGND VPWR VPWR sky130_fd_sc_hd__decap_3
XFILLER_14_268 VGND VGND VPWR VPWR sky130_fd_sc_hd__fill_1
Xclkbuf_2_3__f_CLK clkbuf_0_CLK/X VGND VGND VPWR VPWR clkload2/A sky130_fd_sc_hd__clkbuf_16
XFILLER_80_44 VGND VGND VPWR VPWR sky130_fd_sc_hd__fill_1
XFILLER_10_430 VGND VGND VPWR VPWR sky130_fd_sc_hd__fill_2
XFILLER_6_401 VGND VGND VPWR VPWR sky130_fd_sc_hd__decap_3
XFILLER_80_88 VGND VGND VPWR VPWR sky130_fd_sc_hd__fill_1
XFILLER_10_485 VGND VGND VPWR VPWR sky130_fd_sc_hd__decap_3
XFILLER_13_71 VGND VGND VPWR VPWR sky130_fd_sc_hd__fill_2
XFILLER_6_456 VGND VGND VPWR VPWR sky130_fd_sc_hd__fill_2
XFILLER_69_408 VGND VGND VPWR VPWR sky130_fd_sc_hd__fill_2
XFILLER_89_97 VGND VGND VPWR VPWR sky130_fd_sc_hd__fill_1
XFILLER_1_150 VGND VGND VPWR VPWR sky130_fd_sc_hd__fill_1
XTAP_TAPCELL_ROW_9_283 VGND VPWR sky130_fd_sc_hd__tapvpwrvgnd_1
XFILLER_89_290 VGND VGND VPWR VPWR sky130_fd_sc_hd__fill_2
XFILLER_77_441 VGND VGND VPWR VPWR sky130_fd_sc_hd__decap_3
XFILLER_77_452 VGND VGND VPWR VPWR sky130_fd_sc_hd__decap_3
XFILLER_37_349 VGND VGND VPWR VPWR sky130_fd_sc_hd__decap_3
XFILLER_18_552 VGND VGND VPWR VPWR sky130_fd_sc_hd__fill_1
XTAP_TAPCELL_ROW_63_804 VGND VPWR sky130_fd_sc_hd__tapvpwrvgnd_1
XFILLER_92_477 VGND VGND VPWR VPWR sky130_fd_sc_hd__decap_3
XFILLER_92_466 VGND VGND VPWR VPWR sky130_fd_sc_hd__decap_3
XFILLER_33_511 VGND VGND VPWR VPWR sky130_fd_sc_hd__fill_2
XFILLER_64_179 VGND VGND VPWR VPWR sky130_fd_sc_hd__decap_3
XFILLER_33_533 VGND VGND VPWR VPWR sky130_fd_sc_hd__decap_3
XFILLER_45_382 VGND VGND VPWR VPWR sky130_fd_sc_hd__decap_3
XFILLER_45_393 VGND VGND VPWR VPWR sky130_fd_sc_hd__decap_3
X_4850_ _4850_/A _4850_/B VGND VGND VPWR VPWR _4850_/X sky130_fd_sc_hd__or2_2
X_3801_ _3799_/X _3800_/X _5129_/Q VGND VGND VPWR VPWR _3801_/X sky130_fd_sc_hd__mux2_1
X_4781_ _4547_/A _2502_/Y _3680_/B _4224_/A _4780_/X VGND VGND VPWR VPWR _4781_/X
+ sky130_fd_sc_hd__o221a_2
XFILLER_20_249 VGND VGND VPWR VPWR sky130_fd_sc_hd__decap_3
X_3732_ _5179_/Q _5178_/Q _5177_/Q _5176_/Q VGND VGND VPWR VPWR _3847_/A sky130_fd_sc_hd__or4_2
Xclkload20 _5253_/CLK VGND VGND VPWR VPWR clkload20/X sky130_fd_sc_hd__clkbuf_8
X_3663_ _4464_/B _4464_/A _4010_/S VGND VGND VPWR VPWR _3663_/X sky130_fd_sc_hd__mux2_1
Xclkload31 _5109_/CLK VGND VGND VPWR VPWR clkload31/X sky130_fd_sc_hd__clkbuf_4
X_2614_ _2859_/A _3876_/A _2573_/Y VGND VGND VPWR VPWR _2861_/B sky130_fd_sc_hd__a21bo_2
X_3594_ _4950_/Q _4934_/Q _4918_/Q _4902_/Q _3834_/S0 _3834_/S1 VGND VGND VPWR VPWR
+ _3594_/X sky130_fd_sc_hd__mux4_2
X_2545_ _2539_/X _2541_/X _2544_/X _2435_/Y VGND VGND VPWR VPWR _3924_/B sky130_fd_sc_hd__a22oi_2
X_2476_ _4614_/A VGND VGND VPWR VPWR _4473_/A sky130_fd_sc_hd__inv_2
XFILLER_87_216 VGND VGND VPWR VPWR sky130_fd_sc_hd__decap_3
X_4215_ _4700_/S _4215_/B VGND VGND VPWR VPWR _4215_/Y sky130_fd_sc_hd__nand2_2
X_5195_ _5263_/CLK _5195_/D VGND VGND VPWR VPWR _5195_/Q sky130_fd_sc_hd__dfxtp_2
X_4146_ _5211_/Q _4168_/A _4144_/Y _4145_/Y _3448_/B VGND VGND VPWR VPWR _5211_/D
+ sky130_fd_sc_hd__o221a_2
XFILLER_55_113 VGND VGND VPWR VPWR sky130_fd_sc_hd__fill_2
XFILLER_55_124 VGND VGND VPWR VPWR sky130_fd_sc_hd__decap_3
XFILLER_68_485 VGND VGND VPWR VPWR sky130_fd_sc_hd__decap_3
XTAP_TAPCELL_ROW_87_1025 VGND VPWR sky130_fd_sc_hd__tapvpwrvgnd_1
XFILLER_43_308 VGND VGND VPWR VPWR sky130_fd_sc_hd__decap_3
X_4077_ _4009_/X _4007_/X _4077_/S VGND VGND VPWR VPWR _4077_/X sky130_fd_sc_hd__mux2_1
XFILLER_83_455 VGND VGND VPWR VPWR sky130_fd_sc_hd__fill_2
X_3028_ _2906_/X _3024_/B _3024_/Y _4950_/Q VGND VGND VPWR VPWR _4950_/D sky130_fd_sc_hd__a22o_2
XFILLER_83_477 VGND VGND VPWR VPWR sky130_fd_sc_hd__decap_3
XFILLER_24_544 VGND VGND VPWR VPWR sky130_fd_sc_hd__decap_3
XFILLER_70_149 VGND VGND VPWR VPWR sky130_fd_sc_hd__decap_3
XFILLER_34_48 VGND VGND VPWR VPWR sky130_fd_sc_hd__fill_1
XFILLER_51_363 VGND VGND VPWR VPWR sky130_fd_sc_hd__decap_3
XFILLER_51_396 VGND VGND VPWR VPWR sky130_fd_sc_hd__decap_3
X_4979_ _5112_/CLK _4979_/D VGND VGND VPWR VPWR _4979_/Q sky130_fd_sc_hd__dfxtp_2
Xclkload3 clkload3/A VGND VGND VPWR VPWR clkload3/X sky130_fd_sc_hd__clkbuf_4
XFILLER_50_25 VGND VGND VPWR VPWR sky130_fd_sc_hd__decap_3
XFILLER_50_47 VGND VGND VPWR VPWR sky130_fd_sc_hd__decap_3
XFILLER_59_45 VGND VGND VPWR VPWR sky130_fd_sc_hd__decap_3
XFILLER_59_78 VGND VGND VPWR VPWR sky130_fd_sc_hd__decap_3
XFILLER_59_452 VGND VGND VPWR VPWR sky130_fd_sc_hd__fill_1
XTAP_TAPCELL_ROW_77_929 VGND VPWR sky130_fd_sc_hd__tapvpwrvgnd_1
XFILLER_19_327 VGND VGND VPWR VPWR sky130_fd_sc_hd__decap_3
XFILLER_74_411 VGND VGND VPWR VPWR sky130_fd_sc_hd__decap_3
XFILLER_75_33 VGND VGND VPWR VPWR sky130_fd_sc_hd__decap_3
XFILLER_86_282 VGND VGND VPWR VPWR sky130_fd_sc_hd__decap_3
XFILLER_75_55 VGND VGND VPWR VPWR sky130_fd_sc_hd__fill_1
XFILLER_19_349 VGND VGND VPWR VPWR sky130_fd_sc_hd__decap_3
XFILLER_46_135 VGND VGND VPWR VPWR sky130_fd_sc_hd__decap_3
XFILLER_46_157 VGND VGND VPWR VPWR sky130_fd_sc_hd__decap_3
XFILLER_15_511 VGND VGND VPWR VPWR sky130_fd_sc_hd__fill_1
XFILLER_61_116 VGND VGND VPWR VPWR sky130_fd_sc_hd__decap_3
XFILLER_15_544 VGND VGND VPWR VPWR sky130_fd_sc_hd__decap_3
XFILLER_42_363 VGND VGND VPWR VPWR sky130_fd_sc_hd__fill_1
XTAP_TAPCELL_ROW_32_509 VGND VPWR sky130_fd_sc_hd__tapvpwrvgnd_1
XFILLER_42_374 VGND VGND VPWR VPWR sky130_fd_sc_hd__decap_3
XTAP_TAPCELL_ROW_40_586 VGND VPWR sky130_fd_sc_hd__tapvpwrvgnd_1
XFILLER_10_282 VGND VGND VPWR VPWR sky130_fd_sc_hd__decap_3
XFILLER_6_242 VGND VGND VPWR VPWR sky130_fd_sc_hd__decap_3
XFILLER_6_253 VGND VGND VPWR VPWR sky130_fd_sc_hd__decap_3
XFILLER_40_91 VGND VGND VPWR VPWR sky130_fd_sc_hd__decap_3
X_4000_ _5178_/Q _4001_/B VGND VGND VPWR VPWR _4000_/X sky130_fd_sc_hd__and2_2
XFILLER_84_219 VGND VGND VPWR VPWR sky130_fd_sc_hd__decap_3
XFILLER_1_30 VGND VGND VPWR VPWR sky130_fd_sc_hd__decap_3
XFILLER_37_113 VGND VGND VPWR VPWR sky130_fd_sc_hd__decap_3
XFILLER_65_411 VGND VGND VPWR VPWR sky130_fd_sc_hd__decap_3
XFILLER_77_271 VGND VGND VPWR VPWR sky130_fd_sc_hd__fill_2
XFILLER_1_74 VGND VGND VPWR VPWR sky130_fd_sc_hd__decap_3
XTAP_TAPCELL_ROW_48_653 VGND VPWR sky130_fd_sc_hd__tapvpwrvgnd_1
XFILLER_77_293 VGND VGND VPWR VPWR sky130_fd_sc_hd__decap_3
XFILLER_92_274 VGND VGND VPWR VPWR sky130_fd_sc_hd__decap_3
XFILLER_80_403 VGND VGND VPWR VPWR sky130_fd_sc_hd__decap_3
XFILLER_18_393 VGND VGND VPWR VPWR sky130_fd_sc_hd__decap_3
XFILLER_33_330 VGND VGND VPWR VPWR sky130_fd_sc_hd__decap_3
XFILLER_52_127 VGND VGND VPWR VPWR sky130_fd_sc_hd__decap_3
X_4902_ _5111_/CLK _4902_/D VGND VGND VPWR VPWR _4902_/Q sky130_fd_sc_hd__dfxtp_2
XFILLER_80_458 VGND VGND VPWR VPWR sky130_fd_sc_hd__decap_3
XFILLER_21_503 VGND VGND VPWR VPWR sky130_fd_sc_hd__fill_1
XFILLER_33_352 VGND VGND VPWR VPWR sky130_fd_sc_hd__decap_3
XFILLER_21_547 VGND VGND VPWR VPWR sky130_fd_sc_hd__decap_3
XFILLER_33_385 VGND VGND VPWR VPWR sky130_fd_sc_hd__decap_3
XFILLER_60_182 VGND VGND VPWR VPWR sky130_fd_sc_hd__decap_3
X_4833_ _5246_/Q _4847_/B VGND VGND VPWR VPWR _4833_/X sky130_fd_sc_hd__or2_2
X_4764_ _4547_/A _4115_/A _4764_/S VGND VGND VPWR VPWR _4764_/X sky130_fd_sc_hd__mux2_1
X_3715_ _4750_/S _4287_/A VGND VGND VPWR VPWR _4285_/B sky130_fd_sc_hd__or2_2
X_4695_ _4695_/A VGND VGND VPWR VPWR _4695_/Y sky130_fd_sc_hd__inv_2
X_3646_ _4063_/A _3641_/X _4346_/A _3640_/X VGND VGND VPWR VPWR _3646_/X sky130_fd_sc_hd__a211o_2
X_3577_ _3577_/A _3577_/B _3577_/C VGND VGND VPWR VPWR _3577_/Y sky130_fd_sc_hd__nor3_2
X_2528_ _4889_/Q _4873_/Q _5097_/Q _5081_/Q _5123_/Q _2671_/S1 VGND VGND VPWR VPWR
+ _2529_/B sky130_fd_sc_hd__mux4_2
XTAP_TAPCELL_ROW_93_1084 VGND VPWR sky130_fd_sc_hd__tapvpwrvgnd_1
XFILLER_88_525 VGND VGND VPWR VPWR sky130_fd_sc_hd__decap_3
X_5247_ _5251_/CLK _5247_/D VGND VGND VPWR VPWR _5247_/Q sky130_fd_sc_hd__dfxtp_2
XTAP_TAPCELL_ROW_93_1095 VGND VPWR sky130_fd_sc_hd__tapvpwrvgnd_1
XFILLER_88_547 VGND VGND VPWR VPWR sky130_fd_sc_hd__decap_3
X_2459_ _3457_/A _3457_/B _2458_/X VGND VGND VPWR VPWR _2459_/Y sky130_fd_sc_hd__o21ai_2
XFILLER_68_271 VGND VGND VPWR VPWR sky130_fd_sc_hd__decap_3
X_5178_ _5251_/CLK _5178_/D VGND VGND VPWR VPWR _5178_/Q sky130_fd_sc_hd__dfxtp_2
XTAP_TAPCELL_ROW_3_234 VGND VPWR sky130_fd_sc_hd__tapvpwrvgnd_1
XFILLER_28_135 VGND VGND VPWR VPWR sky130_fd_sc_hd__decap_3
XFILLER_68_293 VGND VGND VPWR VPWR sky130_fd_sc_hd__fill_1
X_4129_ _3651_/Y _3954_/X _4320_/B _4107_/X VGND VGND VPWR VPWR _4129_/X sky130_fd_sc_hd__o22a_2
XFILLER_45_14 VGND VGND VPWR VPWR sky130_fd_sc_hd__fill_2
XFILLER_56_477 VGND VGND VPWR VPWR sky130_fd_sc_hd__decap_3
XFILLER_71_414 VGND VGND VPWR VPWR sky130_fd_sc_hd__decap_3
XFILLER_71_447 VGND VGND VPWR VPWR sky130_fd_sc_hd__fill_1
XFILLER_12_503 VGND VGND VPWR VPWR sky130_fd_sc_hd__decap_3
XTAP_TAPCELL_ROW_82_976 VGND VPWR sky130_fd_sc_hd__tapvpwrvgnd_1
XFILLER_24_374 VGND VGND VPWR VPWR sky130_fd_sc_hd__fill_1
XFILLER_12_547 VGND VGND VPWR VPWR sky130_fd_sc_hd__decap_3
XFILLER_61_57 VGND VGND VPWR VPWR sky130_fd_sc_hd__decap_3
XFILLER_10_72 VGND VGND VPWR VPWR sky130_fd_sc_hd__decap_3
XFILLER_79_514 VGND VGND VPWR VPWR sky130_fd_sc_hd__decap_3
XFILLER_66_208 VGND VGND VPWR VPWR sky130_fd_sc_hd__decap_3
XFILLER_47_400 VGND VGND VPWR VPWR sky130_fd_sc_hd__decap_3
XFILLER_47_455 VGND VGND VPWR VPWR sky130_fd_sc_hd__decap_3
XFILLER_34_127 VGND VGND VPWR VPWR sky130_fd_sc_hd__decap_3
XFILLER_30_388 VGND VGND VPWR VPWR sky130_fd_sc_hd__decap_3
X_3500_ _5156_/Q _5137_/Q VGND VGND VPWR VPWR _3501_/B sky130_fd_sc_hd__or2_2
XFILLER_7_551 VGND VGND VPWR VPWR sky130_fd_sc_hd__fill_2
X_4480_ _4249_/A _4479_/A _4478_/Y _4445_/B VGND VGND VPWR VPWR _4480_/X sky130_fd_sc_hd__o22a_2
X_3431_ _4714_/A _3431_/B VGND VGND VPWR VPWR _5161_/D sky130_fd_sc_hd__nor2_2
X_3362_ _5163_/Q _3352_/B _3353_/A VGND VGND VPWR VPWR _3362_/X sky130_fd_sc_hd__o21a_2
X_5101_ _5210_/CLK _5101_/D VGND VGND VPWR VPWR _5101_/Q sky130_fd_sc_hd__dfxtp_2
X_3293_ _3293_/A _3293_/B VGND VGND VPWR VPWR _3293_/Y sky130_fd_sc_hd__nor2_2
XFILLER_85_517 VGND VGND VPWR VPWR sky130_fd_sc_hd__decap_3
X_5032_ _5094_/CLK _5032_/D VGND VGND VPWR VPWR _5032_/Q sky130_fd_sc_hd__dfxtp_2
XFILLER_38_466 VGND VGND VPWR VPWR sky130_fd_sc_hd__decap_3
XFILLER_38_477 VGND VGND VPWR VPWR sky130_fd_sc_hd__decap_3
XFILLER_53_414 VGND VGND VPWR VPWR sky130_fd_sc_hd__decap_3
XTAP_TAPCELL_ROW_0_204 VGND VPWR sky130_fd_sc_hd__tapvpwrvgnd_1
XPHY_EDGE_ROW_69_Left_163 VGND VGND VPWR VPWR sky130_fd_sc_hd__decap_3
XFILLER_80_200 VGND VGND VPWR VPWR sky130_fd_sc_hd__fill_1
XFILLER_53_458 VGND VGND VPWR VPWR sky130_fd_sc_hd__decap_3
XFILLER_61_491 VGND VGND VPWR VPWR sky130_fd_sc_hd__decap_3
X_4816_ _5254_/Q _5259_/Q VGND VGND VPWR VPWR _4816_/Y sky130_fd_sc_hd__nand2_2
X_4747_ _4804_/A _4804_/B VGND VGND VPWR VPWR _4747_/X sky130_fd_sc_hd__or2_2
XPHY_EDGE_ROW_78_Left_172 VGND VGND VPWR VPWR sky130_fd_sc_hd__decap_3
X_4678_ _4115_/A _2621_/B _3791_/Y _4546_/A VGND VGND VPWR VPWR _4678_/X sky130_fd_sc_hd__o22a_2
X_3629_ _3917_/B _4479_/B _3634_/S VGND VGND VPWR VPWR _3629_/X sky130_fd_sc_hd__mux2_1
XFILLER_88_300 VGND VGND VPWR VPWR sky130_fd_sc_hd__decap_3
XFILLER_0_237 VGND VGND VPWR VPWR sky130_fd_sc_hd__decap_3
XFILLER_0_259 VGND VGND VPWR VPWR sky130_fd_sc_hd__decap_3
XFILLER_29_455 VGND VGND VPWR VPWR sky130_fd_sc_hd__decap_3
XFILLER_56_24 VGND VGND VPWR VPWR sky130_fd_sc_hd__decap_3
XFILLER_56_35 VGND VGND VPWR VPWR sky130_fd_sc_hd__decap_3
XTAP_TAPCELL_ROW_59_759 VGND VPWR sky130_fd_sc_hd__tapvpwrvgnd_1
XPHY_EDGE_ROW_87_Left_181 VGND VGND VPWR VPWR sky130_fd_sc_hd__decap_3
XFILLER_29_477 VGND VGND VPWR VPWR sky130_fd_sc_hd__decap_3
XFILLER_56_274 VGND VGND VPWR VPWR sky130_fd_sc_hd__decap_3
XFILLER_56_68 VGND VGND VPWR VPWR sky130_fd_sc_hd__decap_3
XFILLER_71_200 VGND VGND VPWR VPWR sky130_fd_sc_hd__decap_3
XFILLER_44_436 VGND VGND VPWR VPWR sky130_fd_sc_hd__decap_3
XFILLER_44_469 VGND VGND VPWR VPWR sky130_fd_sc_hd__decap_3
XTAP_TAPCELL_ROW_42_604 VGND VPWR sky130_fd_sc_hd__tapvpwrvgnd_1
XFILLER_52_480 VGND VGND VPWR VPWR sky130_fd_sc_hd__decap_3
XFILLER_71_288 VGND VGND VPWR VPWR sky130_fd_sc_hd__fill_2
XFILLER_12_344 VGND VGND VPWR VPWR sky130_fd_sc_hd__decap_3
XTAP_TAPCELL_ROW_14_339 VGND VPWR sky130_fd_sc_hd__tapvpwrvgnd_1
XTAP_TAPCELL_ROW_50_681 VGND VPWR sky130_fd_sc_hd__tapvpwrvgnd_1
XFILLER_8_359 VGND VGND VPWR VPWR sky130_fd_sc_hd__decap_3
XFILLER_21_60 VGND VGND VPWR VPWR sky130_fd_sc_hd__decap_3
Xclkbuf_leaf_40_CLK clkbuf_leaf_8_CLK/A VGND VGND VPWR VPWR _5122_/CLK sky130_fd_sc_hd__clkbuf_8
XFILLER_67_517 VGND VGND VPWR VPWR sky130_fd_sc_hd__decap_3
XFILLER_79_377 VGND VGND VPWR VPWR sky130_fd_sc_hd__fill_1
XFILLER_35_414 VGND VGND VPWR VPWR sky130_fd_sc_hd__decap_3
XFILLER_47_263 VGND VGND VPWR VPWR sky130_fd_sc_hd__decap_3
XFILLER_62_233 VGND VGND VPWR VPWR sky130_fd_sc_hd__decap_3
XFILLER_35_458 VGND VGND VPWR VPWR sky130_fd_sc_hd__fill_1
X_3980_ _3979_/X _4173_/A VGND VGND VPWR VPWR _3980_/Y sky130_fd_sc_hd__nand2b_2
XFILLER_43_480 VGND VGND VPWR VPWR sky130_fd_sc_hd__fill_1
XFILLER_50_417 VGND VGND VPWR VPWR sky130_fd_sc_hd__decap_3
XFILLER_50_439 VGND VGND VPWR VPWR sky130_fd_sc_hd__fill_1
X_2931_ _5233_/Q _4850_/A _3458_/B _5217_/Q VGND VGND VPWR VPWR _2931_/X sky130_fd_sc_hd__a22o_2
X_4601_ _4500_/A _4500_/B _4563_/A _4564_/Y VGND VGND VPWR VPWR _4632_/B sky130_fd_sc_hd__o31a_2
X_2862_ _2887_/B _4115_/B VGND VGND VPWR VPWR _2862_/Y sky130_fd_sc_hd__nor2_2
X_2793_ _4956_/Q _4940_/Q _4924_/Q _4908_/Q _5131_/Q _2848_/S1 VGND VGND VPWR VPWR
+ _2793_/X sky130_fd_sc_hd__mux4_2
X_4532_ _4532_/A _4588_/A _4551_/A VGND VGND VPWR VPWR _4532_/X sky130_fd_sc_hd__or3b_2
XFILLER_7_51 VGND VGND VPWR VPWR sky130_fd_sc_hd__decap_3
X_4463_ _4642_/A _4427_/X _4512_/A _4462_/X VGND VGND VPWR VPWR _4486_/C sky130_fd_sc_hd__o22a_2
XFILLER_7_381 VGND VGND VPWR VPWR sky130_fd_sc_hd__decap_3
X_3414_ _5260_/Q _3448_/B _3414_/C VGND VGND VPWR VPWR _3414_/X sky130_fd_sc_hd__and3_2
X_4394_ _4405_/A _4405_/B VGND VGND VPWR VPWR _4406_/A sky130_fd_sc_hd__nor2_2
Xclkbuf_leaf_31_CLK clkload2/A VGND VGND VPWR VPWR _5100_/CLK sky130_fd_sc_hd__clkbuf_8
XPHY_EDGE_ROW_15_Right_15 VGND VGND VPWR VPWR sky130_fd_sc_hd__decap_3
XFILLER_58_506 VGND VGND VPWR VPWR sky130_fd_sc_hd__decap_3
X_3345_ _3361_/B _3345_/B VGND VGND VPWR VPWR _3353_/B sky130_fd_sc_hd__and2_2
XTAP_TAPCELL_ROW_90_1054 VGND VPWR sky130_fd_sc_hd__tapvpwrvgnd_1
XFILLER_58_539 VGND VGND VPWR VPWR sky130_fd_sc_hd__decap_3
X_3276_ _5185_/Q _3286_/B _3275_/Y _3265_/B VGND VGND VPWR VPWR _3276_/X sky130_fd_sc_hd__o31a_2
X_5015_ _5100_/CLK _5015_/D VGND VGND VPWR VPWR _5015_/Q sky130_fd_sc_hd__dfxtp_2
XTAP_TAPCELL_ROW_56_729 VGND VPWR sky130_fd_sc_hd__tapvpwrvgnd_1
XFILLER_26_27 VGND VGND VPWR VPWR sky130_fd_sc_hd__fill_1
XFILLER_53_222 VGND VGND VPWR VPWR sky130_fd_sc_hd__fill_2
XFILLER_93_380 VGND VGND VPWR VPWR sky130_fd_sc_hd__decap_3
XFILLER_26_469 VGND VGND VPWR VPWR sky130_fd_sc_hd__decap_3
XFILLER_53_255 VGND VGND VPWR VPWR sky130_fd_sc_hd__decap_3
XPHY_EDGE_ROW_24_Right_24 VGND VGND VPWR VPWR sky130_fd_sc_hd__decap_3
XFILLER_81_542 VGND VGND VPWR VPWR sky130_fd_sc_hd__decap_3
XFILLER_13_108 VGND VGND VPWR VPWR sky130_fd_sc_hd__decap_3
XFILLER_41_417 VGND VGND VPWR VPWR sky130_fd_sc_hd__decap_3
XFILLER_53_277 VGND VGND VPWR VPWR sky130_fd_sc_hd__decap_3
XFILLER_34_480 VGND VGND VPWR VPWR sky130_fd_sc_hd__fill_2
XFILLER_42_37 VGND VGND VPWR VPWR sky130_fd_sc_hd__decap_3
XTAP_TAPCELL_ROW_11_309 VGND VPWR sky130_fd_sc_hd__tapvpwrvgnd_1
XPHY_EDGE_ROW_33_Right_33 VGND VGND VPWR VPWR sky130_fd_sc_hd__decap_3
Xclkbuf_leaf_22_CLK clkload2/A VGND VGND VPWR VPWR _5094_/CLK sky130_fd_sc_hd__clkbuf_8
XFILLER_49_517 VGND VGND VPWR VPWR sky130_fd_sc_hd__decap_3
XFILLER_76_358 VGND VGND VPWR VPWR sky130_fd_sc_hd__decap_3
XFILLER_72_531 VGND VGND VPWR VPWR sky130_fd_sc_hd__fill_1
XPHY_EDGE_ROW_42_Right_42 VGND VGND VPWR VPWR sky130_fd_sc_hd__decap_3
XFILLER_84_380 VGND VGND VPWR VPWR sky130_fd_sc_hd__decap_3
XFILLER_83_44 VGND VGND VPWR VPWR sky130_fd_sc_hd__decap_3
XFILLER_17_458 VGND VGND VPWR VPWR sky130_fd_sc_hd__decap_3
XFILLER_44_244 VGND VGND VPWR VPWR sky130_fd_sc_hd__decap_3
XFILLER_72_542 VGND VGND VPWR VPWR sky130_fd_sc_hd__decap_3
XFILLER_16_71 VGND VGND VPWR VPWR sky130_fd_sc_hd__decap_3
XFILLER_16_82 VGND VGND VPWR VPWR sky130_fd_sc_hd__fill_2
XFILLER_12_130 VGND VGND VPWR VPWR sky130_fd_sc_hd__fill_1
XFILLER_12_141 VGND VGND VPWR VPWR sky130_fd_sc_hd__decap_3
XFILLER_12_185 VGND VGND VPWR VPWR sky130_fd_sc_hd__decap_3
XFILLER_40_483 VGND VGND VPWR VPWR sky130_fd_sc_hd__decap_3
XPHY_EDGE_ROW_51_Right_51 VGND VGND VPWR VPWR sky130_fd_sc_hd__decap_3
XFILLER_8_178 VGND VGND VPWR VPWR sky130_fd_sc_hd__fill_1
Xclkbuf_leaf_13_CLK clkload0/A VGND VGND VPWR VPWR _5262_/CLK sky130_fd_sc_hd__clkbuf_8
XFILLER_67_314 VGND VGND VPWR VPWR sky130_fd_sc_hd__decap_3
X_3130_ _2935_/X _3117_/B _3117_/Y _5039_/Q VGND VGND VPWR VPWR _5039_/D sky130_fd_sc_hd__a22o_2
XFILLER_79_185 VGND VGND VPWR VPWR sky130_fd_sc_hd__fill_1
X_3061_ _4866_/A _3061_/B VGND VGND VPWR VPWR _3061_/Y sky130_fd_sc_hd__nor2_2
XPHY_EDGE_ROW_60_Right_60 VGND VGND VPWR VPWR sky130_fd_sc_hd__decap_3
XFILLER_35_200 VGND VGND VPWR VPWR sky130_fd_sc_hd__decap_3
XFILLER_63_520 VGND VGND VPWR VPWR sky130_fd_sc_hd__decap_3
XFILLER_75_391 VGND VGND VPWR VPWR sky130_fd_sc_hd__fill_1
XFILLER_82_339 VGND VGND VPWR VPWR sky130_fd_sc_hd__decap_3
XFILLER_90_350 VGND VGND VPWR VPWR sky130_fd_sc_hd__fill_1
XFILLER_23_439 VGND VGND VPWR VPWR sky130_fd_sc_hd__decap_3
XFILLER_16_480 VGND VGND VPWR VPWR sky130_fd_sc_hd__decap_3
XFILLER_35_299 VGND VGND VPWR VPWR sky130_fd_sc_hd__decap_3
XFILLER_50_236 VGND VGND VPWR VPWR sky130_fd_sc_hd__decap_3
X_3963_ _3960_/X _3962_/Y _4063_/A VGND VGND VPWR VPWR _3963_/X sky130_fd_sc_hd__mux2_1
X_3894_ _3825_/X _3892_/A _3892_/B _3827_/Y _4095_/A VGND VGND VPWR VPWR _4112_/A
+ sky130_fd_sc_hd__a311oi_2
X_2914_ _4872_/Q _2936_/A2 _2913_/X _2936_/B2 VGND VGND VPWR VPWR _4872_/D sky130_fd_sc_hd__a22o_2
XFILLER_31_472 VGND VGND VPWR VPWR sky130_fd_sc_hd__decap_3
X_2845_ _5074_/Q _5058_/Q _5042_/Q _5026_/Q _5131_/Q _2848_/S1 VGND VGND VPWR VPWR
+ _2845_/X sky130_fd_sc_hd__mux4_2
X_4515_ _4429_/B _4471_/B _4523_/S VGND VGND VPWR VPWR _4515_/X sky130_fd_sc_hd__mux2_1
X_2776_ _5114_/Q _5002_/Q _4986_/Q _4970_/Q _2812_/S0 _2848_/S1 VGND VGND VPWR VPWR
+ _2776_/X sky130_fd_sc_hd__mux4_2
X_4446_ _4493_/A _4493_/B VGND VGND VPWR VPWR _4447_/B sky130_fd_sc_hd__nor2_2
X_4377_ _5221_/Q _4700_/S VGND VGND VPWR VPWR _4377_/X sky130_fd_sc_hd__or2_2
X_3328_ _5185_/Q _3347_/C _3327_/Y _3337_/A VGND VGND VPWR VPWR _3328_/X sky130_fd_sc_hd__o31a_2
XFILLER_58_347 VGND VGND VPWR VPWR sky130_fd_sc_hd__decap_3
XTAP_TAPCELL_ROW_69_854 VGND VPWR sky130_fd_sc_hd__tapvpwrvgnd_1
XFILLER_85_111 VGND VGND VPWR VPWR sky130_fd_sc_hd__fill_1
XFILLER_73_317 VGND VGND VPWR VPWR sky130_fd_sc_hd__decap_3
X_3259_ _5153_/Q _3259_/B VGND VGND VPWR VPWR _3406_/A sky130_fd_sc_hd__xnor2_2
XFILLER_85_166 VGND VGND VPWR VPWR sky130_fd_sc_hd__fill_2
XFILLER_54_520 VGND VGND VPWR VPWR sky130_fd_sc_hd__decap_3
XFILLER_26_233 VGND VGND VPWR VPWR sky130_fd_sc_hd__fill_2
XFILLER_41_225 VGND VGND VPWR VPWR sky130_fd_sc_hd__decap_3
XTAP_TAPCELL_ROW_24_434 VGND VPWR sky130_fd_sc_hd__tapvpwrvgnd_1
XFILLER_41_269 VGND VGND VPWR VPWR sky130_fd_sc_hd__decap_3
XFILLER_22_483 VGND VGND VPWR VPWR sky130_fd_sc_hd__decap_3
XFILLER_78_66 VGND VGND VPWR VPWR sky130_fd_sc_hd__decap_3
XFILLER_1_354 VGND VGND VPWR VPWR sky130_fd_sc_hd__decap_3
XFILLER_49_314 VGND VGND VPWR VPWR sky130_fd_sc_hd__fill_2
XFILLER_78_88 VGND VGND VPWR VPWR sky130_fd_sc_hd__decap_3
XFILLER_49_358 VGND VGND VPWR VPWR sky130_fd_sc_hd__decap_3
XFILLER_76_144 VGND VGND VPWR VPWR sky130_fd_sc_hd__decap_3
XFILLER_45_520 VGND VGND VPWR VPWR sky130_fd_sc_hd__decap_3
XFILLER_64_339 VGND VGND VPWR VPWR sky130_fd_sc_hd__decap_3
XFILLER_57_391 VGND VGND VPWR VPWR sky130_fd_sc_hd__fill_1
XFILLER_17_277 VGND VGND VPWR VPWR sky130_fd_sc_hd__decap_3
XFILLER_60_512 VGND VGND VPWR VPWR sky130_fd_sc_hd__decap_3
Xclkbuf_leaf_2_CLK clkbuf_leaf_8_CLK/A VGND VGND VPWR VPWR _5134_/CLK sky130_fd_sc_hd__clkbuf_8
XFILLER_9_443 VGND VGND VPWR VPWR sky130_fd_sc_hd__decap_3
X_2630_ _4956_/Q _4940_/Q _4924_/Q _4908_/Q _5123_/Q _2671_/S1 VGND VGND VPWR VPWR
+ _2630_/X sky130_fd_sc_hd__mux4_2
XFILLER_9_487 VGND VGND VPWR VPWR sky130_fd_sc_hd__decap_3
X_2561_ _5156_/Q _4466_/B VGND VGND VPWR VPWR _2562_/B sky130_fd_sc_hd__nor2_2
X_4300_ _4330_/B _3869_/Y _4002_/Y _2684_/A VGND VGND VPWR VPWR _4300_/X sky130_fd_sc_hd__a22o_2
X_2492_ _4896_/Q _4880_/Q _5104_/Q _5088_/Q _5123_/Q _5124_/Q VGND VGND VPWR VPWR
+ _2493_/B sky130_fd_sc_hd__mux4_2
X_4231_ _3668_/B _4013_/X _4172_/X VGND VGND VPWR VPWR _4231_/Y sky130_fd_sc_hd__o21ai_2
X_4162_ _4172_/A _4157_/X _4161_/X VGND VGND VPWR VPWR _4162_/Y sky130_fd_sc_hd__a21oi_2
XFILLER_55_306 VGND VGND VPWR VPWR sky130_fd_sc_hd__decap_3
XFILLER_67_166 VGND VGND VPWR VPWR sky130_fd_sc_hd__fill_2
X_4093_ _5209_/Q _4168_/A _4088_/X _4092_/X _3448_/B VGND VGND VPWR VPWR _5209_/D
+ sky130_fd_sc_hd__o221a_2
X_3113_ _2938_/X _3098_/Y _3099_/Y _5024_/Q VGND VGND VPWR VPWR _5024_/D sky130_fd_sc_hd__a22o_2
XFILLER_67_188 VGND VGND VPWR VPWR sky130_fd_sc_hd__fill_1
X_3044_ _2891_/X _3056_/A2 _3043_/Y _4963_/Q VGND VGND VPWR VPWR _4963_/D sky130_fd_sc_hd__a22o_2
XTAP_TAPCELL_ROW_66_824 VGND VPWR sky130_fd_sc_hd__tapvpwrvgnd_1
XFILLER_82_103 VGND VGND VPWR VPWR sky130_fd_sc_hd__decap_3
XFILLER_70_309 VGND VGND VPWR VPWR sky130_fd_sc_hd__decap_3
XTAP_TAPCELL_ROW_38_559 VGND VPWR sky130_fd_sc_hd__tapvpwrvgnd_1
XFILLER_82_169 VGND VGND VPWR VPWR sky130_fd_sc_hd__decap_3
XFILLER_82_136 VGND VGND VPWR VPWR sky130_fd_sc_hd__decap_3
XFILLER_23_225 VGND VGND VPWR VPWR sky130_fd_sc_hd__decap_3
X_4995_ _5112_/CLK _4995_/D VGND VGND VPWR VPWR _4995_/Q sky130_fd_sc_hd__dfxtp_2
X_3946_ _4311_/A _4311_/B VGND VGND VPWR VPWR _4313_/A sky130_fd_sc_hd__nand2_2
XTAP_TAPCELL_ROW_21_404 VGND VPWR sky130_fd_sc_hd__tapvpwrvgnd_1
X_3877_ _3877_/A _3877_/B _3876_/X VGND VGND VPWR VPWR _3877_/X sky130_fd_sc_hd__or3b_2
X_2828_ _2831_/S _2825_/X _5134_/Q VGND VGND VPWR VPWR _2828_/X sky130_fd_sc_hd__o21a_2
X_2759_ _2757_/X _2758_/X _5133_/Q VGND VGND VPWR VPWR _2759_/X sky130_fd_sc_hd__mux2_1
XFILLER_3_9 VGND VGND VPWR VPWR sky130_fd_sc_hd__decap_3
X_4429_ _4477_/A _4429_/B VGND VGND VPWR VPWR _4500_/A sky130_fd_sc_hd__nand2_2
XFILLER_48_25 VGND VGND VPWR VPWR sky130_fd_sc_hd__decap_3
XFILLER_48_47 VGND VGND VPWR VPWR sky130_fd_sc_hd__decap_3
XFILLER_58_111 VGND VGND VPWR VPWR sky130_fd_sc_hd__decap_3
XFILLER_58_122 VGND VGND VPWR VPWR sky130_fd_sc_hd__decap_3
XFILLER_58_133 VGND VGND VPWR VPWR sky130_fd_sc_hd__decap_3
XFILLER_86_442 VGND VGND VPWR VPWR sky130_fd_sc_hd__decap_3
XFILLER_58_155 VGND VGND VPWR VPWR sky130_fd_sc_hd__decap_3
XFILLER_73_125 VGND VGND VPWR VPWR sky130_fd_sc_hd__decap_3
XFILLER_27_531 VGND VGND VPWR VPWR sky130_fd_sc_hd__decap_3
XFILLER_39_391 VGND VGND VPWR VPWR sky130_fd_sc_hd__fill_1
XFILLER_64_68 VGND VGND VPWR VPWR sky130_fd_sc_hd__decap_3
XFILLER_64_79 VGND VGND VPWR VPWR sky130_fd_sc_hd__decap_3
XPHY_EDGE_ROW_14_Left_108 VGND VGND VPWR VPWR sky130_fd_sc_hd__decap_3
XFILLER_42_545 VGND VGND VPWR VPWR sky130_fd_sc_hd__decap_3
XFILLER_54_394 VGND VGND VPWR VPWR sky130_fd_sc_hd__decap_3
XFILLER_81_191 VGND VGND VPWR VPWR sky130_fd_sc_hd__decap_3
XFILLER_80_12 VGND VGND VPWR VPWR sky130_fd_sc_hd__decap_3
XFILLER_10_475 VGND VGND VPWR VPWR sky130_fd_sc_hd__fill_1
XFILLER_6_424 VGND VGND VPWR VPWR sky130_fd_sc_hd__decap_3
XPHY_EDGE_ROW_23_Left_117 VGND VGND VPWR VPWR sky130_fd_sc_hd__decap_3
XFILLER_89_54 VGND VGND VPWR VPWR sky130_fd_sc_hd__fill_2
XTAP_TAPCELL_ROW_9_284 VGND VPWR sky130_fd_sc_hd__tapvpwrvgnd_1
XFILLER_49_111 VGND VGND VPWR VPWR sky130_fd_sc_hd__fill_1
XFILLER_49_122 VGND VGND VPWR VPWR sky130_fd_sc_hd__decap_3
XFILLER_77_420 VGND VGND VPWR VPWR sky130_fd_sc_hd__decap_3
XFILLER_49_133 VGND VGND VPWR VPWR sky130_fd_sc_hd__decap_3
XFILLER_77_475 VGND VGND VPWR VPWR sky130_fd_sc_hd__decap_3
XFILLER_77_464 VGND VGND VPWR VPWR sky130_fd_sc_hd__decap_3
XFILLER_37_328 VGND VGND VPWR VPWR sky130_fd_sc_hd__decap_3
XFILLER_64_103 VGND VGND VPWR VPWR sky130_fd_sc_hd__decap_3
XFILLER_92_434 VGND VGND VPWR VPWR sky130_fd_sc_hd__decap_3
XFILLER_92_401 VGND VGND VPWR VPWR sky130_fd_sc_hd__decap_3
XFILLER_64_158 VGND VGND VPWR VPWR sky130_fd_sc_hd__fill_1
XPHY_EDGE_ROW_32_Left_126 VGND VGND VPWR VPWR sky130_fd_sc_hd__decap_3
XFILLER_45_350 VGND VGND VPWR VPWR sky130_fd_sc_hd__decap_3
XFILLER_52_309 VGND VGND VPWR VPWR sky130_fd_sc_hd__decap_3
XFILLER_92_489 VGND VGND VPWR VPWR sky130_fd_sc_hd__decap_3
XFILLER_33_545 VGND VGND VPWR VPWR sky130_fd_sc_hd__decap_3
X_4780_ _4115_/A _2685_/A _2886_/B _3874_/D _4779_/X VGND VGND VPWR VPWR _4780_/X
+ sky130_fd_sc_hd__o221a_2
X_3800_ _4954_/Q _4938_/Q _4922_/Q _4906_/Q _5127_/Q _3834_/S1 VGND VGND VPWR VPWR
+ _3800_/X sky130_fd_sc_hd__mux4_2
XFILLER_60_375 VGND VGND VPWR VPWR sky130_fd_sc_hd__decap_3
X_3731_ _5179_/Q _5178_/Q _5177_/Q _5176_/Q VGND VGND VPWR VPWR _4662_/A sky130_fd_sc_hd__nor4_4
XFILLER_9_240 VGND VGND VPWR VPWR sky130_fd_sc_hd__fill_1
Xclkload10 _5103_/CLK VGND VGND VPWR VPWR clkload10/X sky130_fd_sc_hd__clkbuf_4
X_3662_ _4171_/A _3668_/B VGND VGND VPWR VPWR _4172_/A sky130_fd_sc_hd__nor2_2
XPHY_EDGE_ROW_41_Left_135 VGND VGND VPWR VPWR sky130_fd_sc_hd__decap_3
Xclkload32 _5112_/CLK VGND VGND VPWR VPWR clkload32/X sky130_fd_sc_hd__clkbuf_4
Xclkload21 _5221_/CLK VGND VGND VPWR VPWR clkload21/Y sky130_fd_sc_hd__inv_6
X_3593_ _3831_/A _3592_/X _5130_/Q VGND VGND VPWR VPWR _3593_/X sky130_fd_sc_hd__o21a_2
X_2613_ _2613_/A _3932_/B VGND VGND VPWR VPWR _3876_/A sky130_fd_sc_hd__nand2_2
X_2544_ _2542_/X _2543_/X _2667_/A VGND VGND VPWR VPWR _2544_/X sky130_fd_sc_hd__mux2_1
XFILLER_5_490 VGND VGND VPWR VPWR sky130_fd_sc_hd__decap_3
X_5263_ _5263_/CLK _5263_/D VGND VGND VPWR VPWR _5263_/Q sky130_fd_sc_hd__dfxtp_2
X_2475_ _2469_/X _2471_/X _2474_/X _2435_/Y VGND VGND VPWR VPWR _4614_/A sky130_fd_sc_hd__a22o_2
X_4214_ _4110_/A _4196_/Y _4212_/X _4213_/X VGND VGND VPWR VPWR _4215_/B sky130_fd_sc_hd__a22o_2
X_5194_ _5254_/CLK _5194_/D VGND VGND VPWR VPWR _5194_/Q sky130_fd_sc_hd__dfxtp_2
XFILLER_87_228 VGND VGND VPWR VPWR sky130_fd_sc_hd__decap_3
XFILLER_28_306 VGND VGND VPWR VPWR sky130_fd_sc_hd__fill_2
X_4145_ _4115_/A _2864_/B _4142_/X VGND VGND VPWR VPWR _4145_/Y sky130_fd_sc_hd__o21ai_2
XFILLER_28_328 VGND VGND VPWR VPWR sky130_fd_sc_hd__fill_2
XFILLER_68_497 VGND VGND VPWR VPWR sky130_fd_sc_hd__decap_3
XPHY_EDGE_ROW_50_Left_144 VGND VGND VPWR VPWR sky130_fd_sc_hd__decap_3
XFILLER_83_434 VGND VGND VPWR VPWR sky130_fd_sc_hd__decap_3
XFILLER_83_412 VGND VGND VPWR VPWR sky130_fd_sc_hd__decap_3
XFILLER_55_136 VGND VGND VPWR VPWR sky130_fd_sc_hd__decap_3
XFILLER_55_147 VGND VGND VPWR VPWR sky130_fd_sc_hd__fill_1
X_4076_ _4473_/A _4173_/A VGND VGND VPWR VPWR _4076_/Y sky130_fd_sc_hd__nand2_2
XTAP_TAPCELL_ROW_87_1026 VGND VPWR sky130_fd_sc_hd__tapvpwrvgnd_1
XFILLER_83_467 VGND VGND VPWR VPWR sky130_fd_sc_hd__fill_1
XFILLER_55_169 VGND VGND VPWR VPWR sky130_fd_sc_hd__decap_3
X_3027_ _2903_/X _3024_/B _3024_/Y _4949_/Q VGND VGND VPWR VPWR _4949_/D sky130_fd_sc_hd__a22o_2
XFILLER_83_489 VGND VGND VPWR VPWR sky130_fd_sc_hd__decap_3
XFILLER_36_383 VGND VGND VPWR VPWR sky130_fd_sc_hd__decap_3
XFILLER_51_375 VGND VGND VPWR VPWR sky130_fd_sc_hd__fill_2
XFILLER_51_386 VGND VGND VPWR VPWR sky130_fd_sc_hd__decap_3
X_4978_ _5115_/CLK _4978_/D VGND VGND VPWR VPWR _4978_/Q sky130_fd_sc_hd__dfxtp_2
Xclkload4 clkload4/A VGND VGND VPWR VPWR clkload4/X sky130_fd_sc_hd__clkbuf_4
X_3929_ _5154_/Q _4067_/A VGND VGND VPWR VPWR _3930_/B sky130_fd_sc_hd__or2_2
XFILLER_50_59 VGND VGND VPWR VPWR sky130_fd_sc_hd__decap_3
XFILLER_3_427 VGND VGND VPWR VPWR sky130_fd_sc_hd__decap_3
XFILLER_1_6 VGND VGND VPWR VPWR sky130_fd_sc_hd__decap_3
XFILLER_3_449 VGND VGND VPWR VPWR sky130_fd_sc_hd__decap_3
XFILLER_59_24 VGND VGND VPWR VPWR sky130_fd_sc_hd__decap_3
XFILLER_59_57 VGND VGND VPWR VPWR sky130_fd_sc_hd__decap_3
XFILLER_78_206 VGND VGND VPWR VPWR sky130_fd_sc_hd__decap_3
XFILLER_59_420 VGND VGND VPWR VPWR sky130_fd_sc_hd__decap_3
XFILLER_78_239 VGND VGND VPWR VPWR sky130_fd_sc_hd__decap_3
XFILLER_59_464 VGND VGND VPWR VPWR sky130_fd_sc_hd__decap_3
XFILLER_75_12 VGND VGND VPWR VPWR sky130_fd_sc_hd__decap_3
XTAP_TAPCELL_ROW_6_254 VGND VPWR sky130_fd_sc_hd__tapvpwrvgnd_1
XFILLER_86_250 VGND VGND VPWR VPWR sky130_fd_sc_hd__fill_2
XFILLER_46_114 VGND VGND VPWR VPWR sky130_fd_sc_hd__decap_3
XFILLER_59_486 VGND VGND VPWR VPWR sky130_fd_sc_hd__decap_3
XFILLER_86_294 VGND VGND VPWR VPWR sky130_fd_sc_hd__decap_3
XFILLER_27_361 VGND VGND VPWR VPWR sky130_fd_sc_hd__decap_3
XFILLER_34_309 VGND VGND VPWR VPWR sky130_fd_sc_hd__decap_3
XFILLER_42_331 VGND VGND VPWR VPWR sky130_fd_sc_hd__fill_1
XFILLER_54_180 VGND VGND VPWR VPWR sky130_fd_sc_hd__decap_3
XFILLER_91_33 VGND VGND VPWR VPWR sky130_fd_sc_hd__decap_3
XFILLER_91_66 VGND VGND VPWR VPWR sky130_fd_sc_hd__fill_1
XFILLER_10_294 VGND VGND VPWR VPWR sky130_fd_sc_hd__decap_3
XFILLER_40_70 VGND VGND VPWR VPWR sky130_fd_sc_hd__decap_3
XFILLER_6_265 VGND VGND VPWR VPWR sky130_fd_sc_hd__decap_3
XFILLER_69_206 VGND VGND VPWR VPWR sky130_fd_sc_hd__decap_3
XFILLER_65_423 VGND VGND VPWR VPWR sky130_fd_sc_hd__fill_2
XFILLER_65_445 VGND VGND VPWR VPWR sky130_fd_sc_hd__decap_3
XFILLER_18_350 VGND VGND VPWR VPWR sky130_fd_sc_hd__decap_3
XFILLER_37_158 VGND VGND VPWR VPWR sky130_fd_sc_hd__decap_3
XFILLER_37_169 VGND VGND VPWR VPWR sky130_fd_sc_hd__decap_3
XFILLER_52_106 VGND VGND VPWR VPWR sky130_fd_sc_hd__decap_3
XFILLER_65_478 VGND VGND VPWR VPWR sky130_fd_sc_hd__decap_3
XTAP_TAPCELL_ROW_48_654 VGND VPWR sky130_fd_sc_hd__tapvpwrvgnd_1
XFILLER_92_253 VGND VGND VPWR VPWR sky130_fd_sc_hd__decap_3
XFILLER_80_415 VGND VGND VPWR VPWR sky130_fd_sc_hd__decap_3
XFILLER_52_139 VGND VGND VPWR VPWR sky130_fd_sc_hd__fill_1
X_4901_ _5111_/CLK _4901_/D VGND VGND VPWR VPWR _4901_/Q sky130_fd_sc_hd__dfxtp_2
XFILLER_92_286 VGND VGND VPWR VPWR sky130_fd_sc_hd__decap_3
XFILLER_80_437 VGND VGND VPWR VPWR sky130_fd_sc_hd__decap_3
XFILLER_33_364 VGND VGND VPWR VPWR sky130_fd_sc_hd__decap_3
XFILLER_60_150 VGND VGND VPWR VPWR sky130_fd_sc_hd__decap_3
X_4832_ input46/X _4816_/Y _4831_/X _3442_/B VGND VGND VPWR VPWR _5245_/D sky130_fd_sc_hd__o211a_2
X_4763_ _4763_/A _4763_/B VGND VGND VPWR VPWR _4763_/X sky130_fd_sc_hd__or2_2
X_4694_ _4743_/B _4607_/B _4804_/A VGND VGND VPWR VPWR _4695_/A sky130_fd_sc_hd__mux2_1
X_3714_ _4429_/B _3883_/B VGND VGND VPWR VPWR _4287_/A sky130_fd_sc_hd__and2_2
X_3645_ _4107_/B _4255_/A VGND VGND VPWR VPWR _4346_/A sky130_fd_sc_hd__or2_2
X_3576_ _3577_/A _3577_/B _3577_/C VGND VGND VPWR VPWR _3576_/X sky130_fd_sc_hd__o21a_2
X_2527_ _5065_/Q _5049_/Q _5033_/Q _5017_/Q _5123_/Q _2671_/S1 VGND VGND VPWR VPWR
+ _2527_/X sky130_fd_sc_hd__mux4_2
XTAP_TAPCELL_ROW_93_1085 VGND VPWR sky130_fd_sc_hd__tapvpwrvgnd_1
XFILLER_88_504 VGND VGND VPWR VPWR sky130_fd_sc_hd__decap_3
X_5246_ _5251_/CLK _5246_/D VGND VGND VPWR VPWR _5246_/Q sky130_fd_sc_hd__dfxtp_2
X_2458_ _5171_/Q _5170_/Q _5169_/Q _5168_/Q VGND VGND VPWR VPWR _2458_/X sky130_fd_sc_hd__and4_2
XTAP_TAPCELL_ROW_93_1096 VGND VPWR sky130_fd_sc_hd__tapvpwrvgnd_1
XPHY_EDGE_ROW_89_Right_89 VGND VGND VPWR VPWR sky130_fd_sc_hd__decap_3
XFILLER_56_401 VGND VGND VPWR VPWR sky130_fd_sc_hd__decap_3
X_5177_ _5177_/CLK _5177_/D VGND VGND VPWR VPWR _5177_/Q sky130_fd_sc_hd__dfxtp_2
X_4128_ _4155_/A _4128_/B VGND VGND VPWR VPWR _4142_/B sky130_fd_sc_hd__or2_2
XFILLER_83_231 VGND VGND VPWR VPWR sky130_fd_sc_hd__decap_3
XFILLER_16_309 VGND VGND VPWR VPWR sky130_fd_sc_hd__decap_3
XFILLER_28_158 VGND VGND VPWR VPWR sky130_fd_sc_hd__decap_3
XFILLER_56_489 VGND VGND VPWR VPWR sky130_fd_sc_hd__decap_3
X_4059_ _3968_/X _3960_/X _4063_/A VGND VGND VPWR VPWR _4059_/X sky130_fd_sc_hd__mux2_1
XFILLER_43_128 VGND VGND VPWR VPWR sky130_fd_sc_hd__decap_3
XFILLER_71_426 VGND VGND VPWR VPWR sky130_fd_sc_hd__fill_2
XFILLER_71_459 VGND VGND VPWR VPWR sky130_fd_sc_hd__decap_3
XTAP_TAPCELL_ROW_82_977 VGND VPWR sky130_fd_sc_hd__tapvpwrvgnd_1
XFILLER_12_526 VGND VGND VPWR VPWR sky130_fd_sc_hd__decap_3
XFILLER_51_150 VGND VGND VPWR VPWR sky130_fd_sc_hd__decap_3
XFILLER_51_172 VGND VGND VPWR VPWR sky130_fd_sc_hd__decap_3
XFILLER_8_519 VGND VGND VPWR VPWR sky130_fd_sc_hd__decap_3
XFILLER_61_69 VGND VGND VPWR VPWR sky130_fd_sc_hd__decap_3
XFILLER_86_22 VGND VGND VPWR VPWR sky130_fd_sc_hd__decap_3
XFILLER_79_548 VGND VGND VPWR VPWR sky130_fd_sc_hd__decap_3
XFILLER_79_526 VGND VGND VPWR VPWR sky130_fd_sc_hd__decap_3
XFILLER_86_55 VGND VGND VPWR VPWR sky130_fd_sc_hd__fill_2
XFILLER_59_261 VGND VGND VPWR VPWR sky130_fd_sc_hd__decap_3
XFILLER_86_66 VGND VGND VPWR VPWR sky130_fd_sc_hd__decap_3
XFILLER_19_60 VGND VGND VPWR VPWR sky130_fd_sc_hd__decap_3
XFILLER_59_294 VGND VGND VPWR VPWR sky130_fd_sc_hd__decap_3
XFILLER_19_169 VGND VGND VPWR VPWR sky130_fd_sc_hd__decap_3
XFILLER_34_106 VGND VGND VPWR VPWR sky130_fd_sc_hd__decap_3
XFILLER_62_404 VGND VGND VPWR VPWR sky130_fd_sc_hd__decap_3
XFILLER_74_253 VGND VGND VPWR VPWR sky130_fd_sc_hd__decap_3
XFILLER_27_180 VGND VGND VPWR VPWR sky130_fd_sc_hd__fill_1
XFILLER_34_139 VGND VGND VPWR VPWR sky130_fd_sc_hd__fill_1
XFILLER_74_286 VGND VGND VPWR VPWR sky130_fd_sc_hd__decap_3
XTAP_TAPCELL_ROW_17_359 VGND VPWR sky130_fd_sc_hd__tapvpwrvgnd_1
XFILLER_30_312 VGND VGND VPWR VPWR sky130_fd_sc_hd__decap_3
XFILLER_30_334 VGND VGND VPWR VPWR sky130_fd_sc_hd__decap_3
X_3430_ _5161_/Q _3227_/X _3429_/X VGND VGND VPWR VPWR _3431_/B sky130_fd_sc_hd__a21oi_2
X_3361_ _3361_/A _3361_/B _3361_/C _3361_/D VGND VGND VPWR VPWR _3361_/X sky130_fd_sc_hd__and4_2
XFILLER_32_3 VGND VGND VPWR VPWR sky130_fd_sc_hd__fill_1
X_5100_ _5100_/CLK _5100_/D VGND VGND VPWR VPWR _5100_/Q sky130_fd_sc_hd__dfxtp_2
X_5031_ _5100_/CLK _5031_/D VGND VGND VPWR VPWR _5031_/Q sky130_fd_sc_hd__dfxtp_2
X_3292_ _5157_/Q _3292_/B VGND VGND VPWR VPWR _3293_/B sky130_fd_sc_hd__and2_2
XFILLER_38_412 VGND VGND VPWR VPWR sky130_fd_sc_hd__decap_3
XFILLER_38_445 VGND VGND VPWR VPWR sky130_fd_sc_hd__decap_3
XFILLER_65_275 VGND VGND VPWR VPWR sky130_fd_sc_hd__decap_3
XTAP_TAPCELL_ROW_0_205 VGND VPWR sky130_fd_sc_hd__tapvpwrvgnd_1
XFILLER_93_551 VGND VGND VPWR VPWR sky130_fd_sc_hd__fill_2
XFILLER_25_128 VGND VGND VPWR VPWR sky130_fd_sc_hd__decap_3
XFILLER_53_426 VGND VGND VPWR VPWR sky130_fd_sc_hd__decap_3
XFILLER_15_29 VGND VGND VPWR VPWR sky130_fd_sc_hd__decap_3
XFILLER_33_150 VGND VGND VPWR VPWR sky130_fd_sc_hd__decap_3
XFILLER_33_172 VGND VGND VPWR VPWR sky130_fd_sc_hd__decap_3
XFILLER_61_470 VGND VGND VPWR VPWR sky130_fd_sc_hd__decap_3
XFILLER_80_289 VGND VGND VPWR VPWR sky130_fd_sc_hd__decap_3
XFILLER_33_183 VGND VGND VPWR VPWR sky130_fd_sc_hd__fill_1
X_4815_ _5254_/Q _5259_/Q VGND VGND VPWR VPWR _4847_/B sky130_fd_sc_hd__and2_2
XFILLER_31_28 VGND VGND VPWR VPWR sky130_fd_sc_hd__fill_2
X_4746_ _4745_/Y _4723_/Y _4802_/A VGND VGND VPWR VPWR _4804_/B sky130_fd_sc_hd__mux2_1
X_4677_ _4676_/X _4586_/X _4804_/A VGND VGND VPWR VPWR _4786_/B sky130_fd_sc_hd__mux2_1
X_3628_ _4477_/A _3634_/S _3627_/Y VGND VGND VPWR VPWR _3628_/Y sky130_fd_sc_hd__o21ai_2
X_3559_ _5164_/Q _5145_/Q VGND VGND VPWR VPWR _3561_/A sky130_fd_sc_hd__nand2_2
XFILLER_0_249 VGND VGND VPWR VPWR sky130_fd_sc_hd__decap_3
XFILLER_48_209 VGND VGND VPWR VPWR sky130_fd_sc_hd__decap_3
X_5229_ _5263_/CLK _5229_/D VGND VGND VPWR VPWR _5229_/Q sky130_fd_sc_hd__dfxtp_2
XFILLER_88_378 VGND VGND VPWR VPWR sky130_fd_sc_hd__decap_3
XFILLER_76_518 VGND VGND VPWR VPWR sky130_fd_sc_hd__fill_1
XFILLER_29_434 VGND VGND VPWR VPWR sky130_fd_sc_hd__decap_3
XFILLER_56_220 VGND VGND VPWR VPWR sky130_fd_sc_hd__decap_3
XFILLER_56_47 VGND VGND VPWR VPWR sky130_fd_sc_hd__decap_3
XFILLER_44_404 VGND VGND VPWR VPWR sky130_fd_sc_hd__decap_3
XFILLER_56_242 VGND VGND VPWR VPWR sky130_fd_sc_hd__decap_3
XFILLER_56_253 VGND VGND VPWR VPWR sky130_fd_sc_hd__decap_3
XFILLER_84_551 VGND VGND VPWR VPWR sky130_fd_sc_hd__fill_2
XFILLER_16_139 VGND VGND VPWR VPWR sky130_fd_sc_hd__fill_1
XFILLER_44_448 VGND VGND VPWR VPWR sky130_fd_sc_hd__fill_1
XFILLER_56_286 VGND VGND VPWR VPWR sky130_fd_sc_hd__decap_3
XFILLER_71_212 VGND VGND VPWR VPWR sky130_fd_sc_hd__decap_3
XFILLER_71_234 VGND VGND VPWR VPWR sky130_fd_sc_hd__decap_3
XFILLER_71_267 VGND VGND VPWR VPWR sky130_fd_sc_hd__decap_3
XTAP_TAPCELL_ROW_42_605 VGND VPWR sky130_fd_sc_hd__tapvpwrvgnd_1
XFILLER_12_323 VGND VGND VPWR VPWR sky130_fd_sc_hd__decap_3
XFILLER_52_492 VGND VGND VPWR VPWR sky130_fd_sc_hd__decap_3
XFILLER_12_356 VGND VGND VPWR VPWR sky130_fd_sc_hd__decap_3
XFILLER_21_72 VGND VGND VPWR VPWR sky130_fd_sc_hd__decap_3
XFILLER_4_544 VGND VGND VPWR VPWR sky130_fd_sc_hd__decap_3
XFILLER_79_345 VGND VGND VPWR VPWR sky130_fd_sc_hd__decap_3
XFILLER_79_334 VGND VGND VPWR VPWR sky130_fd_sc_hd__fill_2
XFILLER_39_209 VGND VGND VPWR VPWR sky130_fd_sc_hd__decap_3
XFILLER_67_529 VGND VGND VPWR VPWR sky130_fd_sc_hd__decap_3
XFILLER_47_231 VGND VGND VPWR VPWR sky130_fd_sc_hd__decap_3
XFILLER_75_540 VGND VGND VPWR VPWR sky130_fd_sc_hd__decap_3
XFILLER_35_426 VGND VGND VPWR VPWR sky130_fd_sc_hd__decap_3
XFILLER_47_286 VGND VGND VPWR VPWR sky130_fd_sc_hd__decap_3
XFILLER_46_80 VGND VGND VPWR VPWR sky130_fd_sc_hd__decap_3
XFILLER_46_91 VGND VGND VPWR VPWR sky130_fd_sc_hd__fill_1
XFILLER_62_245 VGND VGND VPWR VPWR sky130_fd_sc_hd__decap_3
XFILLER_43_470 VGND VGND VPWR VPWR sky130_fd_sc_hd__fill_1
XFILLER_62_267 VGND VGND VPWR VPWR sky130_fd_sc_hd__decap_3
X_2930_ _4877_/Q _2936_/A2 _2929_/X _2936_/B2 VGND VGND VPWR VPWR _4877_/D sky130_fd_sc_hd__a22o_2
XFILLER_15_183 VGND VGND VPWR VPWR sky130_fd_sc_hd__fill_1
X_4600_ _5225_/Q _4850_/B VGND VGND VPWR VPWR _4600_/Y sky130_fd_sc_hd__nand2_2
X_2861_ _3874_/A _2861_/B VGND VGND VPWR VPWR _4115_/B sky130_fd_sc_hd__xnor2_2
XFILLER_30_197 VGND VGND VPWR VPWR sky130_fd_sc_hd__decap_3
X_2792_ _2831_/S _2791_/X _5134_/Q VGND VGND VPWR VPWR _2792_/X sky130_fd_sc_hd__o21a_2
XFILLER_7_30 VGND VGND VPWR VPWR sky130_fd_sc_hd__decap_3
X_4531_ _4477_/C _4589_/B _4529_/Y _4530_/X _4479_/X VGND VGND VPWR VPWR _4531_/X
+ sky130_fd_sc_hd__o311a_2
XFILLER_7_63 VGND VGND VPWR VPWR sky130_fd_sc_hd__decap_3
X_4462_ _4461_/A _4461_/B _4632_/A VGND VGND VPWR VPWR _4462_/X sky130_fd_sc_hd__a21o_2
X_3413_ _5153_/Q _3252_/C _3228_/Y _3412_/X VGND VGND VPWR VPWR _5153_/D sky130_fd_sc_hd__o22a_2
X_4393_ _4408_/S _4534_/C VGND VGND VPWR VPWR _4393_/Y sky130_fd_sc_hd__nand2_2
X_3344_ _3324_/X _3361_/C _3361_/A VGND VGND VPWR VPWR _3345_/B sky130_fd_sc_hd__o21a_2
XTAP_TAPCELL_ROW_90_1055 VGND VPWR sky130_fd_sc_hd__tapvpwrvgnd_1
XFILLER_58_518 VGND VGND VPWR VPWR sky130_fd_sc_hd__decap_3
X_3275_ _5136_/Q _5135_/Q VGND VGND VPWR VPWR _3275_/Y sky130_fd_sc_hd__nor2_2
XFILLER_85_326 VGND VGND VPWR VPWR sky130_fd_sc_hd__fill_2
X_5014_ _5063_/CLK _5014_/D VGND VGND VPWR VPWR _5014_/Q sky130_fd_sc_hd__dfxtp_2
XFILLER_85_337 VGND VGND VPWR VPWR sky130_fd_sc_hd__decap_3
XFILLER_38_242 VGND VGND VPWR VPWR sky130_fd_sc_hd__decap_3
XFILLER_38_253 VGND VGND VPWR VPWR sky130_fd_sc_hd__decap_3
XFILLER_66_551 VGND VGND VPWR VPWR sky130_fd_sc_hd__fill_2
XFILLER_53_201 VGND VGND VPWR VPWR sky130_fd_sc_hd__decap_3
XFILLER_53_234 VGND VGND VPWR VPWR sky130_fd_sc_hd__decap_3
XFILLER_21_175 VGND VGND VPWR VPWR sky130_fd_sc_hd__decap_3
XFILLER_5_319 VGND VGND VPWR VPWR sky130_fd_sc_hd__decap_3
X_4729_ _4727_/X _4728_/Y _4714_/A VGND VGND VPWR VPWR _5231_/D sky130_fd_sc_hd__a21oi_2
XFILLER_67_46 VGND VGND VPWR VPWR sky130_fd_sc_hd__decap_3
XFILLER_67_57 VGND VGND VPWR VPWR sky130_fd_sc_hd__decap_3
XFILLER_88_164 VGND VGND VPWR VPWR sky130_fd_sc_hd__decap_3
XFILLER_76_315 VGND VGND VPWR VPWR sky130_fd_sc_hd__decap_3
XFILLER_29_264 VGND VGND VPWR VPWR sky130_fd_sc_hd__decap_3
XFILLER_17_437 VGND VGND VPWR VPWR sky130_fd_sc_hd__decap_3
XFILLER_72_510 VGND VGND VPWR VPWR sky130_fd_sc_hd__decap_3
XFILLER_44_256 VGND VGND VPWR VPWR sky130_fd_sc_hd__decap_3
XFILLER_83_67 VGND VGND VPWR VPWR sky130_fd_sc_hd__decap_3
XFILLER_32_418 VGND VGND VPWR VPWR sky130_fd_sc_hd__fill_2
XFILLER_32_429 VGND VGND VPWR VPWR sky130_fd_sc_hd__decap_3
XTAP_TAPCELL_ROW_27_454 VGND VPWR sky130_fd_sc_hd__tapvpwrvgnd_1
XFILLER_16_94 VGND VGND VPWR VPWR sky130_fd_sc_hd__decap_3
XFILLER_25_492 VGND VGND VPWR VPWR sky130_fd_sc_hd__decap_3
XFILLER_40_451 VGND VGND VPWR VPWR sky130_fd_sc_hd__decap_3
XFILLER_40_495 VGND VGND VPWR VPWR sky130_fd_sc_hd__decap_3
XFILLER_12_197 VGND VGND VPWR VPWR sky130_fd_sc_hd__decap_3
XFILLER_67_348 VGND VGND VPWR VPWR sky130_fd_sc_hd__decap_3
X_3060_ _3189_/B _3078_/B VGND VGND VPWR VPWR _3061_/B sky130_fd_sc_hd__nor2_2
XFILLER_82_318 VGND VGND VPWR VPWR sky130_fd_sc_hd__decap_3
XFILLER_82_307 VGND VGND VPWR VPWR sky130_fd_sc_hd__fill_1
XFILLER_75_370 VGND VGND VPWR VPWR sky130_fd_sc_hd__decap_3
XFILLER_63_532 VGND VGND VPWR VPWR sky130_fd_sc_hd__fill_1
XFILLER_23_418 VGND VGND VPWR VPWR sky130_fd_sc_hd__decap_3
XFILLER_35_278 VGND VGND VPWR VPWR sky130_fd_sc_hd__fill_2
XFILLER_90_384 VGND VGND VPWR VPWR sky130_fd_sc_hd__fill_2
XFILLER_50_248 VGND VGND VPWR VPWR sky130_fd_sc_hd__decap_3
X_3962_ _4464_/A _4787_/S _3961_/Y VGND VGND VPWR VPWR _3962_/Y sky130_fd_sc_hd__o21ai_2
X_3893_ _3825_/X _3892_/A _3892_/B _3827_/Y VGND VGND VPWR VPWR _3893_/X sky130_fd_sc_hd__a31o_2
X_2913_ _5195_/Q _2455_/X _3456_/B _5243_/Q _2912_/X VGND VGND VPWR VPWR _2913_/X
+ sky130_fd_sc_hd__a221o_2
XTAP_TAPCELL_ROW_61_777 VGND VPWR sky130_fd_sc_hd__tapvpwrvgnd_1
X_2844_ _5133_/Q _2844_/B VGND VGND VPWR VPWR _2844_/X sky130_fd_sc_hd__or2_2
X_4514_ _4468_/A _4432_/B _4523_/S VGND VGND VPWR VPWR _4624_/B sky130_fd_sc_hd__mux2_1
X_2775_ _2831_/S _2775_/B VGND VGND VPWR VPWR _2775_/X sky130_fd_sc_hd__or2_2
X_4445_ _4445_/A _4445_/B VGND VGND VPWR VPWR _4465_/A sky130_fd_sc_hd__nor2_2
X_4376_ _4115_/A _2696_/B _4700_/S VGND VGND VPWR VPWR _4376_/Y sky130_fd_sc_hd__o21ai_2
XFILLER_58_315 VGND VGND VPWR VPWR sky130_fd_sc_hd__decap_3
X_3327_ _5141_/Q _3327_/B VGND VGND VPWR VPWR _3327_/Y sky130_fd_sc_hd__nor2_2
XFILLER_58_359 VGND VGND VPWR VPWR sky130_fd_sc_hd__decap_3
X_3258_ _5153_/Q _3259_/B VGND VGND VPWR VPWR _3258_/Y sky130_fd_sc_hd__nand2_2
XTAP_TAPCELL_ROW_69_855 VGND VPWR sky130_fd_sc_hd__tapvpwrvgnd_1
XFILLER_26_212 VGND VGND VPWR VPWR sky130_fd_sc_hd__decap_3
XFILLER_66_381 VGND VGND VPWR VPWR sky130_fd_sc_hd__decap_3
X_3189_ _3189_/A _3189_/B VGND VGND VPWR VPWR _3190_/B sky130_fd_sc_hd__nor2_2
XFILLER_54_543 VGND VGND VPWR VPWR sky130_fd_sc_hd__fill_2
XFILLER_81_340 VGND VGND VPWR VPWR sky130_fd_sc_hd__decap_3
XFILLER_26_256 VGND VGND VPWR VPWR sky130_fd_sc_hd__fill_2
XFILLER_26_278 VGND VGND VPWR VPWR sky130_fd_sc_hd__decap_3
XTAP_TAPCELL_ROW_52_700 VGND VPWR sky130_fd_sc_hd__tapvpwrvgnd_1
XFILLER_81_373 VGND VGND VPWR VPWR sky130_fd_sc_hd__decap_3
XFILLER_41_237 VGND VGND VPWR VPWR sky130_fd_sc_hd__decap_3
XFILLER_53_37 VGND VGND VPWR VPWR sky130_fd_sc_hd__decap_3
XFILLER_41_259 VGND VGND VPWR VPWR sky130_fd_sc_hd__decap_3
XFILLER_22_473 VGND VGND VPWR VPWR sky130_fd_sc_hd__decap_3
XFILLER_5_105 VGND VGND VPWR VPWR sky130_fd_sc_hd__decap_3
XFILLER_5_149 VGND VGND VPWR VPWR sky130_fd_sc_hd__decap_3
XFILLER_1_333 VGND VGND VPWR VPWR sky130_fd_sc_hd__decap_3
XFILLER_78_45 VGND VGND VPWR VPWR sky130_fd_sc_hd__decap_3
XFILLER_78_78 VGND VGND VPWR VPWR sky130_fd_sc_hd__decap_3
XFILLER_1_388 VGND VGND VPWR VPWR sky130_fd_sc_hd__decap_3
XFILLER_49_326 VGND VGND VPWR VPWR sky130_fd_sc_hd__decap_3
XFILLER_49_337 VGND VGND VPWR VPWR sky130_fd_sc_hd__decap_3
XFILLER_76_112 VGND VGND VPWR VPWR sky130_fd_sc_hd__decap_3
XFILLER_57_370 VGND VGND VPWR VPWR sky130_fd_sc_hd__decap_3
XFILLER_64_318 VGND VGND VPWR VPWR sky130_fd_sc_hd__decap_3
XFILLER_45_543 VGND VGND VPWR VPWR sky130_fd_sc_hd__fill_2
XFILLER_72_373 VGND VGND VPWR VPWR sky130_fd_sc_hd__decap_3
XFILLER_13_495 VGND VGND VPWR VPWR sky130_fd_sc_hd__fill_1
XFILLER_40_281 VGND VGND VPWR VPWR sky130_fd_sc_hd__decap_3
XFILLER_9_466 VGND VGND VPWR VPWR sky130_fd_sc_hd__decap_3
X_2560_ _5156_/Q _4466_/B VGND VGND VPWR VPWR _2560_/Y sky130_fd_sc_hd__nand2_2
X_2491_ _3681_/B VGND VGND VPWR VPWR _2886_/A sky130_fd_sc_hd__inv_2
XFILLER_4_193 VGND VGND VPWR VPWR sky130_fd_sc_hd__decap_3
X_4230_ _4155_/A _4228_/Y _4229_/Y _3985_/B _4200_/Y VGND VGND VPWR VPWR _4230_/X
+ sky130_fd_sc_hd__o32a_2
X_4161_ _4132_/A _4160_/X _4159_/X _2452_/Y VGND VGND VPWR VPWR _4161_/X sky130_fd_sc_hd__a211o_2
XFILLER_67_145 VGND VGND VPWR VPWR sky130_fd_sc_hd__decap_3
X_4092_ _2452_/Y _4090_/Y _4091_/X _4850_/B VGND VGND VPWR VPWR _4092_/X sky130_fd_sc_hd__a31o_2
X_3112_ _2935_/X _3099_/B _3099_/Y _5023_/Q VGND VGND VPWR VPWR _5023_/D sky130_fd_sc_hd__a22o_2
XFILLER_55_318 VGND VGND VPWR VPWR sky130_fd_sc_hd__decap_3
X_3043_ _4866_/A _3043_/B VGND VGND VPWR VPWR _3043_/Y sky130_fd_sc_hd__nor2_2
XTAP_TAPCELL_ROW_66_825 VGND VPWR sky130_fd_sc_hd__tapvpwrvgnd_1
XFILLER_48_381 VGND VGND VPWR VPWR sky130_fd_sc_hd__fill_2
XFILLER_63_340 VGND VGND VPWR VPWR sky130_fd_sc_hd__decap_3
XFILLER_63_362 VGND VGND VPWR VPWR sky130_fd_sc_hd__decap_3
XFILLER_51_546 VGND VGND VPWR VPWR sky130_fd_sc_hd__decap_3
X_4994_ _5115_/CLK _4994_/D VGND VGND VPWR VPWR _4994_/Q sky130_fd_sc_hd__dfxtp_2
XFILLER_90_181 VGND VGND VPWR VPWR sky130_fd_sc_hd__fill_1
X_3945_ _5164_/Q _4453_/B VGND VGND VPWR VPWR _4311_/B sky130_fd_sc_hd__nor2_2
XFILLER_23_29 VGND VGND VPWR VPWR sky130_fd_sc_hd__decap_3
XTAP_TAPCELL_ROW_21_405 VGND VPWR sky130_fd_sc_hd__tapvpwrvgnd_1
XFILLER_31_281 VGND VGND VPWR VPWR sky130_fd_sc_hd__decap_3
X_3876_ _3876_/A _3876_/B _3682_/Y _3875_/Y VGND VGND VPWR VPWR _3876_/X sky130_fd_sc_hd__or4bb_2
X_2827_ _5133_/Q _2827_/B VGND VGND VPWR VPWR _2827_/X sky130_fd_sc_hd__or2_2
X_2758_ _4952_/Q _4936_/Q _4920_/Q _4904_/Q _2812_/S0 _2848_/S1 VGND VGND VPWR VPWR
+ _2758_/X sky130_fd_sc_hd__mux4_2
X_4428_ _4477_/A _4429_/B VGND VGND VPWR VPWR _4469_/A sky130_fd_sc_hd__nor2_2
X_2689_ _2689_/A _4333_/C VGND VGND VPWR VPWR _2690_/B sky130_fd_sc_hd__nand2_2
X_4359_ _4335_/A _4335_/B _3916_/B VGND VGND VPWR VPWR _4360_/C sky130_fd_sc_hd__o21ba_2
XFILLER_39_370 VGND VGND VPWR VPWR sky130_fd_sc_hd__decap_3
XFILLER_46_318 VGND VGND VPWR VPWR sky130_fd_sc_hd__fill_1
XFILLER_58_167 VGND VGND VPWR VPWR sky130_fd_sc_hd__decap_3
XFILLER_64_25 VGND VGND VPWR VPWR sky130_fd_sc_hd__decap_3
XFILLER_42_502 VGND VGND VPWR VPWR sky130_fd_sc_hd__fill_2
XFILLER_54_340 VGND VGND VPWR VPWR sky130_fd_sc_hd__decap_3
XFILLER_64_47 VGND VGND VPWR VPWR sky130_fd_sc_hd__decap_3
XFILLER_14_226 VGND VGND VPWR VPWR sky130_fd_sc_hd__decap_3
XFILLER_42_524 VGND VGND VPWR VPWR sky130_fd_sc_hd__fill_2
XFILLER_14_259 VGND VGND VPWR VPWR sky130_fd_sc_hd__decap_3
XFILLER_80_24 VGND VGND VPWR VPWR sky130_fd_sc_hd__decap_3
XFILLER_10_421 VGND VGND VPWR VPWR sky130_fd_sc_hd__decap_3
XFILLER_89_33 VGND VGND VPWR VPWR sky130_fd_sc_hd__decap_3
XFILLER_1_141 VGND VGND VPWR VPWR sky130_fd_sc_hd__decap_3
XTAP_TAPCELL_ROW_9_285 VGND VPWR sky130_fd_sc_hd__tapvpwrvgnd_1
XFILLER_89_281 VGND VGND VPWR VPWR sky130_fd_sc_hd__decap_3
XFILLER_89_270 VGND VGND VPWR VPWR sky130_fd_sc_hd__decap_3
XFILLER_38_81 VGND VGND VPWR VPWR sky130_fd_sc_hd__decap_3
XFILLER_64_115 VGND VGND VPWR VPWR sky130_fd_sc_hd__decap_3
XFILLER_92_424 VGND VGND VPWR VPWR sky130_fd_sc_hd__decap_3
XFILLER_92_413 VGND VGND VPWR VPWR sky130_fd_sc_hd__decap_3
XFILLER_77_487 VGND VGND VPWR VPWR sky130_fd_sc_hd__decap_3
XFILLER_92_446 VGND VGND VPWR VPWR sky130_fd_sc_hd__decap_3
XFILLER_45_340 VGND VGND VPWR VPWR sky130_fd_sc_hd__fill_1
XFILLER_45_362 VGND VGND VPWR VPWR sky130_fd_sc_hd__fill_1
XFILLER_45_373 VGND VGND VPWR VPWR sky130_fd_sc_hd__decap_3
XFILLER_60_354 VGND VGND VPWR VPWR sky130_fd_sc_hd__decap_3
XFILLER_60_365 VGND VGND VPWR VPWR sky130_fd_sc_hd__fill_2
XFILLER_72_192 VGND VGND VPWR VPWR sky130_fd_sc_hd__decap_3
X_3730_ _4449_/B _4405_/A VGND VGND VPWR VPWR _3992_/A sky130_fd_sc_hd__xnor2_2
XTAP_TAPCELL_ROW_71_872 VGND VPWR sky130_fd_sc_hd__tapvpwrvgnd_1
XFILLER_13_281 VGND VGND VPWR VPWR sky130_fd_sc_hd__decap_3
X_3661_ _5155_/Q _4397_/A _4547_/A VGND VGND VPWR VPWR _3668_/B sky130_fd_sc_hd__mux2_1
Xclkload33 _5111_/CLK VGND VGND VPWR VPWR clkload33/X sky130_fd_sc_hd__clkbuf_4
Xclkload22 _5117_/CLK VGND VGND VPWR VPWR clkload22/Y sky130_fd_sc_hd__clkinv_2
Xclkload11 _5122_/CLK VGND VGND VPWR VPWR clkload11/X sky130_fd_sc_hd__clkbuf_4
X_3592_ _5062_/Q _5046_/Q _5030_/Q _5014_/Q _3834_/S0 _3834_/S1 VGND VGND VPWR VPWR
+ _3592_/X sky130_fd_sc_hd__mux4_2
X_2612_ _5155_/Q _4445_/A VGND VGND VPWR VPWR _4609_/S sky130_fd_sc_hd__nor2_2
XFILLER_9_296 VGND VGND VPWR VPWR sky130_fd_sc_hd__decap_3
X_2543_ _5112_/Q _5000_/Q _4984_/Q _4968_/Q _2658_/S0 _2671_/S1 VGND VGND VPWR VPWR
+ _2543_/X sky130_fd_sc_hd__mux4_2
X_5262_ _5262_/CLK _5262_/D VGND VGND VPWR VPWR _5262_/Q sky130_fd_sc_hd__dfxtp_2
X_2474_ _2472_/X _2473_/X _5125_/Q VGND VGND VPWR VPWR _2474_/X sky130_fd_sc_hd__mux2_1
XFILLER_87_207 VGND VGND VPWR VPWR sky130_fd_sc_hd__decap_3
XFILLER_68_410 VGND VGND VPWR VPWR sky130_fd_sc_hd__fill_1
X_4213_ _3903_/B _4199_/Y _4115_/A _2871_/B VGND VGND VPWR VPWR _4213_/X sky130_fd_sc_hd__o2bb2a_2
X_5193_ clkload7/A _5193_/D VGND VGND VPWR VPWR _5193_/Q sky130_fd_sc_hd__dfxtp_2
X_4144_ _4121_/Y _4122_/X _4143_/X VGND VGND VPWR VPWR _4144_/Y sky130_fd_sc_hd__o21ai_2
XTAP_TAPCELL_ROW_79_950 VGND VPWR sky130_fd_sc_hd__tapvpwrvgnd_1
XFILLER_83_424 VGND VGND VPWR VPWR sky130_fd_sc_hd__decap_3
X_4075_ _4173_/A _4072_/X _4074_/Y VGND VGND VPWR VPWR _4075_/X sky130_fd_sc_hd__o21a_2
XTAP_TAPCELL_ROW_87_1027 VGND VPWR sky130_fd_sc_hd__tapvpwrvgnd_1
X_3026_ _2900_/X _3024_/B _3024_/Y _4948_/Q VGND VGND VPWR VPWR _4948_/D sky130_fd_sc_hd__a22o_2
XFILLER_63_181 VGND VGND VPWR VPWR sky130_fd_sc_hd__decap_3
XFILLER_70_129 VGND VGND VPWR VPWR sky130_fd_sc_hd__decap_3
XFILLER_51_332 VGND VGND VPWR VPWR sky130_fd_sc_hd__decap_3
XFILLER_51_354 VGND VGND VPWR VPWR sky130_fd_sc_hd__decap_3
X_4977_ _5121_/CLK _4977_/D VGND VGND VPWR VPWR _4977_/Q sky130_fd_sc_hd__dfxtp_2
Xclkload5 clkload5/A VGND VGND VPWR VPWR clkload5/X sky130_fd_sc_hd__clkbuf_4
X_3928_ _4048_/A _4048_/B VGND VGND VPWR VPWR _3930_/A sky130_fd_sc_hd__or2_2
X_3859_ _5153_/Q _4405_/A _4404_/S VGND VGND VPWR VPWR _4340_/A sky130_fd_sc_hd__mux2_1
XFILLER_59_36 VGND VGND VPWR VPWR sky130_fd_sc_hd__decap_3
XFILLER_59_69 VGND VGND VPWR VPWR sky130_fd_sc_hd__decap_3
XFILLER_59_443 VGND VGND VPWR VPWR sky130_fd_sc_hd__decap_3
XTAP_TAPCELL_ROW_6_255 VGND VPWR sky130_fd_sc_hd__tapvpwrvgnd_1
XFILLER_74_424 VGND VGND VPWR VPWR sky130_fd_sc_hd__fill_1
XFILLER_86_273 VGND VGND VPWR VPWR sky130_fd_sc_hd__decap_3
XFILLER_86_262 VGND VGND VPWR VPWR sky130_fd_sc_hd__decap_3
XFILLER_46_126 VGND VGND VPWR VPWR sky130_fd_sc_hd__decap_3
XFILLER_15_502 VGND VGND VPWR VPWR sky130_fd_sc_hd__fill_2
XFILLER_27_373 VGND VGND VPWR VPWR sky130_fd_sc_hd__fill_2
XFILLER_42_354 VGND VGND VPWR VPWR sky130_fd_sc_hd__fill_1
XFILLER_54_192 VGND VGND VPWR VPWR sky130_fd_sc_hd__decap_3
XFILLER_24_50 VGND VGND VPWR VPWR sky130_fd_sc_hd__decap_3
XFILLER_42_365 VGND VGND VPWR VPWR sky130_fd_sc_hd__decap_3
XFILLER_24_83 VGND VGND VPWR VPWR sky130_fd_sc_hd__fill_1
XFILLER_10_251 VGND VGND VPWR VPWR sky130_fd_sc_hd__fill_1
XFILLER_10_262 VGND VGND VPWR VPWR sky130_fd_sc_hd__decap_3
XFILLER_6_200 VGND VGND VPWR VPWR sky130_fd_sc_hd__decap_3
XTAP_TAPCELL_ROW_40_577 VGND VPWR sky130_fd_sc_hd__tapvpwrvgnd_1
XFILLER_6_277 VGND VGND VPWR VPWR sky130_fd_sc_hd__decap_3
XFILLER_6_288 VGND VGND VPWR VPWR sky130_fd_sc_hd__decap_3
XFILLER_6_299 VGND VGND VPWR VPWR sky130_fd_sc_hd__decap_3
XFILLER_27_6 VGND VGND VPWR VPWR sky130_fd_sc_hd__decap_3
XFILLER_2_494 VGND VGND VPWR VPWR sky130_fd_sc_hd__decap_3
XFILLER_77_240 VGND VGND VPWR VPWR sky130_fd_sc_hd__decap_3
XFILLER_37_104 VGND VGND VPWR VPWR sky130_fd_sc_hd__decap_3
XFILLER_65_402 VGND VGND VPWR VPWR sky130_fd_sc_hd__fill_1
XTAP_TAPCELL_ROW_76_920 VGND VPWR sky130_fd_sc_hd__tapvpwrvgnd_1
XFILLER_77_262 VGND VGND VPWR VPWR sky130_fd_sc_hd__decap_3
XFILLER_77_284 VGND VGND VPWR VPWR sky130_fd_sc_hd__decap_3
XFILLER_18_362 VGND VGND VPWR VPWR sky130_fd_sc_hd__fill_2
XTAP_TAPCELL_ROW_48_655 VGND VPWR sky130_fd_sc_hd__tapvpwrvgnd_1
XFILLER_92_265 VGND VGND VPWR VPWR sky130_fd_sc_hd__decap_3
XFILLER_18_384 VGND VGND VPWR VPWR sky130_fd_sc_hd__decap_3
XFILLER_33_321 VGND VGND VPWR VPWR sky130_fd_sc_hd__decap_3
XFILLER_45_181 VGND VGND VPWR VPWR sky130_fd_sc_hd__decap_3
X_4900_ _5098_/CLK _4900_/D VGND VGND VPWR VPWR _4900_/Q sky130_fd_sc_hd__dfxtp_2
XFILLER_92_298 VGND VGND VPWR VPWR sky130_fd_sc_hd__decap_3
XFILLER_80_449 VGND VGND VPWR VPWR sky130_fd_sc_hd__decap_3
XFILLER_80_427 VGND VGND VPWR VPWR sky130_fd_sc_hd__fill_2
XFILLER_33_343 VGND VGND VPWR VPWR sky130_fd_sc_hd__decap_3
X_4831_ _5245_/Q _4847_/B VGND VGND VPWR VPWR _4831_/X sky130_fd_sc_hd__or2_2
XFILLER_21_505 VGND VGND VPWR VPWR sky130_fd_sc_hd__decap_3
XFILLER_21_538 VGND VGND VPWR VPWR sky130_fd_sc_hd__decap_3
XFILLER_33_376 VGND VGND VPWR VPWR sky130_fd_sc_hd__decap_3
XTAP_TAPCELL_ROW_31_500 VGND VPWR sky130_fd_sc_hd__tapvpwrvgnd_1
X_4762_ _4786_/A _4639_/X _4761_/X _4634_/Y VGND VGND VPWR VPWR _4763_/B sky130_fd_sc_hd__o22a_2
X_4693_ _4692_/A _4658_/X _4802_/A VGND VGND VPWR VPWR _4743_/B sky130_fd_sc_hd__mux2_1
X_3713_ _4429_/B _3883_/B VGND VGND VPWR VPWR _4750_/S sky130_fd_sc_hd__nor2_2
X_3644_ _4107_/B _4255_/A VGND VGND VPWR VPWR _4369_/A sky130_fd_sc_hd__nor2_2
X_3575_ _3570_/A _3567_/Y _3569_/B VGND VGND VPWR VPWR _3577_/C sky130_fd_sc_hd__o21a_2
XFILLER_0_409 VGND VGND VPWR VPWR sky130_fd_sc_hd__decap_3
X_2526_ _5159_/Q _4464_/A VGND VGND VPWR VPWR _4689_/S sky130_fd_sc_hd__nor2_2
XFILLER_88_516 VGND VGND VPWR VPWR sky130_fd_sc_hd__decap_3
X_5245_ _5252_/CLK _5245_/D VGND VGND VPWR VPWR _5245_/Q sky130_fd_sc_hd__dfxtp_2
X_2457_ _5171_/Q _5170_/Q _5169_/Q _5168_/Q VGND VGND VPWR VPWR _3457_/C sky130_fd_sc_hd__or4_2
XTAP_TAPCELL_ROW_93_1097 VGND VPWR sky130_fd_sc_hd__tapvpwrvgnd_1
XTAP_TAPCELL_ROW_93_1086 VGND VPWR sky130_fd_sc_hd__tapvpwrvgnd_1
XFILLER_88_538 VGND VGND VPWR VPWR sky130_fd_sc_hd__decap_3
XFILLER_56_413 VGND VGND VPWR VPWR sky130_fd_sc_hd__decap_3
XFILLER_68_251 VGND VGND VPWR VPWR sky130_fd_sc_hd__fill_1
X_5176_ _5252_/CLK _5176_/D VGND VGND VPWR VPWR _5176_/Q sky130_fd_sc_hd__dfxtp_2
XFILLER_28_115 VGND VGND VPWR VPWR sky130_fd_sc_hd__decap_3
XFILLER_56_424 VGND VGND VPWR VPWR sky130_fd_sc_hd__fill_2
X_4127_ _4127_/A VGND VGND VPWR VPWR _4128_/B sky130_fd_sc_hd__inv_2
XFILLER_71_405 VGND VGND VPWR VPWR sky130_fd_sc_hd__decap_3
X_4058_ _3962_/Y _3951_/X _4063_/A VGND VGND VPWR VPWR _4058_/X sky130_fd_sc_hd__mux2_1
XFILLER_83_276 VGND VGND VPWR VPWR sky130_fd_sc_hd__decap_3
XFILLER_71_438 VGND VGND VPWR VPWR sky130_fd_sc_hd__decap_3
XFILLER_71_449 VGND VGND VPWR VPWR sky130_fd_sc_hd__fill_1
X_3009_ _2903_/X _3006_/B _3006_/Y _4933_/Q VGND VGND VPWR VPWR _4933_/D sky130_fd_sc_hd__a22o_2
XFILLER_83_298 VGND VGND VPWR VPWR sky130_fd_sc_hd__decap_3
XFILLER_24_321 VGND VGND VPWR VPWR sky130_fd_sc_hd__decap_3
XTAP_TAPCELL_ROW_82_978 VGND VPWR sky130_fd_sc_hd__tapvpwrvgnd_1
XFILLER_24_365 VGND VGND VPWR VPWR sky130_fd_sc_hd__decap_3
XFILLER_51_184 VGND VGND VPWR VPWR sky130_fd_sc_hd__decap_3
XFILLER_3_225 VGND VGND VPWR VPWR sky130_fd_sc_hd__fill_2
XFILLER_86_12 VGND VGND VPWR VPWR sky130_fd_sc_hd__decap_3
XFILLER_59_251 VGND VGND VPWR VPWR sky130_fd_sc_hd__fill_1
XFILLER_59_273 VGND VGND VPWR VPWR sky130_fd_sc_hd__decap_3
XFILLER_86_78 VGND VGND VPWR VPWR sky130_fd_sc_hd__decap_3
XFILLER_47_424 VGND VGND VPWR VPWR sky130_fd_sc_hd__decap_3
XFILLER_59_284 VGND VGND VPWR VPWR sky130_fd_sc_hd__fill_2
XFILLER_34_118 VGND VGND VPWR VPWR sky130_fd_sc_hd__decap_3
XTAP_TAPCELL_ROW_45_625 VGND VPWR sky130_fd_sc_hd__tapvpwrvgnd_1
XFILLER_15_376 VGND VGND VPWR VPWR sky130_fd_sc_hd__decap_3
XFILLER_42_184 VGND VGND VPWR VPWR sky130_fd_sc_hd__decap_3
XFILLER_30_357 VGND VGND VPWR VPWR sky130_fd_sc_hd__decap_3
XFILLER_51_81 VGND VGND VPWR VPWR sky130_fd_sc_hd__decap_3
X_3360_ _3323_/Y _3335_/A _3361_/B _3361_/D VGND VGND VPWR VPWR _3360_/X sky130_fd_sc_hd__and4bb_2
X_5030_ _5063_/CLK _5030_/D VGND VGND VPWR VPWR _5030_/Q sky130_fd_sc_hd__dfxtp_2
X_3291_ _3291_/A VGND VGND VPWR VPWR _3293_/A sky130_fd_sc_hd__inv_2
XFILLER_25_3 VGND VGND VPWR VPWR sky130_fd_sc_hd__decap_3
XFILLER_65_221 VGND VGND VPWR VPWR sky130_fd_sc_hd__decap_3
XFILLER_38_457 VGND VGND VPWR VPWR sky130_fd_sc_hd__decap_3
XTAP_TAPCELL_ROW_0_206 VGND VPWR sky130_fd_sc_hd__tapvpwrvgnd_1
XFILLER_65_287 VGND VGND VPWR VPWR sky130_fd_sc_hd__decap_3
XFILLER_53_449 VGND VGND VPWR VPWR sky130_fd_sc_hd__decap_3
XFILLER_80_235 VGND VGND VPWR VPWR sky130_fd_sc_hd__fill_1
XFILLER_33_140 VGND VGND VPWR VPWR sky130_fd_sc_hd__decap_3
XFILLER_21_335 VGND VGND VPWR VPWR sky130_fd_sc_hd__fill_1
XFILLER_61_482 VGND VGND VPWR VPWR sky130_fd_sc_hd__decap_3
X_4814_ _4800_/Y _4813_/X _4866_/A VGND VGND VPWR VPWR _5237_/D sky130_fd_sc_hd__a21oi_2
X_4745_ _4745_/A VGND VGND VPWR VPWR _4745_/Y sky130_fd_sc_hd__inv_2
X_4676_ _4675_/X _4636_/X _4802_/A VGND VGND VPWR VPWR _4676_/X sky130_fd_sc_hd__mux2_1
X_3627_ _4249_/A _3634_/S VGND VGND VPWR VPWR _3627_/Y sky130_fd_sc_hd__nand2_2
X_3558_ _4714_/A _3558_/B VGND VGND VPWR VPWR _5201_/D sky130_fd_sc_hd__nor2_2
XFILLER_0_206 VGND VGND VPWR VPWR sky130_fd_sc_hd__decap_3
XFILLER_0_228 VGND VGND VPWR VPWR sky130_fd_sc_hd__decap_3
X_2509_ _5119_/Q _5007_/Q _4991_/Q _4975_/Q _5123_/Q _2671_/S1 VGND VGND VPWR VPWR
+ _2509_/X sky130_fd_sc_hd__mux4_2
X_3489_ _3489_/A _3585_/A _3487_/X VGND VGND VPWR VPWR _3489_/X sky130_fd_sc_hd__or3b_2
XFILLER_88_357 VGND VGND VPWR VPWR sky130_fd_sc_hd__decap_3
XFILLER_29_402 VGND VGND VPWR VPWR sky130_fd_sc_hd__decap_3
X_5228_ _5241_/CLK _5228_/D VGND VGND VPWR VPWR _5228_/Q sky130_fd_sc_hd__dfxtp_2
X_5159_ _5177_/CLK _5159_/D VGND VGND VPWR VPWR _5159_/Q sky130_fd_sc_hd__dfxtp_2
XFILLER_29_468 VGND VGND VPWR VPWR sky130_fd_sc_hd__decap_3
XFILLER_56_265 VGND VGND VPWR VPWR sky130_fd_sc_hd__decap_3
XFILLER_56_59 VGND VGND VPWR VPWR sky130_fd_sc_hd__decap_3
XFILLER_56_298 VGND VGND VPWR VPWR sky130_fd_sc_hd__decap_3
XFILLER_71_246 VGND VGND VPWR VPWR sky130_fd_sc_hd__decap_3
XFILLER_52_460 VGND VGND VPWR VPWR sky130_fd_sc_hd__decap_3
XFILLER_12_335 VGND VGND VPWR VPWR sky130_fd_sc_hd__decap_3
XTAP_TAPCELL_ROW_50_672 VGND VPWR sky130_fd_sc_hd__tapvpwrvgnd_1
XFILLER_79_313 VGND VGND VPWR VPWR sky130_fd_sc_hd__decap_3
XFILLER_67_508 VGND VGND VPWR VPWR sky130_fd_sc_hd__decap_3
XFILLER_79_368 VGND VGND VPWR VPWR sky130_fd_sc_hd__decap_3
XFILLER_47_210 VGND VGND VPWR VPWR sky130_fd_sc_hd__decap_3
XFILLER_35_405 VGND VGND VPWR VPWR sky130_fd_sc_hd__decap_3
XFILLER_47_254 VGND VGND VPWR VPWR sky130_fd_sc_hd__decap_3
XTAP_TAPCELL_ROW_58_750 VGND VPWR sky130_fd_sc_hd__tapvpwrvgnd_1
XFILLER_75_552 VGND VGND VPWR VPWR sky130_fd_sc_hd__fill_1
XFILLER_47_298 VGND VGND VPWR VPWR sky130_fd_sc_hd__fill_2
XFILLER_35_449 VGND VGND VPWR VPWR sky130_fd_sc_hd__decap_3
XFILLER_50_408 VGND VGND VPWR VPWR sky130_fd_sc_hd__decap_3
XFILLER_62_279 VGND VGND VPWR VPWR sky130_fd_sc_hd__decap_3
XFILLER_70_290 VGND VGND VPWR VPWR sky130_fd_sc_hd__decap_3
X_2860_ _2887_/B _2860_/B VGND VGND VPWR VPWR _2860_/Y sky130_fd_sc_hd__nor2_2
X_2791_ _5068_/Q _5052_/Q _5036_/Q _5020_/Q _2812_/S0 _2848_/S1 VGND VGND VPWR VPWR
+ _2791_/X sky130_fd_sc_hd__mux4_2
XFILLER_11_390 VGND VGND VPWR VPWR sky130_fd_sc_hd__fill_2
X_4530_ _4493_/A _4067_/A _4449_/B _4445_/B VGND VGND VPWR VPWR _4530_/X sky130_fd_sc_hd__a211o_2
XFILLER_7_42 VGND VGND VPWR VPWR sky130_fd_sc_hd__decap_3
XFILLER_7_350 VGND VGND VPWR VPWR sky130_fd_sc_hd__decap_3
X_4461_ _4461_/A _4461_/B VGND VGND VPWR VPWR _4512_/A sky130_fd_sc_hd__nor2_2
XFILLER_7_97 VGND VGND VPWR VPWR sky130_fd_sc_hd__decap_3
X_3412_ _5260_/Q _3448_/B _3412_/C VGND VGND VPWR VPWR _3412_/X sky130_fd_sc_hd__and3_2
X_4392_ _5155_/Q _4402_/A VGND VGND VPWR VPWR _4534_/C sky130_fd_sc_hd__or2_2
X_3343_ _5160_/Q _3323_/B _3332_/B _5161_/Q VGND VGND VPWR VPWR _3361_/C sky130_fd_sc_hd__a22o_2
XTAP_TAPCELL_ROW_90_1056 VGND VPWR sky130_fd_sc_hd__tapvpwrvgnd_1
X_3274_ _5136_/Q _5135_/Q VGND VGND VPWR VPWR _3286_/B sky130_fd_sc_hd__and2_2
X_5013_ _5063_/CLK _5013_/D VGND VGND VPWR VPWR _5013_/Q sky130_fd_sc_hd__dfxtp_2
XFILLER_85_349 VGND VGND VPWR VPWR sky130_fd_sc_hd__fill_2
XFILLER_26_405 VGND VGND VPWR VPWR sky130_fd_sc_hd__decap_3
XFILLER_53_213 VGND VGND VPWR VPWR sky130_fd_sc_hd__decap_3
XFILLER_93_371 VGND VGND VPWR VPWR sky130_fd_sc_hd__decap_3
XFILLER_53_246 VGND VGND VPWR VPWR sky130_fd_sc_hd__decap_3
XPHY_EDGE_ROW_5_Right_5 VGND VGND VPWR VPWR sky130_fd_sc_hd__decap_3
XFILLER_81_533 VGND VGND VPWR VPWR sky130_fd_sc_hd__decap_3
XFILLER_41_408 VGND VGND VPWR VPWR sky130_fd_sc_hd__decap_3
XFILLER_21_132 VGND VGND VPWR VPWR sky130_fd_sc_hd__fill_2
XFILLER_21_187 VGND VGND VPWR VPWR sky130_fd_sc_hd__decap_3
X_2989_ _2900_/X _2986_/Y _2987_/Y _4916_/Q VGND VGND VPWR VPWR _4916_/D sky130_fd_sc_hd__a22o_2
X_4728_ _5231_/Q _4800_/B VGND VGND VPWR VPWR _4728_/Y sky130_fd_sc_hd__nand2_2
X_4659_ _4658_/X _4605_/X _4802_/A VGND VGND VPWR VPWR _4722_/B sky130_fd_sc_hd__mux2_1
XFILLER_1_526 VGND VGND VPWR VPWR sky130_fd_sc_hd__decap_3
XFILLER_67_36 VGND VGND VPWR VPWR sky130_fd_sc_hd__fill_2
XFILLER_76_305 VGND VGND VPWR VPWR sky130_fd_sc_hd__decap_3
XFILLER_76_349 VGND VGND VPWR VPWR sky130_fd_sc_hd__decap_3
XFILLER_57_552 VGND VGND VPWR VPWR sky130_fd_sc_hd__fill_1
XFILLER_29_276 VGND VGND VPWR VPWR sky130_fd_sc_hd__decap_3
XFILLER_44_213 VGND VGND VPWR VPWR sky130_fd_sc_hd__decap_3
XFILLER_72_522 VGND VGND VPWR VPWR sky130_fd_sc_hd__decap_3
XFILLER_84_371 VGND VGND VPWR VPWR sky130_fd_sc_hd__decap_3
XFILLER_17_449 VGND VGND VPWR VPWR sky130_fd_sc_hd__decap_3
XFILLER_72_533 VGND VGND VPWR VPWR sky130_fd_sc_hd__decap_3
XTAP_TAPCELL_ROW_55_720 VGND VPWR sky130_fd_sc_hd__tapvpwrvgnd_1
XFILLER_84_393 VGND VGND VPWR VPWR sky130_fd_sc_hd__decap_3
XTAP_TAPCELL_ROW_27_455 VGND VPWR sky130_fd_sc_hd__tapvpwrvgnd_1
XFILLER_83_79 VGND VGND VPWR VPWR sky130_fd_sc_hd__decap_3
XFILLER_40_430 VGND VGND VPWR VPWR sky130_fd_sc_hd__decap_3
XFILLER_40_474 VGND VGND VPWR VPWR sky130_fd_sc_hd__fill_2
XTAP_TAPCELL_ROW_10_300 VGND VPWR sky130_fd_sc_hd__tapvpwrvgnd_1
XFILLER_8_125 VGND VGND VPWR VPWR sky130_fd_sc_hd__decap_3
XFILLER_4_397 VGND VGND VPWR VPWR sky130_fd_sc_hd__fill_2
XFILLER_67_305 VGND VGND VPWR VPWR sky130_fd_sc_hd__decap_3
XFILLER_79_154 VGND VGND VPWR VPWR sky130_fd_sc_hd__decap_3
XFILLER_63_511 VGND VGND VPWR VPWR sky130_fd_sc_hd__decap_3
XFILLER_75_382 VGND VGND VPWR VPWR sky130_fd_sc_hd__decap_3
XFILLER_63_544 VGND VGND VPWR VPWR sky130_fd_sc_hd__decap_3
X_3961_ _4477_/A _4787_/S VGND VGND VPWR VPWR _3961_/Y sky130_fd_sc_hd__nand2b_2
XFILLER_50_216 VGND VGND VPWR VPWR sky130_fd_sc_hd__decap_3
XFILLER_50_227 VGND VGND VPWR VPWR sky130_fd_sc_hd__decap_3
X_2912_ _5227_/Q _4850_/A _3458_/B _5211_/Q VGND VGND VPWR VPWR _2912_/X sky130_fd_sc_hd__a22o_2
XFILLER_43_290 VGND VGND VPWR VPWR sky130_fd_sc_hd__decap_3
X_3892_ _3892_/A _3892_/B VGND VGND VPWR VPWR _3892_/Y sky130_fd_sc_hd__nand2_2
XTAP_TAPCELL_ROW_61_778 VGND VPWR sky130_fd_sc_hd__tapvpwrvgnd_1
XFILLER_92_3 VGND VGND VPWR VPWR sky130_fd_sc_hd__decap_3
X_2843_ _4898_/Q _4882_/Q _5106_/Q _5090_/Q _5131_/Q _5132_/Q VGND VGND VPWR VPWR
+ _2844_/B sky130_fd_sc_hd__mux4_2
X_2774_ _4954_/Q _4938_/Q _4922_/Q _4906_/Q _5131_/Q _2848_/S1 VGND VGND VPWR VPWR
+ _2775_/B sky130_fd_sc_hd__mux4_2
X_4513_ _4512_/A _4512_/B _4002_/Y VGND VGND VPWR VPWR _4513_/Y sky130_fd_sc_hd__o21ai_2
X_4444_ _4444_/A _4444_/B VGND VGND VPWR VPWR _4452_/A sky130_fd_sc_hd__or2_2
X_4375_ _4375_/A _4375_/B _4375_/C _4374_/X VGND VGND VPWR VPWR _4375_/X sky130_fd_sc_hd__or4b_2
X_3326_ _5141_/Q _3327_/B VGND VGND VPWR VPWR _3347_/C sky130_fd_sc_hd__and2_2
XFILLER_58_338 VGND VGND VPWR VPWR sky130_fd_sc_hd__decap_3
XFILLER_85_113 VGND VGND VPWR VPWR sky130_fd_sc_hd__decap_3
XFILLER_39_552 VGND VGND VPWR VPWR sky130_fd_sc_hd__fill_1
XFILLER_73_308 VGND VGND VPWR VPWR sky130_fd_sc_hd__decap_3
X_3257_ _3257_/A _3257_/B VGND VGND VPWR VPWR _3262_/A sky130_fd_sc_hd__nor2_2
XTAP_TAPCELL_ROW_69_856 VGND VPWR sky130_fd_sc_hd__tapvpwrvgnd_1
XFILLER_54_511 VGND VGND VPWR VPWR sky130_fd_sc_hd__decap_3
X_3188_ _2944_/X _3172_/B _3172_/Y _5090_/Q VGND VGND VPWR VPWR _5090_/D sky130_fd_sc_hd__a22o_2
XFILLER_26_224 VGND VGND VPWR VPWR sky130_fd_sc_hd__decap_3
XFILLER_66_393 VGND VGND VPWR VPWR sky130_fd_sc_hd__fill_2
XFILLER_14_419 VGND VGND VPWR VPWR sky130_fd_sc_hd__fill_1
XFILLER_81_352 VGND VGND VPWR VPWR sky130_fd_sc_hd__decap_3
XFILLER_53_49 VGND VGND VPWR VPWR sky130_fd_sc_hd__decap_3
XTAP_TAPCELL_ROW_24_425 VGND VPWR sky130_fd_sc_hd__tapvpwrvgnd_1
XFILLER_81_396 VGND VGND VPWR VPWR sky130_fd_sc_hd__decap_3
XFILLER_78_24 VGND VGND VPWR VPWR sky130_fd_sc_hd__decap_3
XFILLER_49_305 VGND VGND VPWR VPWR sky130_fd_sc_hd__decap_3
XFILLER_89_463 VGND VGND VPWR VPWR sky130_fd_sc_hd__fill_1
XFILLER_89_452 VGND VGND VPWR VPWR sky130_fd_sc_hd__fill_2
XFILLER_89_485 VGND VGND VPWR VPWR sky130_fd_sc_hd__decap_3
XFILLER_76_124 VGND VGND VPWR VPWR sky130_fd_sc_hd__decap_3
XFILLER_76_102 VGND VGND VPWR VPWR sky130_fd_sc_hd__decap_3
XFILLER_49_349 VGND VGND VPWR VPWR sky130_fd_sc_hd__decap_3
XFILLER_17_202 VGND VGND VPWR VPWR sky130_fd_sc_hd__decap_3
XFILLER_45_511 VGND VGND VPWR VPWR sky130_fd_sc_hd__decap_3
XFILLER_57_382 VGND VGND VPWR VPWR sky130_fd_sc_hd__decap_3
XFILLER_57_393 VGND VGND VPWR VPWR sky130_fd_sc_hd__decap_3
XFILLER_17_257 VGND VGND VPWR VPWR sky130_fd_sc_hd__decap_3
XFILLER_27_83 VGND VGND VPWR VPWR sky130_fd_sc_hd__fill_1
XFILLER_32_205 VGND VGND VPWR VPWR sky130_fd_sc_hd__decap_3
XFILLER_60_503 VGND VGND VPWR VPWR sky130_fd_sc_hd__decap_3
XFILLER_32_216 VGND VGND VPWR VPWR sky130_fd_sc_hd__decap_3
XFILLER_60_547 VGND VGND VPWR VPWR sky130_fd_sc_hd__decap_3
XFILLER_32_249 VGND VGND VPWR VPWR sky130_fd_sc_hd__decap_3
XFILLER_43_82 VGND VGND VPWR VPWR sky130_fd_sc_hd__decap_3
XFILLER_40_293 VGND VGND VPWR VPWR sky130_fd_sc_hd__decap_3
XFILLER_9_478 VGND VGND VPWR VPWR sky130_fd_sc_hd__decap_3
XFILLER_4_150 VGND VGND VPWR VPWR sky130_fd_sc_hd__decap_3
X_2490_ _2689_/A _2490_/B VGND VGND VPWR VPWR _3681_/B sky130_fd_sc_hd__and2_2
XFILLER_4_32 VGND VGND VPWR VPWR sky130_fd_sc_hd__fill_2
X_4160_ _4173_/A _4031_/X _4076_/Y VGND VGND VPWR VPWR _4160_/X sky130_fd_sc_hd__o21a_2
X_3111_ _2932_/X _3099_/B _3099_/Y _5022_/Q VGND VGND VPWR VPWR _5022_/D sky130_fd_sc_hd__a22o_2
XFILLER_67_157 VGND VGND VPWR VPWR sky130_fd_sc_hd__fill_1
X_4091_ _4091_/A _4091_/B VGND VGND VPWR VPWR _4091_/X sky130_fd_sc_hd__or2_2
XFILLER_36_511 VGND VGND VPWR VPWR sky130_fd_sc_hd__decap_3
XFILLER_48_360 VGND VGND VPWR VPWR sky130_fd_sc_hd__decap_3
X_3042_ _3171_/B _3078_/B VGND VGND VPWR VPWR _3043_/B sky130_fd_sc_hd__nor2_2
XTAP_TAPCELL_ROW_66_826 VGND VPWR sky130_fd_sc_hd__tapvpwrvgnd_1
XFILLER_82_127 VGND VGND VPWR VPWR sky130_fd_sc_hd__decap_3
XFILLER_51_503 VGND VGND VPWR VPWR sky130_fd_sc_hd__fill_1
XFILLER_63_396 VGND VGND VPWR VPWR sky130_fd_sc_hd__decap_3
X_4993_ _5121_/CLK _4993_/D VGND VGND VPWR VPWR _4993_/Q sky130_fd_sc_hd__dfxtp_2
X_3944_ _5166_/Q _4551_/A VGND VGND VPWR VPWR _4361_/B sky130_fd_sc_hd__nand2b_2
XFILLER_90_193 VGND VGND VPWR VPWR sky130_fd_sc_hd__decap_3
X_3875_ _3875_/A _3875_/B _3940_/A _3875_/D VGND VGND VPWR VPWR _3875_/Y sky130_fd_sc_hd__nor4_2
X_2826_ _4896_/Q _4880_/Q _5104_/Q _5088_/Q _5131_/Q _5132_/Q VGND VGND VPWR VPWR
+ _2827_/B sky130_fd_sc_hd__mux4_2
X_2757_ _5112_/Q _5000_/Q _4984_/Q _4968_/Q _2812_/S0 _2848_/S1 VGND VGND VPWR VPWR
+ _2757_/X sky130_fd_sc_hd__mux4_2
X_2688_ _2886_/B _2684_/A _2882_/A _2502_/Y _2886_/A VGND VGND VPWR VPWR _4333_/C
+ sky130_fd_sc_hd__a311o_2
X_4427_ _4687_/A _4417_/X _4641_/B _4426_/X VGND VGND VPWR VPWR _4427_/X sky130_fd_sc_hd__o22a_2
XFILLER_58_102 VGND VGND VPWR VPWR sky130_fd_sc_hd__decap_3
X_4358_ _4360_/A _4356_/Y _4357_/Y VGND VGND VPWR VPWR _4358_/X sky130_fd_sc_hd__o21a_2
XFILLER_86_433 VGND VGND VPWR VPWR sky130_fd_sc_hd__decap_3
XFILLER_86_400 VGND VGND VPWR VPWR sky130_fd_sc_hd__fill_2
X_4289_ _4291_/A _4289_/B VGND VGND VPWR VPWR _4289_/Y sky130_fd_sc_hd__xnor2_2
X_3309_ _2425_/Y _3307_/Y _3308_/X _5151_/Q _5256_/Q VGND VGND VPWR VPWR _3309_/X
+ sky130_fd_sc_hd__a311o_2
XFILLER_86_466 VGND VGND VPWR VPWR sky130_fd_sc_hd__fill_1
XFILLER_73_116 VGND VGND VPWR VPWR sky130_fd_sc_hd__decap_3
XFILLER_39_382 VGND VGND VPWR VPWR sky130_fd_sc_hd__decap_3
XFILLER_39_393 VGND VGND VPWR VPWR sky130_fd_sc_hd__decap_3
XFILLER_64_59 VGND VGND VPWR VPWR sky130_fd_sc_hd__decap_3
XTAP_TAPCELL_ROW_37_550 VGND VPWR sky130_fd_sc_hd__tapvpwrvgnd_1
XFILLER_42_536 VGND VGND VPWR VPWR sky130_fd_sc_hd__decap_3
XFILLER_54_374 VGND VGND VPWR VPWR sky130_fd_sc_hd__decap_3
XFILLER_54_385 VGND VGND VPWR VPWR sky130_fd_sc_hd__decap_3
XFILLER_6_404 VGND VGND VPWR VPWR sky130_fd_sc_hd__decap_3
XFILLER_10_488 VGND VGND VPWR VPWR sky130_fd_sc_hd__fill_2
XFILLER_1_186 VGND VGND VPWR VPWR sky130_fd_sc_hd__decap_3
XTAP_TAPCELL_ROW_9_286 VGND VPWR sky130_fd_sc_hd__tapvpwrvgnd_1
XFILLER_77_411 VGND VGND VPWR VPWR sky130_fd_sc_hd__decap_3
XFILLER_77_455 VGND VGND VPWR VPWR sky130_fd_sc_hd__decap_3
XFILLER_77_444 VGND VGND VPWR VPWR sky130_fd_sc_hd__decap_3
XFILLER_18_533 VGND VGND VPWR VPWR sky130_fd_sc_hd__fill_2
XFILLER_92_469 VGND VGND VPWR VPWR sky130_fd_sc_hd__decap_3
XFILLER_33_536 VGND VGND VPWR VPWR sky130_fd_sc_hd__decap_3
XFILLER_45_385 VGND VGND VPWR VPWR sky130_fd_sc_hd__decap_3
XFILLER_45_396 VGND VGND VPWR VPWR sky130_fd_sc_hd__decap_3
XFILLER_13_260 VGND VGND VPWR VPWR sky130_fd_sc_hd__decap_3
XTAP_TAPCELL_ROW_71_873 VGND VPWR sky130_fd_sc_hd__tapvpwrvgnd_1
XFILLER_9_231 VGND VGND VPWR VPWR sky130_fd_sc_hd__decap_3
X_3660_ _3659_/X _3657_/Y _4077_/S VGND VGND VPWR VPWR _3660_/X sky130_fd_sc_hd__mux2_1
XFILLER_70_91 VGND VGND VPWR VPWR sky130_fd_sc_hd__decap_3
Xclkload34 _5118_/CLK VGND VGND VPWR VPWR clkload34/Y sky130_fd_sc_hd__bufinv_16
Xclkload23 _5114_/CLK VGND VGND VPWR VPWR clkload23/X sky130_fd_sc_hd__clkbuf_8
Xclkload12 _5115_/CLK VGND VGND VPWR VPWR clkload12/X sky130_fd_sc_hd__clkbuf_4
X_3591_ _5129_/Q _3591_/B VGND VGND VPWR VPWR _3591_/X sky130_fd_sc_hd__or2_2
X_2611_ _5155_/Q _4493_/A VGND VGND VPWR VPWR _3932_/B sky130_fd_sc_hd__nand2_2
X_2542_ _4952_/Q _4936_/Q _4920_/Q _4904_/Q _2658_/S0 _2671_/S1 VGND VGND VPWR VPWR
+ _2542_/X sky130_fd_sc_hd__mux4_2
X_5261_ _5262_/CLK _5261_/D VGND VGND VPWR VPWR _5261_/Q sky130_fd_sc_hd__dfxtp_2
X_4212_ _4224_/A _4223_/C _4198_/Y _4712_/A _4211_/X VGND VGND VPWR VPWR _4212_/X
+ sky130_fd_sc_hd__o311a_2
X_2473_ _4962_/Q _4946_/Q _4930_/Q _4914_/Q _5123_/Q _2671_/S1 VGND VGND VPWR VPWR
+ _2473_/X sky130_fd_sc_hd__mux4_2
X_5192_ _5241_/CLK _5192_/D VGND VGND VPWR VPWR _5192_/Q sky130_fd_sc_hd__dfxtp_2
XFILLER_87_219 VGND VGND VPWR VPWR sky130_fd_sc_hd__decap_3
X_4143_ _3934_/C _3932_/Y _3933_/X _3936_/B _4224_/A VGND VGND VPWR VPWR _4143_/X
+ sky130_fd_sc_hd__a311o_2
XTAP_TAPCELL_ROW_79_951 VGND VPWR sky130_fd_sc_hd__tapvpwrvgnd_1
XFILLER_68_477 VGND VGND VPWR VPWR sky130_fd_sc_hd__decap_3
XFILLER_68_488 VGND VGND VPWR VPWR sky130_fd_sc_hd__decap_3
X_4074_ _4173_/A _4173_/B VGND VGND VPWR VPWR _4074_/Y sky130_fd_sc_hd__nand2_2
XFILLER_55_127 VGND VGND VPWR VPWR sky130_fd_sc_hd__decap_3
X_3025_ _2891_/X _3024_/B _3024_/Y _4947_/Q VGND VGND VPWR VPWR _4947_/D sky130_fd_sc_hd__a22o_2
XTAP_TAPCELL_ROW_87_1028 VGND VPWR sky130_fd_sc_hd__tapvpwrvgnd_1
XFILLER_83_447 VGND VGND VPWR VPWR sky130_fd_sc_hd__fill_1
XFILLER_51_311 VGND VGND VPWR VPWR sky130_fd_sc_hd__fill_2
XFILLER_24_547 VGND VGND VPWR VPWR sky130_fd_sc_hd__decap_3
XTAP_TAPCELL_ROW_34_520 VGND VPWR sky130_fd_sc_hd__tapvpwrvgnd_1
XFILLER_11_208 VGND VGND VPWR VPWR sky130_fd_sc_hd__decap_3
XFILLER_51_366 VGND VGND VPWR VPWR sky130_fd_sc_hd__decap_3
X_4976_ _5115_/CLK _4976_/D VGND VGND VPWR VPWR _4976_/Q sky130_fd_sc_hd__dfxtp_2
XFILLER_51_399 VGND VGND VPWR VPWR sky130_fd_sc_hd__decap_3
X_3927_ _2607_/Y _3925_/Y _3926_/X VGND VGND VPWR VPWR _4048_/B sky130_fd_sc_hd__a21oi_2
Xclkload6 clkload6/A VGND VGND VPWR VPWR clkload6/X sky130_fd_sc_hd__clkbuf_8
X_3858_ _4493_/B _4523_/S VGND VGND VPWR VPWR _4421_/C sky130_fd_sc_hd__or2_2
X_3789_ _3784_/X _3785_/X _3788_/X _2432_/Y VGND VGND VPWR VPWR _3885_/B sky130_fd_sc_hd__a22o_2
X_2809_ _5070_/Q _5054_/Q _5038_/Q _5022_/Q _2812_/S0 _2848_/S1 VGND VGND VPWR VPWR
+ _2809_/X sky130_fd_sc_hd__mux4_2
XFILLER_3_418 VGND VGND VPWR VPWR sky130_fd_sc_hd__decap_3
XFILLER_59_411 VGND VGND VPWR VPWR sky130_fd_sc_hd__decap_3
XTAP_TAPCELL_ROW_6_256 VGND VPWR sky130_fd_sc_hd__tapvpwrvgnd_1
XFILLER_86_241 VGND VGND VPWR VPWR sky130_fd_sc_hd__decap_3
XFILLER_59_477 VGND VGND VPWR VPWR sky130_fd_sc_hd__decap_3
XFILLER_74_414 VGND VGND VPWR VPWR sky130_fd_sc_hd__decap_3
XFILLER_75_36 VGND VGND VPWR VPWR sky130_fd_sc_hd__decap_3
XFILLER_46_138 VGND VGND VPWR VPWR sky130_fd_sc_hd__fill_2
XFILLER_74_447 VGND VGND VPWR VPWR sky130_fd_sc_hd__decap_3
XFILLER_86_285 VGND VGND VPWR VPWR sky130_fd_sc_hd__decap_3
XFILLER_74_469 VGND VGND VPWR VPWR sky130_fd_sc_hd__fill_2
XFILLER_82_480 VGND VGND VPWR VPWR sky130_fd_sc_hd__decap_3
XFILLER_15_547 VGND VGND VPWR VPWR sky130_fd_sc_hd__decap_3
XFILLER_42_377 VGND VGND VPWR VPWR sky130_fd_sc_hd__decap_3
XTAP_TAPCELL_ROW_40_578 VGND VPWR sky130_fd_sc_hd__tapvpwrvgnd_1
XFILLER_10_285 VGND VGND VPWR VPWR sky130_fd_sc_hd__decap_3
XFILLER_40_61 VGND VGND VPWR VPWR sky130_fd_sc_hd__decap_3
XFILLER_6_245 VGND VGND VPWR VPWR sky130_fd_sc_hd__decap_3
XFILLER_6_256 VGND VGND VPWR VPWR sky130_fd_sc_hd__decap_3
XFILLER_40_83 VGND VGND VPWR VPWR sky130_fd_sc_hd__fill_1
XFILLER_40_94 VGND VGND VPWR VPWR sky130_fd_sc_hd__decap_3
XFILLER_65_414 VGND VGND VPWR VPWR sky130_fd_sc_hd__decap_3
XFILLER_92_200 VGND VGND VPWR VPWR sky130_fd_sc_hd__fill_2
XFILLER_1_33 VGND VGND VPWR VPWR sky130_fd_sc_hd__decap_3
XFILLER_1_55 VGND VGND VPWR VPWR sky130_fd_sc_hd__fill_1
XFILLER_37_116 VGND VGND VPWR VPWR sky130_fd_sc_hd__decap_3
XFILLER_37_127 VGND VGND VPWR VPWR sky130_fd_sc_hd__decap_3
XTAP_TAPCELL_ROW_76_921 VGND VPWR sky130_fd_sc_hd__tapvpwrvgnd_1
XFILLER_77_296 VGND VGND VPWR VPWR sky130_fd_sc_hd__decap_3
XFILLER_1_77 VGND VGND VPWR VPWR sky130_fd_sc_hd__fill_1
XFILLER_65_458 VGND VGND VPWR VPWR sky130_fd_sc_hd__decap_3
XTAP_TAPCELL_ROW_48_656 VGND VPWR sky130_fd_sc_hd__tapvpwrvgnd_1
XFILLER_80_406 VGND VGND VPWR VPWR sky130_fd_sc_hd__decap_3
XFILLER_92_277 VGND VGND VPWR VPWR sky130_fd_sc_hd__decap_3
XFILLER_18_396 VGND VGND VPWR VPWR sky130_fd_sc_hd__decap_3
XFILLER_33_333 VGND VGND VPWR VPWR sky130_fd_sc_hd__decap_3
XFILLER_33_355 VGND VGND VPWR VPWR sky130_fd_sc_hd__decap_3
X_4830_ input45/X _4816_/Y _4829_/X _3442_/B VGND VGND VPWR VPWR _5244_/D sky130_fd_sc_hd__o211a_2
XFILLER_33_388 VGND VGND VPWR VPWR sky130_fd_sc_hd__decap_3
XFILLER_60_185 VGND VGND VPWR VPWR sky130_fd_sc_hd__decap_3
X_4761_ _4760_/X _4708_/X _4804_/A VGND VGND VPWR VPWR _4761_/X sky130_fd_sc_hd__mux2_1
X_4692_ _4692_/A VGND VGND VPWR VPWR _4692_/Y sky130_fd_sc_hd__inv_2
X_3712_ _3706_/X _3708_/X _3711_/X _2432_/Y VGND VGND VPWR VPWR _3883_/B sky130_fd_sc_hd__a22o_2
X_3643_ _4763_/A _3643_/B VGND VGND VPWR VPWR _4255_/A sky130_fd_sc_hd__or2_2
X_3574_ _5166_/Q _5147_/Q VGND VGND VPWR VPWR _3577_/B sky130_fd_sc_hd__nor2_2
X_2525_ _5159_/Q _4464_/A VGND VGND VPWR VPWR _2623_/A sky130_fd_sc_hd__and2_2
X_5244_ _5263_/CLK _5244_/D VGND VGND VPWR VPWR _5244_/Q sky130_fd_sc_hd__dfxtp_2
X_2456_ _5183_/Q _5182_/Q _5181_/Q _5180_/Q VGND VGND VPWR VPWR _3457_/B sky130_fd_sc_hd__or4_2
XTAP_TAPCELL_ROW_93_1098 VGND VPWR sky130_fd_sc_hd__tapvpwrvgnd_1
XTAP_TAPCELL_ROW_93_1087 VGND VPWR sky130_fd_sc_hd__tapvpwrvgnd_1
XFILLER_88_528 VGND VGND VPWR VPWR sky130_fd_sc_hd__decap_3
X_5175_ clkload5/A _5175_/D VGND VGND VPWR VPWR _5175_/Q sky130_fd_sc_hd__dfxtp_2
XFILLER_68_241 VGND VGND VPWR VPWR sky130_fd_sc_hd__decap_3
XFILLER_68_274 VGND VGND VPWR VPWR sky130_fd_sc_hd__decap_3
X_4126_ _3984_/B _4229_/B _4339_/A VGND VGND VPWR VPWR _4127_/A sky130_fd_sc_hd__mux2_1
XTAP_TAPCELL_ROW_3_226 VGND VPWR sky130_fd_sc_hd__tapvpwrvgnd_1
XFILLER_28_138 VGND VGND VPWR VPWR sky130_fd_sc_hd__fill_2
XFILLER_83_200 VGND VGND VPWR VPWR sky130_fd_sc_hd__decap_3
X_4057_ _4020_/Y _4056_/X _4866_/A VGND VGND VPWR VPWR _5208_/D sky130_fd_sc_hd__a21oi_2
XFILLER_36_160 VGND VGND VPWR VPWR sky130_fd_sc_hd__fill_1
XFILLER_64_480 VGND VGND VPWR VPWR sky130_fd_sc_hd__decap_3
XFILLER_71_417 VGND VGND VPWR VPWR sky130_fd_sc_hd__decap_3
X_3008_ _2900_/X _3005_/Y _3006_/Y _4932_/Q VGND VGND VPWR VPWR _4932_/D sky130_fd_sc_hd__a22o_2
XTAP_TAPCELL_ROW_82_979 VGND VPWR sky130_fd_sc_hd__tapvpwrvgnd_1
XTAP_TAPCELL_ROW_19_380 VGND VPWR sky130_fd_sc_hd__tapvpwrvgnd_1
XFILLER_12_506 VGND VGND VPWR VPWR sky130_fd_sc_hd__fill_2
XFILLER_61_27 VGND VGND VPWR VPWR sky130_fd_sc_hd__decap_3
X_4959_ _5007_/CLK _4959_/D VGND VGND VPWR VPWR _4959_/Q sky130_fd_sc_hd__dfxtp_2
XFILLER_20_550 VGND VGND VPWR VPWR sky130_fd_sc_hd__decap_3
XFILLER_10_75 VGND VGND VPWR VPWR sky130_fd_sc_hd__decap_3
XFILLER_79_517 VGND VGND VPWR VPWR sky130_fd_sc_hd__decap_3
XFILLER_86_46 VGND VGND VPWR VPWR sky130_fd_sc_hd__decap_3
XFILLER_47_403 VGND VGND VPWR VPWR sky130_fd_sc_hd__fill_2
XFILLER_87_550 VGND VGND VPWR VPWR sky130_fd_sc_hd__decap_3
XFILLER_19_73 VGND VGND VPWR VPWR sky130_fd_sc_hd__fill_1
XFILLER_74_222 VGND VGND VPWR VPWR sky130_fd_sc_hd__fill_1
XFILLER_47_458 VGND VGND VPWR VPWR sky130_fd_sc_hd__fill_2
XFILLER_15_311 VGND VGND VPWR VPWR sky130_fd_sc_hd__decap_3
XFILLER_27_160 VGND VGND VPWR VPWR sky130_fd_sc_hd__decap_3
XFILLER_62_417 VGND VGND VPWR VPWR sky130_fd_sc_hd__decap_3
XFILLER_74_277 VGND VGND VPWR VPWR sky130_fd_sc_hd__decap_3
XTAP_TAPCELL_ROW_45_626 VGND VPWR sky130_fd_sc_hd__tapvpwrvgnd_1
XFILLER_55_491 VGND VGND VPWR VPWR sky130_fd_sc_hd__decap_3
XFILLER_15_355 VGND VGND VPWR VPWR sky130_fd_sc_hd__fill_2
XFILLER_70_472 VGND VGND VPWR VPWR sky130_fd_sc_hd__decap_3
X_3290_ _5157_/Q _3292_/B VGND VGND VPWR VPWR _3291_/A sky130_fd_sc_hd__or2_2
XPHY_EDGE_ROW_29_Left_123 VGND VGND VPWR VPWR sky130_fd_sc_hd__decap_3
XFILLER_18_3 VGND VGND VPWR VPWR sky130_fd_sc_hd__decap_3
XFILLER_93_520 VGND VGND VPWR VPWR sky130_fd_sc_hd__decap_3
XFILLER_38_469 VGND VGND VPWR VPWR sky130_fd_sc_hd__decap_3
XFILLER_65_266 VGND VGND VPWR VPWR sky130_fd_sc_hd__decap_3
XFILLER_93_542 VGND VGND VPWR VPWR sky130_fd_sc_hd__decap_3
XFILLER_53_417 VGND VGND VPWR VPWR sky130_fd_sc_hd__decap_3
XFILLER_53_439 VGND VGND VPWR VPWR sky130_fd_sc_hd__decap_3
XFILLER_46_480 VGND VGND VPWR VPWR sky130_fd_sc_hd__decap_3
XFILLER_80_247 VGND VGND VPWR VPWR sky130_fd_sc_hd__decap_3
XFILLER_61_461 VGND VGND VPWR VPWR sky130_fd_sc_hd__decap_3
XTAP_TAPCELL_ROW_16_350 VGND VPWR sky130_fd_sc_hd__tapvpwrvgnd_1
XPHY_EDGE_ROW_38_Left_132 VGND VGND VPWR VPWR sky130_fd_sc_hd__decap_3
XFILLER_61_494 VGND VGND VPWR VPWR sky130_fd_sc_hd__decap_3
X_4813_ _4373_/B _4806_/Y _4812_/X _4136_/Y VGND VGND VPWR VPWR _4813_/X sky130_fd_sc_hd__a31o_2
X_4744_ _4429_/B _4432_/B _4787_/S VGND VGND VPWR VPWR _4745_/A sky130_fd_sc_hd__mux2_1
X_4675_ _3923_/B _3924_/B _4787_/S VGND VGND VPWR VPWR _4675_/X sky130_fd_sc_hd__mux2_1
Xclkbuf_leaf_34_CLK clkbuf_leaf_8_CLK/A VGND VGND VPWR VPWR _5092_/CLK sky130_fd_sc_hd__clkbuf_8
X_3626_ _4405_/B _5152_/Q _4542_/S VGND VGND VPWR VPWR _3634_/S sky130_fd_sc_hd__mux2_2
X_3557_ _3585_/A _3555_/Y _3556_/X _4168_/A _2421_/Y VGND VGND VPWR VPWR _3558_/B
+ sky130_fd_sc_hd__o32a_2
XPHY_EDGE_ROW_47_Left_141 VGND VGND VPWR VPWR sky130_fd_sc_hd__decap_3
X_2508_ _4959_/Q _4943_/Q _4927_/Q _4911_/Q _5123_/Q _2671_/S1 VGND VGND VPWR VPWR
+ _2508_/X sky130_fd_sc_hd__mux4_2
X_5227_ _5241_/CLK _5227_/D VGND VGND VPWR VPWR _5227_/Q sky130_fd_sc_hd__dfxtp_2
X_3488_ _3488_/A _3488_/B _3488_/C VGND VGND VPWR VPWR _3489_/A sky130_fd_sc_hd__and3_2
X_2439_ _3442_/B _5257_/Q VGND VGND VPWR VPWR _5260_/D sky130_fd_sc_hd__and2_2
XFILLER_56_27 VGND VGND VPWR VPWR sky130_fd_sc_hd__fill_1
XFILLER_56_38 VGND VGND VPWR VPWR sky130_fd_sc_hd__decap_3
X_5158_ _5177_/CLK _5158_/D VGND VGND VPWR VPWR _5158_/Q sky130_fd_sc_hd__dfxtp_2
XFILLER_29_458 VGND VGND VPWR VPWR sky130_fd_sc_hd__decap_3
X_4109_ _4346_/A _3650_/X _3651_/Y _3631_/A _4108_/Y VGND VGND VPWR VPWR _4109_/X
+ sky130_fd_sc_hd__o221a_2
X_5089_ clkload3/A _5089_/D VGND VGND VPWR VPWR _5089_/Q sky130_fd_sc_hd__dfxtp_2
XFILLER_44_417 VGND VGND VPWR VPWR sky130_fd_sc_hd__decap_3
XFILLER_44_439 VGND VGND VPWR VPWR sky130_fd_sc_hd__decap_3
XFILLER_56_277 VGND VGND VPWR VPWR sky130_fd_sc_hd__decap_3
XFILLER_71_203 VGND VGND VPWR VPWR sky130_fd_sc_hd__decap_3
XFILLER_37_480 VGND VGND VPWR VPWR sky130_fd_sc_hd__decap_3
XPHY_EDGE_ROW_56_Left_150 VGND VGND VPWR VPWR sky130_fd_sc_hd__decap_3
XFILLER_24_141 VGND VGND VPWR VPWR sky130_fd_sc_hd__decap_3
XFILLER_72_26 VGND VGND VPWR VPWR sky130_fd_sc_hd__fill_2
XFILLER_52_472 VGND VGND VPWR VPWR sky130_fd_sc_hd__decap_3
XFILLER_52_483 VGND VGND VPWR VPWR sky130_fd_sc_hd__decap_3
XFILLER_12_347 VGND VGND VPWR VPWR sky130_fd_sc_hd__fill_1
XTAP_TAPCELL_ROW_50_673 VGND VPWR sky130_fd_sc_hd__tapvpwrvgnd_1
XFILLER_21_63 VGND VGND VPWR VPWR sky130_fd_sc_hd__decap_3
Xclkbuf_leaf_25_CLK clkload2/A VGND VGND VPWR VPWR _4982_/CLK sky130_fd_sc_hd__clkbuf_8
XFILLER_47_222 VGND VGND VPWR VPWR sky130_fd_sc_hd__fill_2
XFILLER_87_391 VGND VGND VPWR VPWR sky130_fd_sc_hd__fill_1
XTAP_TAPCELL_ROW_58_751 VGND VPWR sky130_fd_sc_hd__tapvpwrvgnd_1
XFILLER_35_417 VGND VGND VPWR VPWR sky130_fd_sc_hd__decap_3
XFILLER_46_60 VGND VGND VPWR VPWR sky130_fd_sc_hd__decap_3
XFILLER_47_266 VGND VGND VPWR VPWR sky130_fd_sc_hd__decap_3
XFILLER_62_236 VGND VGND VPWR VPWR sky130_fd_sc_hd__decap_3
XFILLER_43_461 VGND VGND VPWR VPWR sky130_fd_sc_hd__decap_3
XFILLER_62_258 VGND VGND VPWR VPWR sky130_fd_sc_hd__decap_3
X_2790_ _5133_/Q _2790_/B VGND VGND VPWR VPWR _2790_/X sky130_fd_sc_hd__or2_2
XFILLER_7_21 VGND VGND VPWR VPWR sky130_fd_sc_hd__decap_3
XFILLER_7_54 VGND VGND VPWR VPWR sky130_fd_sc_hd__fill_2
XFILLER_7_340 VGND VGND VPWR VPWR sky130_fd_sc_hd__fill_1
X_4460_ _4460_/A _4460_/B VGND VGND VPWR VPWR _4461_/B sky130_fd_sc_hd__xnor2_2
Xclkbuf_leaf_16_CLK clkload0/A VGND VGND VPWR VPWR _5251_/CLK sky130_fd_sc_hd__clkbuf_8
XFILLER_7_384 VGND VGND VPWR VPWR sky130_fd_sc_hd__decap_3
XFILLER_7_362 VGND VGND VPWR VPWR sky130_fd_sc_hd__decap_3
X_4391_ _4534_/B VGND VGND VPWR VPWR _4391_/Y sky130_fd_sc_hd__inv_2
X_3411_ _5152_/Q _3252_/C _3410_/X _3448_/B VGND VGND VPWR VPWR _5152_/D sky130_fd_sc_hd__o211a_2
X_3342_ _3353_/A _3342_/B VGND VGND VPWR VPWR _3361_/B sky130_fd_sc_hd__nor2_2
XTAP_TAPCELL_ROW_90_1057 VGND VPWR sky130_fd_sc_hd__tapvpwrvgnd_1
XFILLER_58_509 VGND VGND VPWR VPWR sky130_fd_sc_hd__decap_3
X_3273_ _3273_/A _3273_/B VGND VGND VPWR VPWR _3273_/Y sky130_fd_sc_hd__xnor2_2
XFILLER_38_200 VGND VGND VPWR VPWR sky130_fd_sc_hd__decap_3
X_5012_ clkload8/A _5012_/D VGND VGND VPWR VPWR _5012_/Q sky130_fd_sc_hd__dfxtp_2
XFILLER_66_531 VGND VGND VPWR VPWR sky130_fd_sc_hd__fill_1
XFILLER_66_542 VGND VGND VPWR VPWR sky130_fd_sc_hd__decap_3
XFILLER_93_383 VGND VGND VPWR VPWR sky130_fd_sc_hd__decap_3
XFILLER_53_225 VGND VGND VPWR VPWR sky130_fd_sc_hd__decap_3
XFILLER_81_545 VGND VGND VPWR VPWR sky130_fd_sc_hd__decap_3
XFILLER_53_258 VGND VGND VPWR VPWR sky130_fd_sc_hd__decap_3
X_2988_ _2891_/X _2987_/B _2987_/Y _4915_/Q VGND VGND VPWR VPWR _4915_/D sky130_fd_sc_hd__a22o_2
X_4727_ _4230_/X _4721_/X _4726_/X _4136_/Y VGND VGND VPWR VPWR _4727_/X sky130_fd_sc_hd__a31o_2
X_4658_ _4466_/A _4466_/B _4787_/S VGND VGND VPWR VPWR _4658_/X sky130_fd_sc_hd__mux2_1
X_3609_ _4884_/Q _4868_/Q _5092_/Q _5076_/Q _3834_/S0 _3834_/S1 VGND VGND VPWR VPWR
+ _3610_/B sky130_fd_sc_hd__mux4_2
X_4589_ _4589_/A _4589_/B _4477_/C VGND VGND VPWR VPWR _4589_/X sky130_fd_sc_hd__or3b_2
XFILLER_88_111 VGND VGND VPWR VPWR sky130_fd_sc_hd__decap_3
XFILLER_88_155 VGND VGND VPWR VPWR sky130_fd_sc_hd__fill_1
XFILLER_57_520 VGND VGND VPWR VPWR sky130_fd_sc_hd__decap_3
XFILLER_69_391 VGND VGND VPWR VPWR sky130_fd_sc_hd__fill_1
XFILLER_29_255 VGND VGND VPWR VPWR sky130_fd_sc_hd__decap_3
XFILLER_72_501 VGND VGND VPWR VPWR sky130_fd_sc_hd__decap_3
XFILLER_29_299 VGND VGND VPWR VPWR sky130_fd_sc_hd__decap_3
XFILLER_44_247 VGND VGND VPWR VPWR sky130_fd_sc_hd__decap_3
XFILLER_72_545 VGND VGND VPWR VPWR sky130_fd_sc_hd__decap_3
XTAP_TAPCELL_ROW_55_721 VGND VPWR sky130_fd_sc_hd__tapvpwrvgnd_1
XFILLER_84_383 VGND VGND VPWR VPWR sky130_fd_sc_hd__fill_1
XFILLER_83_47 VGND VGND VPWR VPWR sky130_fd_sc_hd__decap_3
XFILLER_16_41 VGND VGND VPWR VPWR sky130_fd_sc_hd__decap_3
XTAP_TAPCELL_ROW_27_456 VGND VPWR sky130_fd_sc_hd__tapvpwrvgnd_1
XFILLER_12_100 VGND VGND VPWR VPWR sky130_fd_sc_hd__decap_3
XFILLER_16_74 VGND VGND VPWR VPWR sky130_fd_sc_hd__fill_1
XFILLER_16_85 VGND VGND VPWR VPWR sky130_fd_sc_hd__decap_3
XFILLER_52_280 VGND VGND VPWR VPWR sky130_fd_sc_hd__decap_3
XPHY_EDGE_ROW_11_Right_11 VGND VGND VPWR VPWR sky130_fd_sc_hd__decap_3
XFILLER_12_144 VGND VGND VPWR VPWR sky130_fd_sc_hd__fill_1
XFILLER_40_442 VGND VGND VPWR VPWR sky130_fd_sc_hd__decap_3
XFILLER_40_486 VGND VGND VPWR VPWR sky130_fd_sc_hd__decap_3
XFILLER_12_188 VGND VGND VPWR VPWR sky130_fd_sc_hd__decap_3
XFILLER_32_73 VGND VGND VPWR VPWR sky130_fd_sc_hd__decap_3
XTAP_TAPCELL_ROW_10_301 VGND VPWR sky130_fd_sc_hd__tapvpwrvgnd_1
XFILLER_4_321 VGND VGND VPWR VPWR sky130_fd_sc_hd__decap_3
XPHY_EDGE_ROW_20_Right_20 VGND VGND VPWR VPWR sky130_fd_sc_hd__decap_3
XFILLER_67_339 VGND VGND VPWR VPWR sky130_fd_sc_hd__decap_3
XFILLER_82_309 VGND VGND VPWR VPWR sky130_fd_sc_hd__decap_3
XFILLER_35_203 VGND VGND VPWR VPWR sky130_fd_sc_hd__decap_3
XFILLER_57_81 VGND VGND VPWR VPWR sky130_fd_sc_hd__fill_1
XFILLER_75_361 VGND VGND VPWR VPWR sky130_fd_sc_hd__decap_3
XFILLER_35_225 VGND VGND VPWR VPWR sky130_fd_sc_hd__decap_3
XFILLER_63_523 VGND VGND VPWR VPWR sky130_fd_sc_hd__decap_3
Xclkbuf_leaf_5_CLK clkbuf_leaf_8_CLK/A VGND VGND VPWR VPWR clkload5/A sky130_fd_sc_hd__clkbuf_8
XFILLER_23_409 VGND VGND VPWR VPWR sky130_fd_sc_hd__decap_3
XFILLER_35_269 VGND VGND VPWR VPWR sky130_fd_sc_hd__decap_3
X_3960_ _3924_/B _3923_/B _4787_/S VGND VGND VPWR VPWR _3960_/X sky130_fd_sc_hd__mux2_1
XFILLER_16_483 VGND VGND VPWR VPWR sky130_fd_sc_hd__fill_1
XFILLER_50_239 VGND VGND VPWR VPWR sky130_fd_sc_hd__fill_1
XFILLER_73_80 VGND VGND VPWR VPWR sky130_fd_sc_hd__decap_3
X_2911_ _4871_/Q _2936_/A2 _2910_/X _2936_/B2 VGND VGND VPWR VPWR _4871_/D sky130_fd_sc_hd__a22o_2
X_3891_ _4067_/A _4403_/A VGND VGND VPWR VPWR _3892_/B sky130_fd_sc_hd__or2_2
XTAP_TAPCELL_ROW_61_779 VGND VPWR sky130_fd_sc_hd__tapvpwrvgnd_1
XFILLER_31_475 VGND VGND VPWR VPWR sky130_fd_sc_hd__decap_3
X_2842_ _2851_/A _3386_/B VGND VGND VPWR VPWR _2842_/X sky130_fd_sc_hd__and2_2
XFILLER_85_3 VGND VGND VPWR VPWR sky130_fd_sc_hd__decap_3
X_2773_ _2771_/X _2772_/X _5133_/Q VGND VGND VPWR VPWR _2773_/X sky130_fd_sc_hd__mux2_1
X_4512_ _4512_/A _4512_/B VGND VGND VPWR VPWR _4573_/A sky130_fd_sc_hd__and2_2
X_4443_ _4443_/A _4443_/B VGND VGND VPWR VPWR _4444_/B sky130_fd_sc_hd__and2_2
X_4374_ _4360_/A _4246_/A _4360_/C _4362_/Y _4022_/Y VGND VGND VPWR VPWR _4374_/X
+ sky130_fd_sc_hd__o32a_2
X_3325_ _3313_/A _3315_/Y _3323_/Y _2425_/Y VGND VGND VPWR VPWR _3325_/X sky130_fd_sc_hd__a31o_2
X_3256_ _5154_/Q _3256_/B VGND VGND VPWR VPWR _3257_/B sky130_fd_sc_hd__nor2_2
XTAP_TAPCELL_ROW_69_857 VGND VPWR sky130_fd_sc_hd__tapvpwrvgnd_1
XFILLER_66_350 VGND VGND VPWR VPWR sky130_fd_sc_hd__decap_3
X_3187_ _2941_/X _3172_/B _3172_/Y _5089_/Q VGND VGND VPWR VPWR _5089_/D sky130_fd_sc_hd__a22o_2
XFILLER_85_169 VGND VGND VPWR VPWR sky130_fd_sc_hd__decap_3
XFILLER_54_523 VGND VGND VPWR VPWR sky130_fd_sc_hd__fill_2
XFILLER_93_180 VGND VGND VPWR VPWR sky130_fd_sc_hd__fill_2
XFILLER_81_320 VGND VGND VPWR VPWR sky130_fd_sc_hd__decap_3
XFILLER_81_364 VGND VGND VPWR VPWR sky130_fd_sc_hd__decap_3
XFILLER_41_228 VGND VGND VPWR VPWR sky130_fd_sc_hd__decap_3
XTAP_TAPCELL_ROW_24_426 VGND VPWR sky130_fd_sc_hd__tapvpwrvgnd_1
XFILLER_89_420 VGND VGND VPWR VPWR sky130_fd_sc_hd__fill_1
XFILLER_1_357 VGND VGND VPWR VPWR sky130_fd_sc_hd__decap_3
XFILLER_78_69 VGND VGND VPWR VPWR sky130_fd_sc_hd__decap_3
XFILLER_76_147 VGND VGND VPWR VPWR sky130_fd_sc_hd__decap_3
XFILLER_57_361 VGND VGND VPWR VPWR sky130_fd_sc_hd__decap_3
XFILLER_64_309 VGND VGND VPWR VPWR sky130_fd_sc_hd__decap_3
XFILLER_17_225 VGND VGND VPWR VPWR sky130_fd_sc_hd__decap_3
XFILLER_45_523 VGND VGND VPWR VPWR sky130_fd_sc_hd__decap_3
XFILLER_91_139 VGND VGND VPWR VPWR sky130_fd_sc_hd__decap_3
XFILLER_60_515 VGND VGND VPWR VPWR sky130_fd_sc_hd__decap_3
XFILLER_40_250 VGND VGND VPWR VPWR sky130_fd_sc_hd__fill_2
XFILLER_9_446 VGND VGND VPWR VPWR sky130_fd_sc_hd__fill_2
XFILLER_4_77 VGND VGND VPWR VPWR sky130_fd_sc_hd__decap_3
X_3110_ _2929_/X _3099_/B _3099_/Y _5021_/Q VGND VGND VPWR VPWR _5021_/D sky130_fd_sc_hd__a22o_2
X_4090_ _4091_/A _4091_/B VGND VGND VPWR VPWR _4090_/Y sky130_fd_sc_hd__nand2_2
XFILLER_55_309 VGND VGND VPWR VPWR sky130_fd_sc_hd__decap_3
X_3041_ _5189_/Q _5188_/Q VGND VGND VPWR VPWR _3078_/B sky130_fd_sc_hd__or2_2
XTAP_TAPCELL_ROW_66_827 VGND VPWR sky130_fd_sc_hd__tapvpwrvgnd_1
XFILLER_82_106 VGND VGND VPWR VPWR sky130_fd_sc_hd__decap_3
XFILLER_63_320 VGND VGND VPWR VPWR sky130_fd_sc_hd__decap_3
XFILLER_82_139 VGND VGND VPWR VPWR sky130_fd_sc_hd__fill_1
XFILLER_23_217 VGND VGND VPWR VPWR sky130_fd_sc_hd__decap_3
XFILLER_23_228 VGND VGND VPWR VPWR sky130_fd_sc_hd__decap_3
X_4992_ _5115_/CLK _4992_/D VGND VGND VPWR VPWR _4992_/Q sky130_fd_sc_hd__dfxtp_2
X_3943_ _5167_/Q _4473_/A VGND VGND VPWR VPWR _3943_/X sky130_fd_sc_hd__or2_2
X_3874_ _3874_/A _4048_/A _3934_/C _3874_/D VGND VGND VPWR VPWR _3875_/D sky130_fd_sc_hd__or4_2
X_2825_ _5072_/Q _5056_/Q _5040_/Q _5024_/Q _5131_/Q _2848_/S1 VGND VGND VPWR VPWR
+ _2825_/X sky130_fd_sc_hd__mux4_2
X_2756_ _2831_/S _2755_/X _5134_/Q VGND VGND VPWR VPWR _2756_/X sky130_fd_sc_hd__o21a_2
X_2687_ _2502_/Y _2684_/A _2882_/A _4311_/A VGND VGND VPWR VPWR _2886_/C sky130_fd_sc_hd__o22a_2
X_4426_ _4425_/X _4424_/X _4686_/S VGND VGND VPWR VPWR _4426_/X sky130_fd_sc_hd__mux2_1
XFILLER_58_114 VGND VGND VPWR VPWR sky130_fd_sc_hd__decap_3
X_4357_ _4360_/A _4356_/Y _4546_/A VGND VGND VPWR VPWR _4357_/Y sky130_fd_sc_hd__a21oi_2
XFILLER_86_412 VGND VGND VPWR VPWR sky130_fd_sc_hd__decap_3
XFILLER_58_136 VGND VGND VPWR VPWR sky130_fd_sc_hd__decap_3
X_4288_ _4218_/A _4196_/B _4284_/Y _4287_/X VGND VGND VPWR VPWR _4289_/B sky130_fd_sc_hd__a31o_2
X_3308_ _5139_/Q _3317_/C VGND VGND VPWR VPWR _3308_/X sky130_fd_sc_hd__or2_2
XFILLER_86_445 VGND VGND VPWR VPWR sky130_fd_sc_hd__decap_3
XFILLER_58_158 VGND VGND VPWR VPWR sky130_fd_sc_hd__decap_3
X_3239_ _5260_/Q _3442_/B input5/X VGND VGND VPWR VPWR _3239_/X sky130_fd_sc_hd__and3_2
XFILLER_27_534 VGND VGND VPWR VPWR sky130_fd_sc_hd__fill_1
XFILLER_73_128 VGND VGND VPWR VPWR sky130_fd_sc_hd__decap_3
XFILLER_54_353 VGND VGND VPWR VPWR sky130_fd_sc_hd__decap_3
XFILLER_66_191 VGND VGND VPWR VPWR sky130_fd_sc_hd__decap_3
XTAP_TAPCELL_ROW_37_551 VGND VPWR sky130_fd_sc_hd__tapvpwrvgnd_1
XFILLER_54_397 VGND VGND VPWR VPWR sky130_fd_sc_hd__decap_3
XFILLER_81_172 VGND VGND VPWR VPWR sky130_fd_sc_hd__fill_2
XFILLER_81_150 VGND VGND VPWR VPWR sky130_fd_sc_hd__decap_3
XFILLER_42_548 VGND VGND VPWR VPWR sky130_fd_sc_hd__decap_3
XFILLER_81_194 VGND VGND VPWR VPWR sky130_fd_sc_hd__decap_3
XFILLER_80_15 VGND VGND VPWR VPWR sky130_fd_sc_hd__decap_3
XFILLER_6_427 VGND VGND VPWR VPWR sky130_fd_sc_hd__fill_1
XFILLER_1_132 VGND VGND VPWR VPWR sky130_fd_sc_hd__decap_3
XTAP_TAPCELL_ROW_9_287 VGND VPWR sky130_fd_sc_hd__tapvpwrvgnd_1
XFILLER_89_261 VGND VGND VPWR VPWR sky130_fd_sc_hd__decap_3
XFILLER_77_423 VGND VGND VPWR VPWR sky130_fd_sc_hd__decap_3
XFILLER_49_136 VGND VGND VPWR VPWR sky130_fd_sc_hd__decap_3
XFILLER_18_501 VGND VGND VPWR VPWR sky130_fd_sc_hd__decap_3
XFILLER_49_169 VGND VGND VPWR VPWR sky130_fd_sc_hd__decap_3
XFILLER_64_106 VGND VGND VPWR VPWR sky130_fd_sc_hd__decap_3
XFILLER_92_404 VGND VGND VPWR VPWR sky130_fd_sc_hd__decap_3
XFILLER_77_478 VGND VGND VPWR VPWR sky130_fd_sc_hd__decap_3
XFILLER_77_467 VGND VGND VPWR VPWR sky130_fd_sc_hd__decap_3
XFILLER_92_437 VGND VGND VPWR VPWR sky130_fd_sc_hd__decap_3
XFILLER_45_331 VGND VGND VPWR VPWR sky130_fd_sc_hd__decap_3
XFILLER_45_353 VGND VGND VPWR VPWR sky130_fd_sc_hd__decap_3
XFILLER_60_301 VGND VGND VPWR VPWR sky130_fd_sc_hd__decap_3
XFILLER_60_312 VGND VGND VPWR VPWR sky130_fd_sc_hd__decap_3
XFILLER_72_150 VGND VGND VPWR VPWR sky130_fd_sc_hd__decap_3
XFILLER_33_548 VGND VGND VPWR VPWR sky130_fd_sc_hd__decap_3
XFILLER_54_60 VGND VGND VPWR VPWR sky130_fd_sc_hd__decap_3
XTAP_TAPCELL_ROW_71_874 VGND VPWR sky130_fd_sc_hd__tapvpwrvgnd_1
XFILLER_70_70 VGND VGND VPWR VPWR sky130_fd_sc_hd__decap_3
XFILLER_9_276 VGND VGND VPWR VPWR sky130_fd_sc_hd__decap_3
XFILLER_70_81 VGND VGND VPWR VPWR sky130_fd_sc_hd__decap_3
Xclkload35 _5116_/CLK VGND VGND VPWR VPWR clkload35/X sky130_fd_sc_hd__clkbuf_8
Xclkload24 _5085_/CLK VGND VGND VPWR VPWR clkload24/Y sky130_fd_sc_hd__bufinv_16
Xclkload13 _5263_/CLK VGND VGND VPWR VPWR clkload13/X sky130_fd_sc_hd__clkbuf_4
X_3590_ _4886_/Q _4870_/Q _5094_/Q _5078_/Q _3834_/S0 _3834_/S1 VGND VGND VPWR VPWR
+ _3591_/B sky130_fd_sc_hd__mux4_2
X_2610_ _5155_/Q _4493_/A VGND VGND VPWR VPWR _2613_/A sky130_fd_sc_hd__or2_2
X_2541_ _2667_/A _2540_/X _5126_/Q VGND VGND VPWR VPWR _2541_/X sky130_fd_sc_hd__o21a_2
X_5260_ _5262_/CLK _5260_/D VGND VGND VPWR VPWR _5260_/Q sky130_fd_sc_hd__dfxtp_2
X_2472_ _5122_/Q _5010_/Q _4994_/Q _4978_/Q _5123_/Q _5124_/Q VGND VGND VPWR VPWR
+ _2472_/X sky130_fd_sc_hd__mux4_2
XPHY_EDGE_ROW_10_Left_104 VGND VGND VPWR VPWR sky130_fd_sc_hd__decap_3
XFILLER_5_493 VGND VGND VPWR VPWR sky130_fd_sc_hd__decap_3
X_4211_ _4210_/X _4211_/B _4712_/B _4211_/D VGND VGND VPWR VPWR _4211_/X sky130_fd_sc_hd__and4b_2
XFILLER_68_401 VGND VGND VPWR VPWR sky130_fd_sc_hd__decap_3
X_5191_ _5241_/CLK _5191_/D VGND VGND VPWR VPWR _5191_/Q sky130_fd_sc_hd__dfxtp_2
X_4142_ _4138_/X _4142_/B _4142_/C _4142_/D VGND VGND VPWR VPWR _4142_/X sky130_fd_sc_hd__and4b_2
XTAP_TAPCELL_ROW_79_952 VGND VPWR sky130_fd_sc_hd__tapvpwrvgnd_1
X_4073_ _3977_/Y _4011_/A _4077_/S VGND VGND VPWR VPWR _4173_/B sky130_fd_sc_hd__mux2_1
XFILLER_83_415 VGND VGND VPWR VPWR sky130_fd_sc_hd__fill_2
X_3024_ _4866_/A _3024_/B VGND VGND VPWR VPWR _3024_/Y sky130_fd_sc_hd__nor2_2
XTAP_TAPCELL_ROW_87_1029 VGND VPWR sky130_fd_sc_hd__tapvpwrvgnd_1
XFILLER_83_437 VGND VGND VPWR VPWR sky130_fd_sc_hd__fill_2
XFILLER_24_504 VGND VGND VPWR VPWR sky130_fd_sc_hd__decap_3
XFILLER_36_386 VGND VGND VPWR VPWR sky130_fd_sc_hd__fill_1
XFILLER_63_172 VGND VGND VPWR VPWR sky130_fd_sc_hd__decap_3
X_4975_ clkload9/A _4975_/D VGND VGND VPWR VPWR _4975_/Q sky130_fd_sc_hd__dfxtp_2
XTAP_TAPCELL_ROW_34_521 VGND VPWR sky130_fd_sc_hd__tapvpwrvgnd_1
XFILLER_51_389 VGND VGND VPWR VPWR sky130_fd_sc_hd__decap_3
X_3926_ _5153_/Q _4449_/B VGND VGND VPWR VPWR _3926_/X sky130_fd_sc_hd__and2b_2
XFILLER_50_29 VGND VGND VPWR VPWR sky130_fd_sc_hd__fill_2
Xclkload7 clkload7/A VGND VGND VPWR VPWR clkload7/X sky130_fd_sc_hd__clkbuf_4
X_3857_ _4523_/S VGND VGND VPWR VPWR _4225_/B sky130_fd_sc_hd__inv_2
X_3788_ _3786_/X _3787_/X _3831_/A VGND VGND VPWR VPWR _3788_/X sky130_fd_sc_hd__mux2_1
X_2808_ _5133_/Q _2808_/B VGND VGND VPWR VPWR _2808_/X sky130_fd_sc_hd__or2_2
X_2739_ _5133_/Q _2739_/B VGND VGND VPWR VPWR _2739_/X sky130_fd_sc_hd__or2_2
XFILLER_1_9 VGND VGND VPWR VPWR sky130_fd_sc_hd__fill_1
XFILLER_59_27 VGND VGND VPWR VPWR sky130_fd_sc_hd__decap_3
XFILLER_78_209 VGND VGND VPWR VPWR sky130_fd_sc_hd__fill_1
X_4409_ _4477_/A _4523_/S _4249_/Y VGND VGND VPWR VPWR _4409_/Y sky130_fd_sc_hd__o21ai_2
XFILLER_59_423 VGND VGND VPWR VPWR sky130_fd_sc_hd__decap_3
XTAP_TAPCELL_ROW_6_257 VGND VPWR sky130_fd_sc_hd__tapvpwrvgnd_1
XFILLER_59_467 VGND VGND VPWR VPWR sky130_fd_sc_hd__fill_1
XFILLER_59_489 VGND VGND VPWR VPWR sky130_fd_sc_hd__fill_2
XFILLER_75_15 VGND VGND VPWR VPWR sky130_fd_sc_hd__decap_3
XFILLER_86_253 VGND VGND VPWR VPWR sky130_fd_sc_hd__fill_1
XFILLER_46_117 VGND VGND VPWR VPWR sky130_fd_sc_hd__decap_3
XFILLER_86_297 VGND VGND VPWR VPWR sky130_fd_sc_hd__decap_3
XFILLER_74_459 VGND VGND VPWR VPWR sky130_fd_sc_hd__fill_1
XFILLER_27_364 VGND VGND VPWR VPWR sky130_fd_sc_hd__decap_3
XFILLER_54_150 VGND VGND VPWR VPWR sky130_fd_sc_hd__decap_3
XFILLER_42_345 VGND VGND VPWR VPWR sky130_fd_sc_hd__decap_3
XFILLER_54_183 VGND VGND VPWR VPWR sky130_fd_sc_hd__decap_3
XFILLER_91_36 VGND VGND VPWR VPWR sky130_fd_sc_hd__decap_3
XFILLER_24_41 VGND VGND VPWR VPWR sky130_fd_sc_hd__decap_3
XFILLER_24_85 VGND VGND VPWR VPWR sky130_fd_sc_hd__fill_2
XFILLER_10_242 VGND VGND VPWR VPWR sky130_fd_sc_hd__decap_3
XFILLER_10_253 VGND VGND VPWR VPWR sky130_fd_sc_hd__decap_3
XTAP_TAPCELL_ROW_40_579 VGND VPWR sky130_fd_sc_hd__tapvpwrvgnd_1
XFILLER_10_297 VGND VGND VPWR VPWR sky130_fd_sc_hd__decap_3
XFILLER_6_268 VGND VGND VPWR VPWR sky130_fd_sc_hd__decap_3
XFILLER_40_73 VGND VGND VPWR VPWR sky130_fd_sc_hd__decap_3
XFILLER_69_209 VGND VGND VPWR VPWR sky130_fd_sc_hd__decap_3
XFILLER_77_220 VGND VGND VPWR VPWR sky130_fd_sc_hd__decap_3
XTAP_TAPCELL_ROW_76_922 VGND VPWR sky130_fd_sc_hd__tapvpwrvgnd_1
XFILLER_18_353 VGND VGND VPWR VPWR sky130_fd_sc_hd__decap_3
XTAP_TAPCELL_ROW_48_657 VGND VPWR sky130_fd_sc_hd__tapvpwrvgnd_1
XFILLER_92_256 VGND VGND VPWR VPWR sky130_fd_sc_hd__decap_3
XFILLER_33_312 VGND VGND VPWR VPWR sky130_fd_sc_hd__decap_3
XFILLER_45_161 VGND VGND VPWR VPWR sky130_fd_sc_hd__decap_3
XFILLER_45_172 VGND VGND VPWR VPWR sky130_fd_sc_hd__decap_3
XFILLER_65_92 VGND VGND VPWR VPWR sky130_fd_sc_hd__decap_3
XFILLER_92_289 VGND VGND VPWR VPWR sky130_fd_sc_hd__decap_3
XFILLER_80_418 VGND VGND VPWR VPWR sky130_fd_sc_hd__fill_2
XFILLER_73_492 VGND VGND VPWR VPWR sky130_fd_sc_hd__decap_3
XFILLER_33_367 VGND VGND VPWR VPWR sky130_fd_sc_hd__decap_3
XFILLER_60_153 VGND VGND VPWR VPWR sky130_fd_sc_hd__decap_3
XFILLER_21_529 VGND VGND VPWR VPWR sky130_fd_sc_hd__decap_3
XFILLER_60_197 VGND VGND VPWR VPWR sky130_fd_sc_hd__decap_3
X_4760_ _4759_/Y _4736_/Y _4802_/A VGND VGND VPWR VPWR _4760_/X sky130_fd_sc_hd__mux2_1
XFILLER_81_80 VGND VGND VPWR VPWR sky130_fd_sc_hd__decap_3
X_4691_ _4464_/A _4464_/B _4787_/S VGND VGND VPWR VPWR _4692_/A sky130_fd_sc_hd__mux2_1
X_3711_ _3709_/X _3710_/X _3831_/A VGND VGND VPWR VPWR _3711_/X sky130_fd_sc_hd__mux2_1
X_3642_ _4763_/A _3643_/B VGND VGND VPWR VPWR _4208_/B sky130_fd_sc_hd__nor2_2
X_3573_ _5166_/Q _5147_/Q VGND VGND VPWR VPWR _3577_/A sky130_fd_sc_hd__and2_2
XPHY_EDGE_ROW_49_Right_49 VGND VGND VPWR VPWR sky130_fd_sc_hd__decap_3
XFILLER_5_290 VGND VGND VPWR VPWR sky130_fd_sc_hd__decap_3
X_2524_ _2518_/X _2520_/X _2523_/X _2435_/Y VGND VGND VPWR VPWR _4464_/A sky130_fd_sc_hd__a22o_2
XFILLER_88_507 VGND VGND VPWR VPWR sky130_fd_sc_hd__decap_3
X_5243_ _5263_/CLK _5243_/D VGND VGND VPWR VPWR _5243_/Q sky130_fd_sc_hd__dfxtp_2
X_2455_ _2889_/A _2461_/D _2889_/C VGND VGND VPWR VPWR _2455_/X sky130_fd_sc_hd__and3_2
XTAP_TAPCELL_ROW_93_1099 VGND VPWR sky130_fd_sc_hd__tapvpwrvgnd_1
XTAP_TAPCELL_ROW_93_1088 VGND VPWR sky130_fd_sc_hd__tapvpwrvgnd_1
X_5174_ clkload5/A _5174_/D VGND VGND VPWR VPWR _5174_/Q sky130_fd_sc_hd__dfxtp_2
XFILLER_56_404 VGND VGND VPWR VPWR sky130_fd_sc_hd__decap_3
X_4125_ _4340_/A _4068_/Y _4124_/Y VGND VGND VPWR VPWR _4229_/B sky130_fd_sc_hd__a21oi_2
XTAP_TAPCELL_ROW_3_227 VGND VPWR sky130_fd_sc_hd__tapvpwrvgnd_1
XFILLER_83_212 VGND VGND VPWR VPWR sky130_fd_sc_hd__fill_2
X_4056_ _4716_/B _4021_/X _4055_/X _4850_/B VGND VGND VPWR VPWR _4056_/X sky130_fd_sc_hd__a211o_2
XPHY_EDGE_ROW_58_Right_58 VGND VGND VPWR VPWR sky130_fd_sc_hd__decap_3
XFILLER_83_234 VGND VGND VPWR VPWR sky130_fd_sc_hd__decap_3
XFILLER_64_470 VGND VGND VPWR VPWR sky130_fd_sc_hd__fill_1
X_3007_ _2891_/X _3006_/B _3006_/Y _4931_/Q VGND VGND VPWR VPWR _4931_/D sky130_fd_sc_hd__a22o_2
XFILLER_24_312 VGND VGND VPWR VPWR sky130_fd_sc_hd__decap_3
XFILLER_24_345 VGND VGND VPWR VPWR sky130_fd_sc_hd__decap_3
XTAP_TAPCELL_ROW_19_381 VGND VPWR sky130_fd_sc_hd__tapvpwrvgnd_1
XFILLER_51_153 VGND VGND VPWR VPWR sky130_fd_sc_hd__decap_3
XFILLER_12_529 VGND VGND VPWR VPWR sky130_fd_sc_hd__decap_3
XFILLER_51_175 VGND VGND VPWR VPWR sky130_fd_sc_hd__decap_3
X_4958_ _5116_/CLK _4958_/D VGND VGND VPWR VPWR _4958_/Q sky130_fd_sc_hd__dfxtp_2
X_4889_ _5092_/CLK _4889_/D VGND VGND VPWR VPWR _4889_/Q sky130_fd_sc_hd__dfxtp_2
X_3909_ _3844_/X _3902_/B _3907_/X VGND VGND VPWR VPWR _4291_/B sky130_fd_sc_hd__o21ba_2
XPHY_EDGE_ROW_67_Right_67 VGND VGND VPWR VPWR sky130_fd_sc_hd__decap_3
XFILLER_10_32 VGND VGND VPWR VPWR sky130_fd_sc_hd__decap_3
XFILLER_79_529 VGND VGND VPWR VPWR sky130_fd_sc_hd__decap_3
XFILLER_59_231 VGND VGND VPWR VPWR sky130_fd_sc_hd__fill_1
XFILLER_86_36 VGND VGND VPWR VPWR sky130_fd_sc_hd__decap_3
XFILLER_86_25 VGND VGND VPWR VPWR sky130_fd_sc_hd__decap_3
XFILLER_19_30 VGND VGND VPWR VPWR sky130_fd_sc_hd__decap_3
XFILLER_59_264 VGND VGND VPWR VPWR sky130_fd_sc_hd__decap_3
XFILLER_86_69 VGND VGND VPWR VPWR sky130_fd_sc_hd__decap_3
XFILLER_19_63 VGND VGND VPWR VPWR sky130_fd_sc_hd__decap_3
XFILLER_59_297 VGND VGND VPWR VPWR sky130_fd_sc_hd__decap_3
XPHY_EDGE_ROW_76_Right_76 VGND VGND VPWR VPWR sky130_fd_sc_hd__decap_3
XFILLER_74_256 VGND VGND VPWR VPWR sky130_fd_sc_hd__decap_3
XFILLER_34_109 VGND VGND VPWR VPWR sky130_fd_sc_hd__decap_3
XFILLER_62_407 VGND VGND VPWR VPWR sky130_fd_sc_hd__decap_3
XFILLER_74_289 VGND VGND VPWR VPWR sky130_fd_sc_hd__decap_3
XTAP_TAPCELL_ROW_45_627 VGND VPWR sky130_fd_sc_hd__tapvpwrvgnd_1
XFILLER_70_451 VGND VGND VPWR VPWR sky130_fd_sc_hd__decap_3
XFILLER_30_315 VGND VGND VPWR VPWR sky130_fd_sc_hd__decap_3
XFILLER_30_337 VGND VGND VPWR VPWR sky130_fd_sc_hd__fill_2
XFILLER_35_95 VGND VGND VPWR VPWR sky130_fd_sc_hd__fill_1
XFILLER_42_197 VGND VGND VPWR VPWR sky130_fd_sc_hd__decap_3
XFILLER_11_540 VGND VGND VPWR VPWR sky130_fd_sc_hd__decap_3
XFILLER_51_50 VGND VGND VPWR VPWR sky130_fd_sc_hd__decap_3
XPHY_EDGE_ROW_85_Right_85 VGND VGND VPWR VPWR sky130_fd_sc_hd__decap_3
XFILLER_38_404 VGND VGND VPWR VPWR sky130_fd_sc_hd__fill_1
XFILLER_78_551 VGND VGND VPWR VPWR sky130_fd_sc_hd__fill_2
XFILLER_38_415 VGND VGND VPWR VPWR sky130_fd_sc_hd__decap_3
XFILLER_38_448 VGND VGND VPWR VPWR sky130_fd_sc_hd__decap_3
XFILLER_46_470 VGND VGND VPWR VPWR sky130_fd_sc_hd__decap_3
XFILLER_65_278 VGND VGND VPWR VPWR sky130_fd_sc_hd__fill_2
XFILLER_18_172 VGND VGND VPWR VPWR sky130_fd_sc_hd__decap_3
XFILLER_46_492 VGND VGND VPWR VPWR sky130_fd_sc_hd__decap_3
XFILLER_33_153 VGND VGND VPWR VPWR sky130_fd_sc_hd__decap_3
XFILLER_61_440 VGND VGND VPWR VPWR sky130_fd_sc_hd__decap_3
XFILLER_21_337 VGND VGND VPWR VPWR sky130_fd_sc_hd__decap_3
XFILLER_33_164 VGND VGND VPWR VPWR sky130_fd_sc_hd__decap_3
XFILLER_33_197 VGND VGND VPWR VPWR sky130_fd_sc_hd__decap_3
XFILLER_61_473 VGND VGND VPWR VPWR sky130_fd_sc_hd__decap_3
X_4812_ _2479_/A _3874_/D _4808_/X _4811_/X VGND VGND VPWR VPWR _4812_/X sky130_fd_sc_hd__o211a_2
XTAP_TAPCELL_ROW_16_351 VGND VPWR sky130_fd_sc_hd__tapvpwrvgnd_1
X_4743_ _4804_/A _4743_/B VGND VGND VPWR VPWR _4743_/Y sky130_fd_sc_hd__nand2_2
X_4674_ _4687_/A _4672_/X _4673_/Y _4641_/X _4671_/Y VGND VGND VPWR VPWR _4674_/X
+ sky130_fd_sc_hd__a32o_2
X_3625_ _3620_/X _3621_/X _3624_/X _2432_/Y VGND VGND VPWR VPWR _4405_/B sky130_fd_sc_hd__a22o_2
X_3556_ _3555_/B _3555_/C _3555_/A VGND VGND VPWR VPWR _3556_/X sky130_fd_sc_hd__o21a_2
X_2507_ _5125_/Q _2506_/X _5126_/Q VGND VGND VPWR VPWR _2507_/X sky130_fd_sc_hd__o21a_2
X_5226_ clkload8/A _5226_/D VGND VGND VPWR VPWR _5226_/Q sky130_fd_sc_hd__dfxtp_2
X_3487_ _3488_/A _3488_/B _3488_/C VGND VGND VPWR VPWR _3487_/X sky130_fd_sc_hd__a21o_2
XFILLER_88_348 VGND VGND VPWR VPWR sky130_fd_sc_hd__decap_3
XFILLER_69_551 VGND VGND VPWR VPWR sky130_fd_sc_hd__fill_2
X_2438_ _5260_/Q _3442_/B VGND VGND VPWR VPWR _5263_/D sky130_fd_sc_hd__and2_2
XFILLER_29_437 VGND VGND VPWR VPWR sky130_fd_sc_hd__decap_3
X_5157_ _5177_/CLK _5157_/D VGND VGND VPWR VPWR _5157_/Q sky130_fd_sc_hd__dfxtp_2
XFILLER_84_521 VGND VGND VPWR VPWR sky130_fd_sc_hd__decap_3
XFILLER_56_223 VGND VGND VPWR VPWR sky130_fd_sc_hd__decap_3
XFILLER_56_245 VGND VGND VPWR VPWR sky130_fd_sc_hd__decap_3
XFILLER_56_256 VGND VGND VPWR VPWR sky130_fd_sc_hd__decap_3
X_4108_ _4108_/A _4179_/B VGND VGND VPWR VPWR _4108_/Y sky130_fd_sc_hd__nand2_2
X_5088_ _5134_/CLK _5088_/D VGND VGND VPWR VPWR _5088_/Q sky130_fd_sc_hd__dfxtp_2
XFILLER_44_407 VGND VGND VPWR VPWR sky130_fd_sc_hd__decap_3
XFILLER_56_289 VGND VGND VPWR VPWR sky130_fd_sc_hd__decap_3
XFILLER_71_215 VGND VGND VPWR VPWR sky130_fd_sc_hd__decap_3
X_4039_ _4040_/A _4040_/B VGND VGND VPWR VPWR _4041_/B sky130_fd_sc_hd__nand2_2
XFILLER_24_120 VGND VGND VPWR VPWR sky130_fd_sc_hd__decap_3
XFILLER_71_237 VGND VGND VPWR VPWR sky130_fd_sc_hd__decap_3
XFILLER_12_326 VGND VGND VPWR VPWR sky130_fd_sc_hd__decap_3
XFILLER_52_495 VGND VGND VPWR VPWR sky130_fd_sc_hd__decap_3
XFILLER_12_359 VGND VGND VPWR VPWR sky130_fd_sc_hd__decap_3
XFILLER_24_197 VGND VGND VPWR VPWR sky130_fd_sc_hd__decap_3
XTAP_TAPCELL_ROW_50_674 VGND VPWR sky130_fd_sc_hd__tapvpwrvgnd_1
XFILLER_20_392 VGND VGND VPWR VPWR sky130_fd_sc_hd__decap_3
XFILLER_21_75 VGND VGND VPWR VPWR sky130_fd_sc_hd__decap_3
XFILLER_4_547 VGND VGND VPWR VPWR sky130_fd_sc_hd__decap_3
XFILLER_79_359 VGND VGND VPWR VPWR sky130_fd_sc_hd__decap_3
XFILLER_87_370 VGND VGND VPWR VPWR sky130_fd_sc_hd__decap_3
XFILLER_75_521 VGND VGND VPWR VPWR sky130_fd_sc_hd__fill_1
XFILLER_47_234 VGND VGND VPWR VPWR sky130_fd_sc_hd__decap_3
XTAP_TAPCELL_ROW_58_752 VGND VPWR sky130_fd_sc_hd__tapvpwrvgnd_1
XFILLER_75_543 VGND VGND VPWR VPWR sky130_fd_sc_hd__decap_3
XFILLER_35_429 VGND VGND VPWR VPWR sky130_fd_sc_hd__decap_3
XFILLER_47_289 VGND VGND VPWR VPWR sky130_fd_sc_hd__decap_3
XFILLER_62_204 VGND VGND VPWR VPWR sky130_fd_sc_hd__decap_3
XFILLER_46_83 VGND VGND VPWR VPWR sky130_fd_sc_hd__fill_1
XFILLER_62_248 VGND VGND VPWR VPWR sky130_fd_sc_hd__decap_3
XFILLER_70_270 VGND VGND VPWR VPWR sky130_fd_sc_hd__decap_3
XFILLER_70_281 VGND VGND VPWR VPWR sky130_fd_sc_hd__decap_3
XFILLER_62_71 VGND VGND VPWR VPWR sky130_fd_sc_hd__decap_3
XTAP_TAPCELL_ROW_13_321 VGND VPWR sky130_fd_sc_hd__tapvpwrvgnd_1
XFILLER_7_33 VGND VGND VPWR VPWR sky130_fd_sc_hd__decap_3
XFILLER_7_77 VGND VGND VPWR VPWR sky130_fd_sc_hd__decap_3
XFILLER_7_66 VGND VGND VPWR VPWR sky130_fd_sc_hd__fill_2
X_4390_ _5155_/Q _4402_/A VGND VGND VPWR VPWR _4534_/B sky130_fd_sc_hd__nand2_2
X_3410_ _5260_/Q input1/X _3227_/X VGND VGND VPWR VPWR _3410_/X sky130_fd_sc_hd__a21o_2
X_3341_ _5162_/Q _3341_/B VGND VGND VPWR VPWR _3342_/B sky130_fd_sc_hd__nor2_2
X_3272_ _3262_/A _3262_/B _3257_/A VGND VGND VPWR VPWR _3273_/B sky130_fd_sc_hd__a21oi_2
XTAP_TAPCELL_ROW_90_1058 VGND VPWR sky130_fd_sc_hd__tapvpwrvgnd_1
XFILLER_66_510 VGND VGND VPWR VPWR sky130_fd_sc_hd__decap_3
X_5011_ _5063_/CLK _5011_/D VGND VGND VPWR VPWR _5011_/Q sky130_fd_sc_hd__dfxtp_2
XFILLER_78_381 VGND VGND VPWR VPWR sky130_fd_sc_hd__decap_3
XFILLER_38_245 VGND VGND VPWR VPWR sky130_fd_sc_hd__decap_3
XFILLER_93_340 VGND VGND VPWR VPWR sky130_fd_sc_hd__decap_3
XFILLER_26_418 VGND VGND VPWR VPWR sky130_fd_sc_hd__fill_2
XFILLER_38_256 VGND VGND VPWR VPWR sky130_fd_sc_hd__fill_2
XFILLER_53_204 VGND VGND VPWR VPWR sky130_fd_sc_hd__decap_3
XFILLER_19_470 VGND VGND VPWR VPWR sky130_fd_sc_hd__decap_3
XFILLER_53_237 VGND VGND VPWR VPWR sky130_fd_sc_hd__decap_3
XFILLER_34_451 VGND VGND VPWR VPWR sky130_fd_sc_hd__decap_3
XFILLER_61_281 VGND VGND VPWR VPWR sky130_fd_sc_hd__decap_3
XFILLER_21_178 VGND VGND VPWR VPWR sky130_fd_sc_hd__fill_1
X_2987_ _4866_/A _2987_/B VGND VGND VPWR VPWR _2987_/Y sky130_fd_sc_hd__nor2_2
X_4726_ _4786_/A _4722_/Y _4725_/X _4545_/Y _4635_/Y VGND VGND VPWR VPWR _4726_/X
+ sky130_fd_sc_hd__a32o_2
X_4657_ _4687_/A _4655_/Y _4656_/X _4641_/X _4654_/Y VGND VGND VPWR VPWR _4657_/X
+ sky130_fd_sc_hd__a32o_2
X_3608_ _4403_/A _5154_/Q _4542_/S VGND VGND VPWR VPWR _4107_/B sky130_fd_sc_hd__mux2_1
X_4588_ _4588_/A _4588_/B VGND VGND VPWR VPWR _4588_/Y sky130_fd_sc_hd__nor2_2
X_3539_ _5161_/Q _5142_/Q VGND VGND VPWR VPWR _3540_/B sky130_fd_sc_hd__and2_2
XFILLER_67_27 VGND VGND VPWR VPWR sky130_fd_sc_hd__decap_3
XFILLER_88_167 VGND VGND VPWR VPWR sky130_fd_sc_hd__decap_3
XFILLER_29_201 VGND VGND VPWR VPWR sky130_fd_sc_hd__decap_3
XFILLER_67_49 VGND VGND VPWR VPWR sky130_fd_sc_hd__decap_3
XFILLER_69_370 VGND VGND VPWR VPWR sky130_fd_sc_hd__decap_3
X_5209_ _5210_/CLK _5209_/D VGND VGND VPWR VPWR _5209_/Q sky130_fd_sc_hd__dfxtp_2
XFILLER_76_318 VGND VGND VPWR VPWR sky130_fd_sc_hd__decap_3
XFILLER_57_543 VGND VGND VPWR VPWR sky130_fd_sc_hd__decap_3
XFILLER_29_267 VGND VGND VPWR VPWR sky130_fd_sc_hd__decap_3
XFILLER_44_204 VGND VGND VPWR VPWR sky130_fd_sc_hd__decap_3
XFILLER_72_513 VGND VGND VPWR VPWR sky130_fd_sc_hd__decap_3
XFILLER_84_351 VGND VGND VPWR VPWR sky130_fd_sc_hd__decap_3
XTAP_TAPCELL_ROW_55_722 VGND VPWR sky130_fd_sc_hd__tapvpwrvgnd_1
XFILLER_44_259 VGND VGND VPWR VPWR sky130_fd_sc_hd__decap_3
XTAP_TAPCELL_ROW_27_457 VGND VPWR sky130_fd_sc_hd__tapvpwrvgnd_1
XFILLER_25_495 VGND VGND VPWR VPWR sky130_fd_sc_hd__decap_3
XFILLER_40_410 VGND VGND VPWR VPWR sky130_fd_sc_hd__decap_3
XFILLER_16_97 VGND VGND VPWR VPWR sky130_fd_sc_hd__decap_3
XFILLER_40_421 VGND VGND VPWR VPWR sky130_fd_sc_hd__decap_3
XFILLER_40_454 VGND VGND VPWR VPWR sky130_fd_sc_hd__decap_3
XFILLER_40_498 VGND VGND VPWR VPWR sky130_fd_sc_hd__decap_3
XFILLER_8_138 VGND VGND VPWR VPWR sky130_fd_sc_hd__fill_2
XFILLER_32_85 VGND VGND VPWR VPWR sky130_fd_sc_hd__decap_3
XFILLER_79_134 VGND VGND VPWR VPWR sky130_fd_sc_hd__decap_3
XFILLER_48_510 VGND VGND VPWR VPWR sky130_fd_sc_hd__decap_3
XFILLER_57_60 VGND VGND VPWR VPWR sky130_fd_sc_hd__decap_3
XFILLER_75_373 VGND VGND VPWR VPWR sky130_fd_sc_hd__decap_3
XFILLER_35_248 VGND VGND VPWR VPWR sky130_fd_sc_hd__decap_3
XFILLER_73_92 VGND VGND VPWR VPWR sky130_fd_sc_hd__decap_3
X_2910_ _2910_/A _2910_/B VGND VGND VPWR VPWR _2910_/X sky130_fd_sc_hd__or2_2
XFILLER_43_281 VGND VGND VPWR VPWR sky130_fd_sc_hd__decap_3
X_3890_ _4042_/A _4042_/B _4040_/A VGND VGND VPWR VPWR _3892_/A sky130_fd_sc_hd__o21bai_2
X_2841_ _5134_/Q _2836_/X _2838_/X _2840_/X VGND VGND VPWR VPWR _3386_/B sky130_fd_sc_hd__a22o_2
XPHY_EDGE_ROW_75_Left_169 VGND VGND VPWR VPWR sky130_fd_sc_hd__decap_3
X_2772_ _5066_/Q _5050_/Q _5034_/Q _5018_/Q _2812_/S0 _2848_/S1 VGND VGND VPWR VPWR
+ _2772_/X sky130_fd_sc_hd__mux4_2
X_4511_ _4511_/A _4511_/B VGND VGND VPWR VPWR _4512_/B sky130_fd_sc_hd__xor2_2
X_4442_ _4443_/A _4443_/B VGND VGND VPWR VPWR _4444_/A sky130_fd_sc_hd__nor2_2
X_4373_ _4360_/X _4373_/B _4373_/C VGND VGND VPWR VPWR _4375_/C sky130_fd_sc_hd__nand3b_2
X_3324_ _3323_/Y _3324_/B VGND VGND VPWR VPWR _3324_/X sky130_fd_sc_hd__and2b_2
XFILLER_58_329 VGND VGND VPWR VPWR sky130_fd_sc_hd__decap_3
X_3255_ _5154_/Q _3256_/B VGND VGND VPWR VPWR _3257_/A sky130_fd_sc_hd__and2_2
XPHY_EDGE_ROW_84_Left_178 VGND VGND VPWR VPWR sky130_fd_sc_hd__decap_3
XFILLER_37_19 VGND VGND VPWR VPWR sky130_fd_sc_hd__fill_1
XTAP_TAPCELL_ROW_69_858 VGND VPWR sky130_fd_sc_hd__tapvpwrvgnd_1
XFILLER_66_362 VGND VGND VPWR VPWR sky130_fd_sc_hd__fill_2
X_3186_ _2938_/X _3172_/B _3172_/Y _5088_/Q VGND VGND VPWR VPWR _5088_/D sky130_fd_sc_hd__a22o_2
XFILLER_26_215 VGND VGND VPWR VPWR sky130_fd_sc_hd__decap_3
XFILLER_66_384 VGND VGND VPWR VPWR sky130_fd_sc_hd__decap_3
XFILLER_81_332 VGND VGND VPWR VPWR sky130_fd_sc_hd__decap_3
XFILLER_93_192 VGND VGND VPWR VPWR sky130_fd_sc_hd__decap_3
XFILLER_81_343 VGND VGND VPWR VPWR sky130_fd_sc_hd__decap_3
XTAP_TAPCELL_ROW_24_427 VGND VPWR sky130_fd_sc_hd__tapvpwrvgnd_1
XFILLER_81_376 VGND VGND VPWR VPWR sky130_fd_sc_hd__decap_3
XFILLER_22_421 VGND VGND VPWR VPWR sky130_fd_sc_hd__decap_3
XFILLER_34_292 VGND VGND VPWR VPWR sky130_fd_sc_hd__decap_3
XPHY_EDGE_ROW_93_Left_187 VGND VGND VPWR VPWR sky130_fd_sc_hd__decap_3
XFILLER_22_454 VGND VGND VPWR VPWR sky130_fd_sc_hd__decap_3
XFILLER_5_108 VGND VGND VPWR VPWR sky130_fd_sc_hd__decap_3
X_4709_ _4708_/X _4637_/X _4804_/A VGND VGND VPWR VPWR _4709_/X sky130_fd_sc_hd__mux2_1
XFILLER_89_432 VGND VGND VPWR VPWR sky130_fd_sc_hd__fill_1
XFILLER_78_48 VGND VGND VPWR VPWR sky130_fd_sc_hd__decap_3
XFILLER_49_329 VGND VGND VPWR VPWR sky130_fd_sc_hd__decap_3
XFILLER_76_115 VGND VGND VPWR VPWR sky130_fd_sc_hd__decap_3
XFILLER_45_502 VGND VGND VPWR VPWR sky130_fd_sc_hd__fill_2
XFILLER_57_340 VGND VGND VPWR VPWR sky130_fd_sc_hd__decap_3
XFILLER_57_373 VGND VGND VPWR VPWR sky130_fd_sc_hd__decap_3
XFILLER_27_74 VGND VGND VPWR VPWR sky130_fd_sc_hd__decap_3
XFILLER_72_354 VGND VGND VPWR VPWR sky130_fd_sc_hd__decap_3
XFILLER_72_365 VGND VGND VPWR VPWR sky130_fd_sc_hd__fill_1
XFILLER_84_192 VGND VGND VPWR VPWR sky130_fd_sc_hd__decap_3
XFILLER_60_538 VGND VGND VPWR VPWR sky130_fd_sc_hd__decap_3
XFILLER_72_376 VGND VGND VPWR VPWR sky130_fd_sc_hd__decap_3
XFILLER_25_281 VGND VGND VPWR VPWR sky130_fd_sc_hd__decap_3
XFILLER_40_262 VGND VGND VPWR VPWR sky130_fd_sc_hd__decap_3
XFILLER_43_73 VGND VGND VPWR VPWR sky130_fd_sc_hd__decap_3
XFILLER_40_284 VGND VGND VPWR VPWR sky130_fd_sc_hd__decap_3
XFILLER_4_141 VGND VGND VPWR VPWR sky130_fd_sc_hd__decap_3
XFILLER_4_45 VGND VGND VPWR VPWR sky130_fd_sc_hd__decap_3
XFILLER_0_380 VGND VGND VPWR VPWR sky130_fd_sc_hd__decap_3
XFILLER_0_391 VGND VGND VPWR VPWR sky130_fd_sc_hd__fill_1
XFILLER_67_148 VGND VGND VPWR VPWR sky130_fd_sc_hd__decap_3
XFILLER_48_351 VGND VGND VPWR VPWR sky130_fd_sc_hd__decap_3
X_3040_ _2944_/X _3024_/B _3024_/Y _4962_/Q VGND VGND VPWR VPWR _4962_/D sky130_fd_sc_hd__a22o_2
XTAP_TAPCELL_ROW_66_828 VGND VPWR sky130_fd_sc_hd__tapvpwrvgnd_1
XFILLER_75_181 VGND VGND VPWR VPWR sky130_fd_sc_hd__decap_3
XFILLER_36_546 VGND VGND VPWR VPWR sky130_fd_sc_hd__decap_3
XFILLER_63_343 VGND VGND VPWR VPWR sky130_fd_sc_hd__decap_3
XFILLER_63_365 VGND VGND VPWR VPWR sky130_fd_sc_hd__fill_1
X_4991_ _5007_/CLK _4991_/D VGND VGND VPWR VPWR _4991_/Q sky130_fd_sc_hd__dfxtp_2
XFILLER_16_270 VGND VGND VPWR VPWR sky130_fd_sc_hd__decap_3
XFILLER_51_549 VGND VGND VPWR VPWR sky130_fd_sc_hd__decap_3
X_3942_ _3352_/A _4429_/B _3682_/Y _4198_/C _3922_/Y VGND VGND VPWR VPWR _4312_/B
+ sky130_fd_sc_hd__a221oi_2
X_3873_ _4164_/A _3873_/B VGND VGND VPWR VPWR _3940_/A sky130_fd_sc_hd__or2_2
XFILLER_31_284 VGND VGND VPWR VPWR sky130_fd_sc_hd__decap_3
X_2824_ _2851_/A _3366_/B VGND VGND VPWR VPWR _2824_/X sky130_fd_sc_hd__and2_2
X_2755_ _5064_/Q _5048_/Q _5032_/Q _5016_/Q _2812_/S0 _2848_/S1 VGND VGND VPWR VPWR
+ _2755_/X sky130_fd_sc_hd__mux4_2
XFILLER_8_480 VGND VGND VPWR VPWR sky130_fd_sc_hd__decap_3
X_2686_ _4311_/A VGND VGND VPWR VPWR _3680_/B sky130_fd_sc_hd__inv_2
X_4425_ _4624_/A _4420_/X _4421_/X VGND VGND VPWR VPWR _4425_/X sky130_fd_sc_hd__a21o_2
X_4356_ _4335_/A _4332_/B _3768_/B VGND VGND VPWR VPWR _4356_/Y sky130_fd_sc_hd__a21oi_2
XFILLER_48_29 VGND VGND VPWR VPWR sky130_fd_sc_hd__fill_1
X_3307_ _5139_/Q _3317_/C VGND VGND VPWR VPWR _3307_/Y sky130_fd_sc_hd__nand2_2
X_4287_ _4287_/A _4287_/B VGND VGND VPWR VPWR _4287_/X sky130_fd_sc_hd__or2_2
XFILLER_27_502 VGND VGND VPWR VPWR sky130_fd_sc_hd__fill_2
XFILLER_39_340 VGND VGND VPWR VPWR sky130_fd_sc_hd__fill_2
X_3238_ _5164_/Q _3450_/C _3228_/Y _3237_/X VGND VGND VPWR VPWR _5127_/D sky130_fd_sc_hd__o22a_2
XFILLER_39_373 VGND VGND VPWR VPWR sky130_fd_sc_hd__decap_3
X_3169_ _2941_/X _3154_/B _3154_/Y _5073_/Q VGND VGND VPWR VPWR _5073_/D sky130_fd_sc_hd__a22o_2
XFILLER_54_332 VGND VGND VPWR VPWR sky130_fd_sc_hd__fill_1
XFILLER_14_229 VGND VGND VPWR VPWR sky130_fd_sc_hd__decap_3
XFILLER_54_365 VGND VGND VPWR VPWR sky130_fd_sc_hd__decap_3
XTAP_TAPCELL_ROW_37_552 VGND VPWR sky130_fd_sc_hd__tapvpwrvgnd_1
XFILLER_81_162 VGND VGND VPWR VPWR sky130_fd_sc_hd__decap_3
XFILLER_80_38 VGND VGND VPWR VPWR sky130_fd_sc_hd__decap_3
XFILLER_80_27 VGND VGND VPWR VPWR sky130_fd_sc_hd__fill_1
XFILLER_10_424 VGND VGND VPWR VPWR sky130_fd_sc_hd__decap_3
XFILLER_13_65 VGND VGND VPWR VPWR sky130_fd_sc_hd__decap_3
XFILLER_8_3 VGND VGND VPWR VPWR sky130_fd_sc_hd__decap_3
XFILLER_89_240 VGND VGND VPWR VPWR sky130_fd_sc_hd__decap_3
XFILLER_1_144 VGND VGND VPWR VPWR sky130_fd_sc_hd__decap_3
XTAP_TAPCELL_ROW_9_288 VGND VPWR sky130_fd_sc_hd__tapvpwrvgnd_1
XFILLER_89_273 VGND VGND VPWR VPWR sky130_fd_sc_hd__fill_2
XFILLER_77_402 VGND VGND VPWR VPWR sky130_fd_sc_hd__decap_3
XFILLER_89_284 VGND VGND VPWR VPWR sky130_fd_sc_hd__decap_3
XFILLER_77_435 VGND VGND VPWR VPWR sky130_fd_sc_hd__decap_3
XFILLER_92_416 VGND VGND VPWR VPWR sky130_fd_sc_hd__decap_3
XFILLER_64_118 VGND VGND VPWR VPWR sky130_fd_sc_hd__decap_3
XFILLER_92_427 VGND VGND VPWR VPWR sky130_fd_sc_hd__fill_2
XFILLER_57_192 VGND VGND VPWR VPWR sky130_fd_sc_hd__decap_3
XFILLER_33_505 VGND VGND VPWR VPWR sky130_fd_sc_hd__decap_3
XFILLER_45_376 VGND VGND VPWR VPWR sky130_fd_sc_hd__decap_3
XFILLER_72_195 VGND VGND VPWR VPWR sky130_fd_sc_hd__fill_1
XTAP_TAPCELL_ROW_71_875 VGND VPWR sky130_fd_sc_hd__tapvpwrvgnd_1
Xclkload25 _5210_/CLK VGND VGND VPWR VPWR clkload25/Y sky130_fd_sc_hd__clkinv_2
Xclkload14 _5254_/CLK VGND VGND VPWR VPWR clkload14/X sky130_fd_sc_hd__clkbuf_8
XFILLER_9_299 VGND VGND VPWR VPWR sky130_fd_sc_hd__fill_2
Xclkload36 _5100_/CLK VGND VGND VPWR VPWR clkload36/X sky130_fd_sc_hd__clkbuf_8
X_2540_ _5064_/Q _5048_/Q _5032_/Q _5016_/Q _2658_/S0 _2671_/S1 VGND VGND VPWR VPWR
+ _2540_/X sky130_fd_sc_hd__mux4_2
X_2471_ _2667_/A _2470_/X _5126_/Q VGND VGND VPWR VPWR _2471_/X sky130_fd_sc_hd__o21a_2
X_4210_ _3682_/B _4000_/X _4002_/Y _2649_/Y _4110_/A VGND VGND VPWR VPWR _4210_/X
+ sky130_fd_sc_hd__a221o_2
X_5190_ clkload7/A _5190_/D VGND VGND VPWR VPWR _5190_/Q sky130_fd_sc_hd__dfxtp_2
XFILLER_68_446 VGND VGND VPWR VPWR sky130_fd_sc_hd__decap_3
X_4141_ _3886_/Y _4112_/A _4666_/A _4140_/Y _4139_/A VGND VGND VPWR VPWR _4142_/D
+ sky130_fd_sc_hd__o32a_2
XTAP_TAPCELL_ROW_79_953 VGND VPWR sky130_fd_sc_hd__tapvpwrvgnd_1
X_4072_ _3972_/Y _3978_/X _4077_/S VGND VGND VPWR VPWR _4072_/X sky130_fd_sc_hd__mux2_1
X_3023_ _3207_/A _3023_/B VGND VGND VPWR VPWR _3023_/Y sky130_fd_sc_hd__nor2_2
XFILLER_83_449 VGND VGND VPWR VPWR sky130_fd_sc_hd__decap_3
XFILLER_83_427 VGND VGND VPWR VPWR sky130_fd_sc_hd__fill_2
XFILLER_36_354 VGND VGND VPWR VPWR sky130_fd_sc_hd__fill_1
XFILLER_36_365 VGND VGND VPWR VPWR sky130_fd_sc_hd__decap_3
XFILLER_51_302 VGND VGND VPWR VPWR sky130_fd_sc_hd__decap_3
XFILLER_91_482 VGND VGND VPWR VPWR sky130_fd_sc_hd__decap_3
XFILLER_91_471 VGND VGND VPWR VPWR sky130_fd_sc_hd__fill_2
XFILLER_51_335 VGND VGND VPWR VPWR sky130_fd_sc_hd__fill_1
XFILLER_63_184 VGND VGND VPWR VPWR sky130_fd_sc_hd__decap_3
X_4974_ _5114_/CLK _4974_/D VGND VGND VPWR VPWR _4974_/Q sky130_fd_sc_hd__dfxtp_2
XTAP_TAPCELL_ROW_34_522 VGND VPWR sky130_fd_sc_hd__tapvpwrvgnd_1
XFILLER_51_357 VGND VGND VPWR VPWR sky130_fd_sc_hd__decap_3
X_3925_ _5152_/Q _4493_/B VGND VGND VPWR VPWR _3925_/Y sky130_fd_sc_hd__nand2_2
Xclkload8 clkload8/A VGND VGND VPWR VPWR clkload8/X sky130_fd_sc_hd__clkbuf_4
X_3856_ _5152_/Q _4405_/B _4404_/S VGND VGND VPWR VPWR _4523_/S sky130_fd_sc_hd__mux2_2
X_3787_ _5113_/Q _5001_/Q _4985_/Q _4969_/Q _5127_/Q _3834_/S1 VGND VGND VPWR VPWR
+ _3787_/X sky130_fd_sc_hd__mux4_2
X_2807_ _4894_/Q _4878_/Q _5102_/Q _5086_/Q _2812_/S0 _2848_/S1 VGND VGND VPWR VPWR
+ _2808_/B sky130_fd_sc_hd__mux4_2
X_2738_ _5110_/Q _4998_/Q _4982_/Q _4966_/Q _2812_/S0 _2848_/S1 VGND VGND VPWR VPWR
+ _2739_/B sky130_fd_sc_hd__mux4_2
XFILLER_59_39 VGND VGND VPWR VPWR sky130_fd_sc_hd__decap_3
X_4408_ _4406_/Y _4407_/X _4408_/S VGND VGND VPWR VPWR _4624_/A sky130_fd_sc_hd__mux2_1
X_2669_ _5125_/Q _2668_/X _5126_/Q VGND VGND VPWR VPWR _2669_/X sky130_fd_sc_hd__o21a_2
XFILLER_59_402 VGND VGND VPWR VPWR sky130_fd_sc_hd__decap_3
XFILLER_59_446 VGND VGND VPWR VPWR sky130_fd_sc_hd__fill_2
X_4339_ _4339_/A _4339_/B VGND VGND VPWR VPWR _4339_/Y sky130_fd_sc_hd__nor2_2
XTAP_TAPCELL_ROW_6_258 VGND VPWR sky130_fd_sc_hd__tapvpwrvgnd_1
XFILLER_86_265 VGND VGND VPWR VPWR sky130_fd_sc_hd__fill_1
XFILLER_46_129 VGND VGND VPWR VPWR sky130_fd_sc_hd__decap_3
XFILLER_86_276 VGND VGND VPWR VPWR sky130_fd_sc_hd__decap_3
XFILLER_39_181 VGND VGND VPWR VPWR sky130_fd_sc_hd__decap_3
XFILLER_15_505 VGND VGND VPWR VPWR sky130_fd_sc_hd__decap_3
XFILLER_54_195 VGND VGND VPWR VPWR sky130_fd_sc_hd__fill_1
XFILLER_42_368 VGND VGND VPWR VPWR sky130_fd_sc_hd__decap_3
XFILLER_24_53 VGND VGND VPWR VPWR sky130_fd_sc_hd__decap_3
XFILLER_10_221 VGND VGND VPWR VPWR sky130_fd_sc_hd__fill_1
XFILLER_50_390 VGND VGND VPWR VPWR sky130_fd_sc_hd__decap_3
XFILLER_6_203 VGND VGND VPWR VPWR sky130_fd_sc_hd__decap_3
XFILLER_6_236 VGND VGND VPWR VPWR sky130_fd_sc_hd__decap_3
XFILLER_40_85 VGND VGND VPWR VPWR sky130_fd_sc_hd__decap_3
XFILLER_77_265 VGND VGND VPWR VPWR sky130_fd_sc_hd__decap_3
XFILLER_37_107 VGND VGND VPWR VPWR sky130_fd_sc_hd__decap_3
XTAP_TAPCELL_ROW_76_923 VGND VPWR sky130_fd_sc_hd__tapvpwrvgnd_1
XFILLER_77_287 VGND VGND VPWR VPWR sky130_fd_sc_hd__decap_3
XFILLER_18_321 VGND VGND VPWR VPWR sky130_fd_sc_hd__decap_3
XTAP_TAPCELL_ROW_48_658 VGND VPWR sky130_fd_sc_hd__tapvpwrvgnd_1
XFILLER_92_246 VGND VGND VPWR VPWR sky130_fd_sc_hd__decap_3
XFILLER_18_365 VGND VGND VPWR VPWR sky130_fd_sc_hd__decap_3
XFILLER_45_140 VGND VGND VPWR VPWR sky130_fd_sc_hd__decap_3
XFILLER_65_71 VGND VGND VPWR VPWR sky130_fd_sc_hd__decap_3
XFILLER_92_268 VGND VGND VPWR VPWR sky130_fd_sc_hd__decap_3
XFILLER_18_387 VGND VGND VPWR VPWR sky130_fd_sc_hd__decap_3
XFILLER_33_324 VGND VGND VPWR VPWR sky130_fd_sc_hd__decap_3
XFILLER_33_346 VGND VGND VPWR VPWR sky130_fd_sc_hd__decap_3
XFILLER_45_184 VGND VGND VPWR VPWR sky130_fd_sc_hd__decap_3
XFILLER_73_482 VGND VGND VPWR VPWR sky130_fd_sc_hd__fill_2
XFILLER_21_508 VGND VGND VPWR VPWR sky130_fd_sc_hd__decap_3
XFILLER_33_379 VGND VGND VPWR VPWR sky130_fd_sc_hd__fill_1
X_3710_ _5118_/Q _5006_/Q _4990_/Q _4974_/Q _3834_/S0 _3834_/S1 VGND VGND VPWR VPWR
+ _3710_/X sky130_fd_sc_hd__mux4_2
X_4690_ _2449_/Y _2452_/Y _4690_/S VGND VGND VPWR VPWR _4690_/X sky130_fd_sc_hd__mux2_1
X_3641_ _4067_/A _4493_/A _4787_/S VGND VGND VPWR VPWR _3641_/X sky130_fd_sc_hd__mux2_1
XFILLER_60_3 VGND VGND VPWR VPWR sky130_fd_sc_hd__decap_3
X_3572_ _4714_/A _3572_/B VGND VGND VPWR VPWR _5203_/D sky130_fd_sc_hd__nor2_2
X_2523_ _2521_/X _2522_/X _2667_/A VGND VGND VPWR VPWR _2523_/X sky130_fd_sc_hd__mux2_1
X_5242_ _5254_/CLK _5242_/D VGND VGND VPWR VPWR _5242_/Q sky130_fd_sc_hd__dfxtp_2
X_2454_ _2887_/B _4546_/A _4171_/A _4115_/A VGND VGND VPWR VPWR _2463_/A sky130_fd_sc_hd__and4b_2
XTAP_TAPCELL_ROW_93_1089 VGND VPWR sky130_fd_sc_hd__tapvpwrvgnd_1
XFILLER_88_519 VGND VGND VPWR VPWR sky130_fd_sc_hd__decap_3
XFILLER_68_210 VGND VGND VPWR VPWR sky130_fd_sc_hd__decap_3
X_5173_ clkload4/A _5173_/D VGND VGND VPWR VPWR _5173_/Q sky130_fd_sc_hd__dfxtp_2
XFILLER_68_232 VGND VGND VPWR VPWR sky130_fd_sc_hd__decap_3
X_4124_ _4340_/A _4124_/B VGND VGND VPWR VPWR _4124_/Y sky130_fd_sc_hd__nor2_2
XFILLER_28_118 VGND VGND VPWR VPWR sky130_fd_sc_hd__decap_3
XFILLER_28_129 VGND VGND VPWR VPWR sky130_fd_sc_hd__decap_3
XFILLER_56_416 VGND VGND VPWR VPWR sky130_fd_sc_hd__decap_3
XFILLER_68_287 VGND VGND VPWR VPWR sky130_fd_sc_hd__decap_3
Xinput1 INSTR_STREAM[0] VGND VGND VPWR VPWR input1/X sky130_fd_sc_hd__clkdlybuf4s25_1
XTAP_TAPCELL_ROW_3_228 VGND VPWR sky130_fd_sc_hd__tapvpwrvgnd_1
X_4055_ _4022_/Y _4023_/X _4030_/X _4054_/Y VGND VGND VPWR VPWR _4055_/X sky130_fd_sc_hd__o211a_2
XFILLER_71_408 VGND VGND VPWR VPWR sky130_fd_sc_hd__decap_3
X_3006_ _4866_/A _3006_/B VGND VGND VPWR VPWR _3006_/Y sky130_fd_sc_hd__nor2_2
XFILLER_83_279 VGND VGND VPWR VPWR sky130_fd_sc_hd__fill_1
XFILLER_24_324 VGND VGND VPWR VPWR sky130_fd_sc_hd__decap_3
XFILLER_36_195 VGND VGND VPWR VPWR sky130_fd_sc_hd__fill_1
XFILLER_64_493 VGND VGND VPWR VPWR sky130_fd_sc_hd__fill_1
XTAP_TAPCELL_ROW_19_382 VGND VPWR sky130_fd_sc_hd__tapvpwrvgnd_1
XFILLER_24_368 VGND VGND VPWR VPWR sky130_fd_sc_hd__decap_3
XFILLER_51_187 VGND VGND VPWR VPWR sky130_fd_sc_hd__fill_1
X_4957_ _5007_/CLK _4957_/D VGND VGND VPWR VPWR _4957_/Q sky130_fd_sc_hd__dfxtp_2
XFILLER_20_541 VGND VGND VPWR VPWR sky130_fd_sc_hd__decap_3
X_4888_ _5109_/CLK _4888_/D VGND VGND VPWR VPWR _4888_/Q sky130_fd_sc_hd__dfxtp_2
X_3908_ _3844_/X _3902_/B _3907_/X VGND VGND VPWR VPWR _3908_/Y sky130_fd_sc_hd__o21bai_2
X_3839_ _4646_/S _3839_/B VGND VGND VPWR VPWR _4095_/A sky130_fd_sc_hd__nor2_2
XFILLER_59_210 VGND VGND VPWR VPWR sky130_fd_sc_hd__decap_3
XFILLER_86_15 VGND VGND VPWR VPWR sky130_fd_sc_hd__fill_2
XFILLER_87_541 VGND VGND VPWR VPWR sky130_fd_sc_hd__decap_3
XFILLER_59_276 VGND VGND VPWR VPWR sky130_fd_sc_hd__decap_3
XFILLER_74_213 VGND VGND VPWR VPWR sky130_fd_sc_hd__decap_3
XFILLER_47_449 VGND VGND VPWR VPWR sky130_fd_sc_hd__decap_3
XFILLER_27_151 VGND VGND VPWR VPWR sky130_fd_sc_hd__decap_3
XFILLER_15_335 VGND VGND VPWR VPWR sky130_fd_sc_hd__fill_1
XFILLER_35_52 VGND VGND VPWR VPWR sky130_fd_sc_hd__decap_3
XFILLER_55_482 VGND VGND VPWR VPWR sky130_fd_sc_hd__decap_3
XFILLER_70_430 VGND VGND VPWR VPWR sky130_fd_sc_hd__decap_3
XTAP_TAPCELL_ROW_45_628 VGND VPWR sky130_fd_sc_hd__tapvpwrvgnd_1
XFILLER_15_379 VGND VGND VPWR VPWR sky130_fd_sc_hd__decap_3
XTAP_TAPCELL_ROW_81_970 VGND VPWR sky130_fd_sc_hd__tapvpwrvgnd_1
XFILLER_11_552 VGND VGND VPWR VPWR sky130_fd_sc_hd__fill_1
XFILLER_51_84 VGND VGND VPWR VPWR sky130_fd_sc_hd__decap_3
XFILLER_7_545 VGND VGND VPWR VPWR sky130_fd_sc_hd__decap_3
XFILLER_25_6 VGND VGND VPWR VPWR sky130_fd_sc_hd__decap_3
XFILLER_93_511 VGND VGND VPWR VPWR sky130_fd_sc_hd__decap_3
XFILLER_65_235 VGND VGND VPWR VPWR sky130_fd_sc_hd__fill_2
XFILLER_93_533 VGND VGND VPWR VPWR sky130_fd_sc_hd__decap_3
XFILLER_33_143 VGND VGND VPWR VPWR sky130_fd_sc_hd__fill_2
XFILLER_61_452 VGND VGND VPWR VPWR sky130_fd_sc_hd__decap_3
XFILLER_73_290 VGND VGND VPWR VPWR sky130_fd_sc_hd__decap_3
X_4811_ _4361_/A _4807_/X _4810_/Y _4373_/C VGND VGND VPWR VPWR _4811_/X sky130_fd_sc_hd__o211a_2
XFILLER_61_485 VGND VGND VPWR VPWR sky130_fd_sc_hd__decap_3
XTAP_TAPCELL_ROW_16_352 VGND VPWR sky130_fd_sc_hd__tapvpwrvgnd_1
X_4742_ _4740_/X _4741_/Y _4714_/A VGND VGND VPWR VPWR _5232_/D sky130_fd_sc_hd__a21oi_2
X_4673_ _4686_/S _4673_/B VGND VGND VPWR VPWR _4673_/Y sky130_fd_sc_hd__nand2_2
X_3624_ _3622_/X _3623_/X _5129_/Q VGND VGND VPWR VPWR _3624_/X sky130_fd_sc_hd__mux2_1
X_3555_ _3555_/A _3555_/B _3555_/C VGND VGND VPWR VPWR _3555_/Y sky130_fd_sc_hd__nor3_2
XFILLER_0_209 VGND VGND VPWR VPWR sky130_fd_sc_hd__decap_3
X_3486_ _5152_/Q _5149_/Q _3479_/C _3477_/X VGND VGND VPWR VPWR _3488_/C sky130_fd_sc_hd__a31o_2
X_2506_ _4895_/Q _4879_/Q _5103_/Q _5087_/Q _2658_/S0 _2671_/S1 VGND VGND VPWR VPWR
+ _2506_/X sky130_fd_sc_hd__mux4_2
XFILLER_88_316 VGND VGND VPWR VPWR sky130_fd_sc_hd__decap_3
X_5225_ clkload8/A _5225_/D VGND VGND VPWR VPWR _5225_/Q sky130_fd_sc_hd__dfxtp_2
X_2437_ _5134_/Q VGND VGND VPWR VPWR _2437_/Y sky130_fd_sc_hd__inv_2
XFILLER_29_405 VGND VGND VPWR VPWR sky130_fd_sc_hd__fill_1
XFILLER_56_29 VGND VGND VPWR VPWR sky130_fd_sc_hd__decap_3
X_5156_ _5177_/CLK _5156_/D VGND VGND VPWR VPWR _5156_/Q sky130_fd_sc_hd__dfxtp_2
XFILLER_29_449 VGND VGND VPWR VPWR sky130_fd_sc_hd__decap_3
X_4107_ _4107_/A _4107_/B VGND VGND VPWR VPWR _4107_/X sky130_fd_sc_hd__or2_2
X_5087_ _5103_/CLK _5087_/D VGND VGND VPWR VPWR _5087_/Q sky130_fd_sc_hd__dfxtp_2
XFILLER_56_268 VGND VGND VPWR VPWR sky130_fd_sc_hd__decap_3
X_4038_ _4546_/B _3843_/A _3729_/X VGND VGND VPWR VPWR _4040_/B sky130_fd_sc_hd__a21o_2
XFILLER_52_430 VGND VGND VPWR VPWR sky130_fd_sc_hd__decap_3
XFILLER_52_463 VGND VGND VPWR VPWR sky130_fd_sc_hd__decap_3
XFILLER_12_338 VGND VGND VPWR VPWR sky130_fd_sc_hd__decap_3
XTAP_TAPCELL_ROW_50_675 VGND VPWR sky130_fd_sc_hd__tapvpwrvgnd_1
XFILLER_79_316 VGND VGND VPWR VPWR sky130_fd_sc_hd__decap_3
XFILLER_47_213 VGND VGND VPWR VPWR sky130_fd_sc_hd__decap_3
XFILLER_87_382 VGND VGND VPWR VPWR sky130_fd_sc_hd__decap_3
XFILLER_87_393 VGND VGND VPWR VPWR sky130_fd_sc_hd__decap_3
XFILLER_28_460 VGND VGND VPWR VPWR sky130_fd_sc_hd__decap_3
XFILLER_35_408 VGND VGND VPWR VPWR sky130_fd_sc_hd__fill_1
XFILLER_46_51 VGND VGND VPWR VPWR sky130_fd_sc_hd__decap_3
XFILLER_47_257 VGND VGND VPWR VPWR sky130_fd_sc_hd__decap_3
XFILLER_47_279 VGND VGND VPWR VPWR sky130_fd_sc_hd__fill_1
XTAP_TAPCELL_ROW_58_753 VGND VPWR sky130_fd_sc_hd__tapvpwrvgnd_1
XFILLER_15_110 VGND VGND VPWR VPWR sky130_fd_sc_hd__fill_2
XFILLER_28_493 VGND VGND VPWR VPWR sky130_fd_sc_hd__fill_1
XFILLER_43_452 VGND VGND VPWR VPWR sky130_fd_sc_hd__fill_1
XFILLER_15_165 VGND VGND VPWR VPWR sky130_fd_sc_hd__decap_3
XFILLER_70_293 VGND VGND VPWR VPWR sky130_fd_sc_hd__decap_3
XTAP_TAPCELL_ROW_13_322 VGND VPWR sky130_fd_sc_hd__tapvpwrvgnd_1
XFILLER_7_12 VGND VGND VPWR VPWR sky130_fd_sc_hd__decap_3
XFILLER_11_393 VGND VGND VPWR VPWR sky130_fd_sc_hd__fill_1
XFILLER_7_45 VGND VGND VPWR VPWR sky130_fd_sc_hd__decap_3
XFILLER_7_353 VGND VGND VPWR VPWR sky130_fd_sc_hd__decap_3
X_3340_ _5162_/Q _3341_/B VGND VGND VPWR VPWR _3353_/A sky130_fd_sc_hd__and2_2
X_5010_ _5115_/CLK _5010_/D VGND VGND VPWR VPWR _5010_/Q sky130_fd_sc_hd__dfxtp_2
X_3271_ _3271_/A VGND VGND VPWR VPWR _3273_/A sky130_fd_sc_hd__inv_2
XTAP_TAPCELL_ROW_90_1059 VGND VPWR sky130_fd_sc_hd__tapvpwrvgnd_1
XFILLER_23_3 VGND VGND VPWR VPWR sky130_fd_sc_hd__decap_3
XFILLER_87_80 VGND VGND VPWR VPWR sky130_fd_sc_hd__decap_3
XFILLER_66_522 VGND VGND VPWR VPWR sky130_fd_sc_hd__decap_3
XFILLER_66_533 VGND VGND VPWR VPWR sky130_fd_sc_hd__decap_3
XFILLER_78_393 VGND VGND VPWR VPWR sky130_fd_sc_hd__decap_3
XFILLER_19_460 VGND VGND VPWR VPWR sky130_fd_sc_hd__fill_2
XFILLER_26_408 VGND VGND VPWR VPWR sky130_fd_sc_hd__fill_2
XFILLER_93_374 VGND VGND VPWR VPWR sky130_fd_sc_hd__decap_3
XFILLER_93_363 VGND VGND VPWR VPWR sky130_fd_sc_hd__fill_1
XFILLER_93_352 VGND VGND VPWR VPWR sky130_fd_sc_hd__decap_3
XFILLER_53_216 VGND VGND VPWR VPWR sky130_fd_sc_hd__decap_3
XFILLER_81_536 VGND VGND VPWR VPWR sky130_fd_sc_hd__decap_3
XFILLER_34_430 VGND VGND VPWR VPWR sky130_fd_sc_hd__decap_3
XFILLER_53_249 VGND VGND VPWR VPWR sky130_fd_sc_hd__decap_3
XFILLER_21_113 VGND VGND VPWR VPWR sky130_fd_sc_hd__decap_3
X_2986_ _3004_/B _3189_/B VGND VGND VPWR VPWR _2986_/Y sky130_fd_sc_hd__nor2_2
X_4725_ _4804_/A _4773_/B VGND VGND VPWR VPWR _4725_/X sky130_fd_sc_hd__or2_2
X_4656_ _4686_/S _4656_/B VGND VGND VPWR VPWR _4656_/X sky130_fd_sc_hd__or2_2
X_4587_ _4586_/X _4607_/A VGND VGND VPWR VPWR _4587_/Y sky130_fd_sc_hd__nand2b_2
X_3607_ _3602_/X _3603_/X _3606_/X _2432_/Y VGND VGND VPWR VPWR _4403_/A sky130_fd_sc_hd__a22o_2
X_3538_ _5161_/Q _5142_/Q VGND VGND VPWR VPWR _3549_/A sky130_fd_sc_hd__nor2_2
XFILLER_1_529 VGND VGND VPWR VPWR sky130_fd_sc_hd__decap_3
X_3469_ _5174_/Q _3453_/X _4850_/B VGND VGND VPWR VPWR _3469_/X sky130_fd_sc_hd__a21o_2
X_5208_ _5241_/CLK _5208_/D VGND VGND VPWR VPWR _5208_/Q sky130_fd_sc_hd__dfxtp_2
XFILLER_69_393 VGND VGND VPWR VPWR sky130_fd_sc_hd__decap_3
X_5139_ _5164_/CLK _5139_/D VGND VGND VPWR VPWR _5139_/Q sky130_fd_sc_hd__dfxtp_2
XFILLER_29_279 VGND VGND VPWR VPWR sky130_fd_sc_hd__fill_1
XFILLER_44_216 VGND VGND VPWR VPWR sky130_fd_sc_hd__decap_3
XFILLER_72_525 VGND VGND VPWR VPWR sky130_fd_sc_hd__decap_3
XFILLER_72_536 VGND VGND VPWR VPWR sky130_fd_sc_hd__decap_3
XTAP_TAPCELL_ROW_55_723 VGND VPWR sky130_fd_sc_hd__tapvpwrvgnd_1
XFILLER_84_396 VGND VGND VPWR VPWR sky130_fd_sc_hd__decap_3
XFILLER_84_374 VGND VGND VPWR VPWR sky130_fd_sc_hd__decap_3
XFILLER_16_32 VGND VGND VPWR VPWR sky130_fd_sc_hd__decap_3
XFILLER_37_290 VGND VGND VPWR VPWR sky130_fd_sc_hd__fill_1
XTAP_TAPCELL_ROW_27_458 VGND VPWR sky130_fd_sc_hd__tapvpwrvgnd_1
XFILLER_52_271 VGND VGND VPWR VPWR sky130_fd_sc_hd__decap_3
XFILLER_12_113 VGND VGND VPWR VPWR sky130_fd_sc_hd__fill_1
XFILLER_40_433 VGND VGND VPWR VPWR sky130_fd_sc_hd__decap_3
XFILLER_40_477 VGND VGND VPWR VPWR sky130_fd_sc_hd__decap_3
XFILLER_12_179 VGND VGND VPWR VPWR sky130_fd_sc_hd__decap_3
XFILLER_8_128 VGND VGND VPWR VPWR sky130_fd_sc_hd__fill_1
XFILLER_4_312 VGND VGND VPWR VPWR sky130_fd_sc_hd__decap_3
XFILLER_0_551 VGND VGND VPWR VPWR sky130_fd_sc_hd__fill_2
XFILLER_48_500 VGND VGND VPWR VPWR sky130_fd_sc_hd__decap_3
XFILLER_67_308 VGND VGND VPWR VPWR sky130_fd_sc_hd__decap_3
XFILLER_57_72 VGND VGND VPWR VPWR sky130_fd_sc_hd__decap_3
XFILLER_75_352 VGND VGND VPWR VPWR sky130_fd_sc_hd__decap_3
XFILLER_63_514 VGND VGND VPWR VPWR sky130_fd_sc_hd__decap_3
XFILLER_63_547 VGND VGND VPWR VPWR sky130_fd_sc_hd__decap_3
XFILLER_75_385 VGND VGND VPWR VPWR sky130_fd_sc_hd__decap_3
XFILLER_73_71 VGND VGND VPWR VPWR sky130_fd_sc_hd__decap_3
XFILLER_43_293 VGND VGND VPWR VPWR sky130_fd_sc_hd__decap_3
X_2840_ _2831_/S _2839_/X _2437_/Y VGND VGND VPWR VPWR _2840_/X sky130_fd_sc_hd__o21a_2
XFILLER_92_6 VGND VGND VPWR VPWR sky130_fd_sc_hd__fill_2
XFILLER_31_466 VGND VGND VPWR VPWR sky130_fd_sc_hd__decap_3
X_2771_ _4890_/Q _4874_/Q _5098_/Q _5082_/Q _2812_/S0 _2848_/S1 VGND VGND VPWR VPWR
+ _2771_/X sky130_fd_sc_hd__mux4_2
X_4510_ _4510_/A _4510_/B VGND VGND VPWR VPWR _4511_/B sky130_fd_sc_hd__xnor2_2
X_4441_ _4441_/A _4441_/B VGND VGND VPWR VPWR _4443_/B sky130_fd_sc_hd__xnor2_2
XFILLER_7_172 VGND VGND VPWR VPWR sky130_fd_sc_hd__decap_3
XPHY_EDGE_ROW_9_Right_9 VGND VGND VPWR VPWR sky130_fd_sc_hd__decap_3
X_4372_ _2479_/A _4002_/Y _4172_/B _4371_/Y VGND VGND VPWR VPWR _4375_/B sky130_fd_sc_hd__a211o_2
X_3323_ _5160_/Q _3323_/B VGND VGND VPWR VPWR _3323_/Y sky130_fd_sc_hd__xnor2_2
XFILLER_39_511 VGND VGND VPWR VPWR sky130_fd_sc_hd__decap_3
X_3254_ _4866_/A _4866_/B VGND VGND VPWR VPWR _5134_/D sky130_fd_sc_hd__nor2_2
XTAP_TAPCELL_ROW_69_859 VGND VPWR sky130_fd_sc_hd__tapvpwrvgnd_1
XFILLER_66_341 VGND VGND VPWR VPWR sky130_fd_sc_hd__decap_3
X_3185_ _2935_/X _3185_/A2 _3185_/B1 _5087_/Q VGND VGND VPWR VPWR _5087_/D sky130_fd_sc_hd__a22o_2
XFILLER_26_227 VGND VGND VPWR VPWR sky130_fd_sc_hd__decap_3
XFILLER_54_514 VGND VGND VPWR VPWR sky130_fd_sc_hd__decap_3
XFILLER_81_311 VGND VGND VPWR VPWR sky130_fd_sc_hd__decap_3
XFILLER_53_19 VGND VGND VPWR VPWR sky130_fd_sc_hd__decap_3
XFILLER_81_399 VGND VGND VPWR VPWR sky130_fd_sc_hd__decap_3
XTAP_TAPCELL_ROW_24_428 VGND VPWR sky130_fd_sc_hd__tapvpwrvgnd_1
XFILLER_22_477 VGND VGND VPWR VPWR sky130_fd_sc_hd__decap_3
X_2969_ _2891_/X _2984_/A2 _2968_/Y _4899_/Q VGND VGND VPWR VPWR _4899_/D sky130_fd_sc_hd__a22o_2
XTAP_TAPCELL_ROW_60_770 VGND VPWR sky130_fd_sc_hd__tapvpwrvgnd_1
X_4708_ _4707_/Y _4675_/X _4802_/A VGND VGND VPWR VPWR _4708_/X sky130_fd_sc_hd__mux2_1
X_4639_ _4637_/X _4638_/X _4804_/A VGND VGND VPWR VPWR _4639_/X sky130_fd_sc_hd__mux2_1
XFILLER_1_315 VGND VGND VPWR VPWR sky130_fd_sc_hd__fill_1
XFILLER_89_411 VGND VGND VPWR VPWR sky130_fd_sc_hd__decap_3
XFILLER_78_27 VGND VGND VPWR VPWR sky130_fd_sc_hd__fill_1
XFILLER_49_308 VGND VGND VPWR VPWR sky130_fd_sc_hd__decap_3
XFILLER_89_488 VGND VGND VPWR VPWR sky130_fd_sc_hd__fill_2
XFILLER_76_127 VGND VGND VPWR VPWR sky130_fd_sc_hd__decap_3
XFILLER_17_205 VGND VGND VPWR VPWR sky130_fd_sc_hd__fill_1
XFILLER_45_514 VGND VGND VPWR VPWR sky130_fd_sc_hd__decap_3
XFILLER_57_385 VGND VGND VPWR VPWR sky130_fd_sc_hd__decap_3
XFILLER_57_396 VGND VGND VPWR VPWR sky130_fd_sc_hd__decap_3
XFILLER_72_300 VGND VGND VPWR VPWR sky130_fd_sc_hd__decap_3
XFILLER_60_506 VGND VGND VPWR VPWR sky130_fd_sc_hd__decap_3
XFILLER_13_422 VGND VGND VPWR VPWR sky130_fd_sc_hd__decap_3
XFILLER_72_399 VGND VGND VPWR VPWR sky130_fd_sc_hd__fill_1
XFILLER_40_296 VGND VGND VPWR VPWR sky130_fd_sc_hd__decap_3
XFILLER_43_85 VGND VGND VPWR VPWR sky130_fd_sc_hd__fill_1
XFILLER_4_153 VGND VGND VPWR VPWR sky130_fd_sc_hd__decap_3
XFILLER_4_197 VGND VGND VPWR VPWR sky130_fd_sc_hd__decap_3
XFILLER_68_60 VGND VGND VPWR VPWR sky130_fd_sc_hd__decap_3
XFILLER_48_330 VGND VGND VPWR VPWR sky130_fd_sc_hd__decap_3
XFILLER_36_514 VGND VGND VPWR VPWR sky130_fd_sc_hd__decap_3
XFILLER_48_363 VGND VGND VPWR VPWR sky130_fd_sc_hd__fill_1
XFILLER_63_300 VGND VGND VPWR VPWR sky130_fd_sc_hd__decap_3
XTAP_TAPCELL_ROW_89_1050 VGND VPWR sky130_fd_sc_hd__tapvpwrvgnd_1
XTAP_TAPCELL_ROW_66_829 VGND VPWR sky130_fd_sc_hd__tapvpwrvgnd_1
XFILLER_63_333 VGND VGND VPWR VPWR sky130_fd_sc_hd__decap_3
XFILLER_90_141 VGND VGND VPWR VPWR sky130_fd_sc_hd__decap_3
XFILLER_84_81 VGND VGND VPWR VPWR sky130_fd_sc_hd__decap_3
XFILLER_51_517 VGND VGND VPWR VPWR sky130_fd_sc_hd__decap_3
X_4990_ _5116_/CLK _4990_/D VGND VGND VPWR VPWR _4990_/Q sky130_fd_sc_hd__dfxtp_2
XFILLER_16_282 VGND VGND VPWR VPWR sky130_fd_sc_hd__decap_3
XFILLER_63_399 VGND VGND VPWR VPWR sky130_fd_sc_hd__fill_2
X_3941_ _3936_/A _3936_/B _3939_/Y _3940_/Y VGND VGND VPWR VPWR _4198_/C sky130_fd_sc_hd__o31a_2
X_3872_ _2853_/B _4003_/A _4003_/B _2855_/A VGND VGND VPWR VPWR _3877_/B sky130_fd_sc_hd__a211oi_2
X_2823_ _5134_/Q _2818_/X _2820_/X _2822_/X VGND VGND VPWR VPWR _3366_/B sky130_fd_sc_hd__a22o_2
X_2754_ _5133_/Q _2754_/B VGND VGND VPWR VPWR _2754_/X sky130_fd_sc_hd__or2_2
X_2685_ _2685_/A _2886_/B VGND VGND VPWR VPWR _4311_/A sky130_fd_sc_hd__nand2_2
X_4424_ _4422_/X _4423_/Y _4624_/A VGND VGND VPWR VPWR _4424_/X sky130_fd_sc_hd__mux2_1
X_4355_ _4800_/B _4353_/X _4354_/X _3442_/B VGND VGND VPWR VPWR _5220_/D sky130_fd_sc_hd__o211a_2
XFILLER_58_105 VGND VGND VPWR VPWR sky130_fd_sc_hd__decap_3
X_3306_ _3306_/A _3306_/B VGND VGND VPWR VPWR _3306_/Y sky130_fd_sc_hd__nor2_2
X_4286_ _4750_/S _4275_/B _4285_/X VGND VGND VPWR VPWR _4287_/B sky130_fd_sc_hd__o21ai_2
XFILLER_86_436 VGND VGND VPWR VPWR sky130_fd_sc_hd__decap_3
X_3237_ _5260_/Q _3448_/B input4/X VGND VGND VPWR VPWR _3237_/X sky130_fd_sc_hd__and3_2
XFILLER_39_385 VGND VGND VPWR VPWR sky130_fd_sc_hd__decap_3
X_3168_ _2938_/X _3154_/B _3154_/Y _5072_/Q VGND VGND VPWR VPWR _5072_/D sky130_fd_sc_hd__a22o_2
XFILLER_39_396 VGND VGND VPWR VPWR sky130_fd_sc_hd__decap_3
XFILLER_64_29 VGND VGND VPWR VPWR sky130_fd_sc_hd__decap_3
XFILLER_81_130 VGND VGND VPWR VPWR sky130_fd_sc_hd__decap_3
XFILLER_54_377 VGND VGND VPWR VPWR sky130_fd_sc_hd__fill_2
XFILLER_54_388 VGND VGND VPWR VPWR sky130_fd_sc_hd__decap_3
X_3099_ _4866_/A _3099_/B VGND VGND VPWR VPWR _3099_/Y sky130_fd_sc_hd__nor2_2
XTAP_TAPCELL_ROW_37_553 VGND VPWR sky130_fd_sc_hd__tapvpwrvgnd_1
XFILLER_42_539 VGND VGND VPWR VPWR sky130_fd_sc_hd__decap_3
XFILLER_50_550 VGND VGND VPWR VPWR sky130_fd_sc_hd__decap_3
XFILLER_10_469 VGND VGND VPWR VPWR sky130_fd_sc_hd__fill_1
XFILLER_6_407 VGND VGND VPWR VPWR sky130_fd_sc_hd__decap_3
XTAP_TAPCELL_ROW_9_289 VGND VPWR sky130_fd_sc_hd__tapvpwrvgnd_1
XFILLER_89_252 VGND VGND VPWR VPWR sky130_fd_sc_hd__decap_3
XFILLER_77_414 VGND VGND VPWR VPWR sky130_fd_sc_hd__decap_3
XFILLER_1_189 VGND VGND VPWR VPWR sky130_fd_sc_hd__fill_1
XFILLER_77_447 VGND VGND VPWR VPWR sky130_fd_sc_hd__fill_1
XFILLER_49_149 VGND VGND VPWR VPWR sky130_fd_sc_hd__decap_3
XFILLER_77_458 VGND VGND VPWR VPWR sky130_fd_sc_hd__decap_3
XFILLER_45_322 VGND VGND VPWR VPWR sky130_fd_sc_hd__decap_3
XFILLER_45_388 VGND VGND VPWR VPWR sky130_fd_sc_hd__decap_3
XFILLER_72_141 VGND VGND VPWR VPWR sky130_fd_sc_hd__decap_3
XFILLER_33_539 VGND VGND VPWR VPWR sky130_fd_sc_hd__decap_3
XFILLER_45_399 VGND VGND VPWR VPWR sky130_fd_sc_hd__decap_3
XFILLER_54_51 VGND VGND VPWR VPWR sky130_fd_sc_hd__decap_3
XTAP_TAPCELL_ROW_71_876 VGND VPWR sky130_fd_sc_hd__tapvpwrvgnd_1
XFILLER_13_263 VGND VGND VPWR VPWR sky130_fd_sc_hd__decap_3
XFILLER_9_234 VGND VGND VPWR VPWR sky130_fd_sc_hd__decap_3
XFILLER_70_61 VGND VGND VPWR VPWR sky130_fd_sc_hd__decap_3
XFILLER_70_94 VGND VGND VPWR VPWR sky130_fd_sc_hd__fill_2
Xclkload26 _5098_/CLK VGND VGND VPWR VPWR clkload26/Y sky130_fd_sc_hd__bufinv_16
Xclkload15 _5177_/CLK VGND VGND VPWR VPWR clkload15/X sky130_fd_sc_hd__clkbuf_8
X_2470_ _5074_/Q _5058_/Q _5042_/Q _5026_/Q _5123_/Q _2671_/S1 VGND VGND VPWR VPWR
+ _2470_/X sky130_fd_sc_hd__mux4_2
X_4140_ _3886_/Y _4112_/A _4360_/B VGND VGND VPWR VPWR _4140_/Y sky130_fd_sc_hd__o21ai_2
X_4071_ _4155_/A _4071_/B VGND VGND VPWR VPWR _4088_/C sky130_fd_sc_hd__nor2_2
XTAP_TAPCELL_ROW_79_954 VGND VPWR sky130_fd_sc_hd__tapvpwrvgnd_1
XFILLER_36_300 VGND VGND VPWR VPWR sky130_fd_sc_hd__decap_3
X_3022_ _2944_/X _3006_/B _3006_/Y _4946_/Q VGND VGND VPWR VPWR _4946_/D sky130_fd_sc_hd__a22o_2
XFILLER_76_480 VGND VGND VPWR VPWR sky130_fd_sc_hd__decap_3
XFILLER_48_182 VGND VGND VPWR VPWR sky130_fd_sc_hd__decap_3
XFILLER_91_461 VGND VGND VPWR VPWR sky130_fd_sc_hd__fill_1
X_4973_ _5119_/CLK _4973_/D VGND VGND VPWR VPWR _4973_/Q sky130_fd_sc_hd__dfxtp_2
XTAP_TAPCELL_ROW_34_523 VGND VPWR sky130_fd_sc_hd__tapvpwrvgnd_1
XFILLER_51_369 VGND VGND VPWR VPWR sky130_fd_sc_hd__decap_3
X_3924_ _5157_/Q _3924_/B VGND VGND VPWR VPWR _3936_/A sky130_fd_sc_hd__nor2_2
Xclkload9 clkload9/A VGND VGND VPWR VPWR clkload9/X sky130_fd_sc_hd__clkbuf_4
X_3855_ _4642_/A _4200_/B VGND VGND VPWR VPWR _4155_/A sky130_fd_sc_hd__or2_2
X_3786_ _4953_/Q _4937_/Q _4921_/Q _4905_/Q _5127_/Q _3834_/S1 VGND VGND VPWR VPWR
+ _3786_/X sky130_fd_sc_hd__mux4_2
X_2806_ _2851_/A _3341_/B VGND VGND VPWR VPWR _2806_/X sky130_fd_sc_hd__and2_2
X_2737_ _2735_/X _2736_/X _5133_/Q VGND VGND VPWR VPWR _2737_/X sky130_fd_sc_hd__mux2_1
X_2668_ _4893_/Q _4877_/Q _5101_/Q _5085_/Q _5123_/Q _2671_/S1 VGND VGND VPWR VPWR
+ _2668_/X sky130_fd_sc_hd__mux4_2
X_4407_ _5153_/Q _5152_/Q VGND VGND VPWR VPWR _4407_/X sky130_fd_sc_hd__xor2_2
X_2599_ _5107_/Q _4995_/Q _4979_/Q _4963_/Q _2658_/S0 _2671_/S1 VGND VGND VPWR VPWR
+ _2599_/X sky130_fd_sc_hd__mux4_2
XFILLER_59_414 VGND VGND VPWR VPWR sky130_fd_sc_hd__decap_3
XFILLER_59_436 VGND VGND VPWR VPWR sky130_fd_sc_hd__fill_2
X_4338_ _3681_/B _3947_/X _4313_/D _4224_/A VGND VGND VPWR VPWR _4338_/X sky130_fd_sc_hd__a31o_2
XTAP_TAPCELL_ROW_6_259 VGND VPWR sky130_fd_sc_hd__tapvpwrvgnd_1
XFILLER_86_222 VGND VGND VPWR VPWR sky130_fd_sc_hd__fill_2
XFILLER_86_200 VGND VGND VPWR VPWR sky130_fd_sc_hd__decap_3
XFILLER_59_458 VGND VGND VPWR VPWR sky130_fd_sc_hd__decap_3
X_4269_ _4255_/A _4066_/B _4071_/B _4200_/Y VGND VGND VPWR VPWR _4269_/X sky130_fd_sc_hd__o22a_2
XFILLER_86_244 VGND VGND VPWR VPWR sky130_fd_sc_hd__decap_3
XFILLER_46_108 VGND VGND VPWR VPWR sky130_fd_sc_hd__decap_3
XFILLER_74_417 VGND VGND VPWR VPWR sky130_fd_sc_hd__decap_3
XFILLER_75_39 VGND VGND VPWR VPWR sky130_fd_sc_hd__fill_2
XFILLER_86_288 VGND VGND VPWR VPWR sky130_fd_sc_hd__decap_3
XFILLER_42_303 VGND VGND VPWR VPWR sky130_fd_sc_hd__decap_3
XFILLER_54_141 VGND VGND VPWR VPWR sky130_fd_sc_hd__decap_3
XFILLER_82_483 VGND VGND VPWR VPWR sky130_fd_sc_hd__decap_3
XFILLER_24_32 VGND VGND VPWR VPWR sky130_fd_sc_hd__decap_3
XFILLER_10_200 VGND VGND VPWR VPWR sky130_fd_sc_hd__decap_3
XFILLER_10_288 VGND VGND VPWR VPWR sky130_fd_sc_hd__decap_3
XFILLER_6_248 VGND VGND VPWR VPWR sky130_fd_sc_hd__decap_3
XFILLER_6_259 VGND VGND VPWR VPWR sky130_fd_sc_hd__decap_3
XFILLER_40_64 VGND VGND VPWR VPWR sky130_fd_sc_hd__decap_3
XFILLER_40_97 VGND VGND VPWR VPWR sky130_fd_sc_hd__fill_2
XFILLER_49_62 VGND VGND VPWR VPWR sky130_fd_sc_hd__decap_3
XFILLER_1_36 VGND VGND VPWR VPWR sky130_fd_sc_hd__fill_1
XFILLER_65_417 VGND VGND VPWR VPWR sky130_fd_sc_hd__decap_3
XTAP_TAPCELL_ROW_76_924 VGND VPWR sky130_fd_sc_hd__tapvpwrvgnd_1
XFILLER_77_299 VGND VGND VPWR VPWR sky130_fd_sc_hd__decap_3
XFILLER_58_480 VGND VGND VPWR VPWR sky130_fd_sc_hd__decap_3
XFILLER_65_50 VGND VGND VPWR VPWR sky130_fd_sc_hd__decap_3
XTAP_TAPCELL_ROW_86_1020 VGND VPWR sky130_fd_sc_hd__tapvpwrvgnd_1
XTAP_TAPCELL_ROW_48_659 VGND VPWR sky130_fd_sc_hd__tapvpwrvgnd_1
XFILLER_33_303 VGND VGND VPWR VPWR sky130_fd_sc_hd__decap_3
XFILLER_45_152 VGND VGND VPWR VPWR sky130_fd_sc_hd__decap_3
XFILLER_80_409 VGND VGND VPWR VPWR sky130_fd_sc_hd__decap_3
XFILLER_18_399 VGND VGND VPWR VPWR sky130_fd_sc_hd__decap_3
XFILLER_33_358 VGND VGND VPWR VPWR sky130_fd_sc_hd__decap_3
XFILLER_60_188 VGND VGND VPWR VPWR sky130_fd_sc_hd__fill_1
XFILLER_81_60 VGND VGND VPWR VPWR sky130_fd_sc_hd__decap_3
X_3640_ _4063_/A _4706_/A _3640_/C VGND VGND VPWR VPWR _3640_/X sky130_fd_sc_hd__and3b_2
X_3571_ _5203_/Q _4800_/B _3585_/A _3570_/Y VGND VGND VPWR VPWR _3572_/B sky130_fd_sc_hd__o2bb2a_2
X_2522_ _5114_/Q _5002_/Q _4986_/Q _4970_/Q _2658_/S0 _2671_/S1 VGND VGND VPWR VPWR
+ _2522_/X sky130_fd_sc_hd__mux4_2
XFILLER_5_270 VGND VGND VPWR VPWR sky130_fd_sc_hd__decap_3
XFILLER_5_281 VGND VGND VPWR VPWR sky130_fd_sc_hd__decap_3
X_5241_ _5241_/CLK _5241_/D VGND VGND VPWR VPWR _5241_/Q sky130_fd_sc_hd__dfxtp_2
X_2453_ _5176_/Q _3995_/B VGND VGND VPWR VPWR _4546_/A sky130_fd_sc_hd__or2_2
X_5172_ clkload5/A _5172_/D VGND VGND VPWR VPWR _5172_/Q sky130_fd_sc_hd__dfxtp_2
X_4123_ _4466_/A _4466_/B _4523_/S VGND VGND VPWR VPWR _4124_/B sky130_fd_sc_hd__mux2_1
XFILLER_68_277 VGND VGND VPWR VPWR sky130_fd_sc_hd__decap_3
X_4054_ _4132_/A _4033_/X _4036_/X _4172_/A _4053_/X VGND VGND VPWR VPWR _4054_/Y
+ sky130_fd_sc_hd__a221oi_2
Xinput2 INSTR_STREAM[10] VGND VGND VPWR VPWR input2/X sky130_fd_sc_hd__clkdlybuf4s25_1
XTAP_TAPCELL_ROW_3_229 VGND VPWR sky130_fd_sc_hd__tapvpwrvgnd_1
XFILLER_83_203 VGND VGND VPWR VPWR sky130_fd_sc_hd__decap_3
X_3005_ _3135_/A _3023_/B VGND VGND VPWR VPWR _3005_/Y sky130_fd_sc_hd__nor2_2
XFILLER_83_247 VGND VGND VPWR VPWR sky130_fd_sc_hd__decap_3
XFILLER_83_225 VGND VGND VPWR VPWR sky130_fd_sc_hd__decap_3
XFILLER_64_483 VGND VGND VPWR VPWR sky130_fd_sc_hd__decap_3
XTAP_TAPCELL_ROW_19_383 VGND VPWR sky130_fd_sc_hd__tapvpwrvgnd_1
XFILLER_51_133 VGND VGND VPWR VPWR sky130_fd_sc_hd__decap_3
XFILLER_91_291 VGND VGND VPWR VPWR sky130_fd_sc_hd__decap_3
X_4956_ _5116_/CLK _4956_/D VGND VGND VPWR VPWR _4956_/Q sky130_fd_sc_hd__dfxtp_2
X_4887_ _5111_/CLK _4887_/D VGND VGND VPWR VPWR _4887_/Q sky130_fd_sc_hd__dfxtp_2
X_3907_ _4285_/B _4278_/A _3906_/Y _3727_/X _3883_/Y VGND VGND VPWR VPWR _3907_/X
+ sky130_fd_sc_hd__a221o_2
Xclkbuf_leaf_37_CLK clkload1/A VGND VGND VPWR VPWR _5007_/CLK sky130_fd_sc_hd__clkbuf_8
X_3838_ _4466_/B _3886_/B VGND VGND VPWR VPWR _3839_/B sky130_fd_sc_hd__and2_2
X_3769_ _4898_/Q _4882_/Q _5106_/Q _5090_/Q _5127_/Q _5128_/Q VGND VGND VPWR VPWR
+ _3770_/B sky130_fd_sc_hd__mux4_2
XFILLER_10_78 VGND VGND VPWR VPWR sky130_fd_sc_hd__decap_3
XFILLER_87_520 VGND VGND VPWR VPWR sky130_fd_sc_hd__decap_3
XFILLER_86_49 VGND VGND VPWR VPWR sky130_fd_sc_hd__decap_3
XFILLER_15_314 VGND VGND VPWR VPWR sky130_fd_sc_hd__decap_3
XFILLER_27_163 VGND VGND VPWR VPWR sky130_fd_sc_hd__decap_3
XFILLER_42_100 VGND VGND VPWR VPWR sky130_fd_sc_hd__decap_3
XFILLER_55_494 VGND VGND VPWR VPWR sky130_fd_sc_hd__fill_1
XTAP_TAPCELL_ROW_45_629 VGND VPWR sky130_fd_sc_hd__tapvpwrvgnd_1
XFILLER_82_280 VGND VGND VPWR VPWR sky130_fd_sc_hd__decap_3
XFILLER_70_442 VGND VGND VPWR VPWR sky130_fd_sc_hd__decap_3
XFILLER_70_475 VGND VGND VPWR VPWR sky130_fd_sc_hd__fill_1
XTAP_TAPCELL_ROW_81_971 VGND VPWR sky130_fd_sc_hd__tapvpwrvgnd_1
XFILLER_51_41 VGND VGND VPWR VPWR sky130_fd_sc_hd__decap_3
XFILLER_51_63 VGND VGND VPWR VPWR sky130_fd_sc_hd__decap_3
Xclkbuf_leaf_28_CLK clkload2/A VGND VGND VPWR VPWR _5116_/CLK sky130_fd_sc_hd__clkbuf_8
XFILLER_7_502 VGND VGND VPWR VPWR sky130_fd_sc_hd__fill_2
XPHY_EDGE_ROW_2_Left_96 VGND VGND VPWR VPWR sky130_fd_sc_hd__decap_3
XFILLER_78_520 VGND VGND VPWR VPWR sky130_fd_sc_hd__decap_3
XFILLER_93_523 VGND VGND VPWR VPWR sky130_fd_sc_hd__decap_3
XFILLER_93_501 VGND VGND VPWR VPWR sky130_fd_sc_hd__decap_3
XFILLER_38_439 VGND VGND VPWR VPWR sky130_fd_sc_hd__decap_3
XFILLER_65_225 VGND VGND VPWR VPWR sky130_fd_sc_hd__decap_3
XFILLER_93_545 VGND VGND VPWR VPWR sky130_fd_sc_hd__decap_3
XFILLER_76_82 VGND VGND VPWR VPWR sky130_fd_sc_hd__fill_2
XFILLER_18_141 VGND VGND VPWR VPWR sky130_fd_sc_hd__fill_1
XFILLER_46_450 VGND VGND VPWR VPWR sky130_fd_sc_hd__decap_3
XFILLER_65_269 VGND VGND VPWR VPWR sky130_fd_sc_hd__decap_3
XFILLER_18_163 VGND VGND VPWR VPWR sky130_fd_sc_hd__decap_3
XFILLER_46_483 VGND VGND VPWR VPWR sky130_fd_sc_hd__decap_3
XFILLER_61_420 VGND VGND VPWR VPWR sky130_fd_sc_hd__decap_3
XFILLER_61_431 VGND VGND VPWR VPWR sky130_fd_sc_hd__decap_3
X_4810_ _4360_/A _4360_/B _4809_/X VGND VGND VPWR VPWR _4810_/Y sky130_fd_sc_hd__a21oi_2
XFILLER_61_464 VGND VGND VPWR VPWR sky130_fd_sc_hd__decap_3
XFILLER_61_497 VGND VGND VPWR VPWR sky130_fd_sc_hd__decap_3
XTAP_TAPCELL_ROW_16_353 VGND VPWR sky130_fd_sc_hd__tapvpwrvgnd_1
XFILLER_14_380 VGND VGND VPWR VPWR sky130_fd_sc_hd__decap_3
X_4741_ _5232_/Q _4800_/B VGND VGND VPWR VPWR _4741_/Y sky130_fd_sc_hd__nand2_2
X_4672_ _4686_/S _4672_/B VGND VGND VPWR VPWR _4672_/X sky130_fd_sc_hd__or2_2
Xclkbuf_leaf_19_CLK clkload0/A VGND VGND VPWR VPWR _5221_/CLK sky130_fd_sc_hd__clkbuf_8
X_3623_ _4947_/Q _4931_/Q _4915_/Q _4899_/Q _3834_/S0 _3834_/S1 VGND VGND VPWR VPWR
+ _3623_/X sky130_fd_sc_hd__mux4_2
X_3554_ _5163_/Q _5144_/Q VGND VGND VPWR VPWR _3555_/C sky130_fd_sc_hd__and2_2
X_3485_ _5154_/Q _5135_/Q VGND VGND VPWR VPWR _3488_/B sky130_fd_sc_hd__nand2_2
X_2505_ _2667_/A _2505_/B VGND VGND VPWR VPWR _2505_/X sky130_fd_sc_hd__or2_2
X_5224_ _5241_/CLK _5224_/D VGND VGND VPWR VPWR _5224_/Q sky130_fd_sc_hd__dfxtp_2
X_2436_ _5133_/Q VGND VGND VPWR VPWR _2831_/S sky130_fd_sc_hd__inv_2
X_5155_ clkload4/A _5155_/D VGND VGND VPWR VPWR _5155_/Q sky130_fd_sc_hd__dfxtp_2
XPHY_EDGE_ROW_16_Left_110 VGND VGND VPWR VPWR sky130_fd_sc_hd__decap_3
XFILLER_84_512 VGND VGND VPWR VPWR sky130_fd_sc_hd__decap_3
XFILLER_84_501 VGND VGND VPWR VPWR sky130_fd_sc_hd__decap_3
XFILLER_56_214 VGND VGND VPWR VPWR sky130_fd_sc_hd__decap_3
X_4106_ _4107_/A _4107_/B VGND VGND VPWR VPWR _4179_/B sky130_fd_sc_hd__nor2_2
X_5086_ _5114_/CLK _5086_/D VGND VGND VPWR VPWR _5086_/Q sky130_fd_sc_hd__dfxtp_2
XFILLER_84_545 VGND VGND VPWR VPWR sky130_fd_sc_hd__decap_3
XFILLER_71_206 VGND VGND VPWR VPWR sky130_fd_sc_hd__decap_3
X_4037_ _4115_/A _4037_/B VGND VGND VPWR VPWR _4053_/A sky130_fd_sc_hd__nor2_2
XFILLER_37_483 VGND VGND VPWR VPWR sky130_fd_sc_hd__decap_3
XFILLER_37_494 VGND VGND VPWR VPWR sky130_fd_sc_hd__fill_2
XFILLER_72_29 VGND VGND VPWR VPWR sky130_fd_sc_hd__decap_3
XFILLER_12_306 VGND VGND VPWR VPWR sky130_fd_sc_hd__fill_2
XFILLER_12_317 VGND VGND VPWR VPWR sky130_fd_sc_hd__decap_3
XFILLER_52_475 VGND VGND VPWR VPWR sky130_fd_sc_hd__fill_1
XFILLER_52_486 VGND VGND VPWR VPWR sky130_fd_sc_hd__decap_3
X_4939_ _5103_/CLK _4939_/D VGND VGND VPWR VPWR _4939_/Q sky130_fd_sc_hd__dfxtp_2
XTAP_TAPCELL_ROW_50_676 VGND VPWR sky130_fd_sc_hd__tapvpwrvgnd_1
XFILLER_20_383 VGND VGND VPWR VPWR sky130_fd_sc_hd__decap_3
XFILLER_21_66 VGND VGND VPWR VPWR sky130_fd_sc_hd__decap_3
XFILLER_79_328 VGND VGND VPWR VPWR sky130_fd_sc_hd__decap_3
XFILLER_87_361 VGND VGND VPWR VPWR sky130_fd_sc_hd__decap_3
XFILLER_46_41 VGND VGND VPWR VPWR sky130_fd_sc_hd__decap_3
XFILLER_47_269 VGND VGND VPWR VPWR sky130_fd_sc_hd__decap_3
XTAP_TAPCELL_ROW_58_754 VGND VPWR sky130_fd_sc_hd__tapvpwrvgnd_1
XFILLER_46_63 VGND VGND VPWR VPWR sky130_fd_sc_hd__fill_1
XFILLER_46_85 VGND VGND VPWR VPWR sky130_fd_sc_hd__decap_3
XFILLER_62_239 VGND VGND VPWR VPWR sky130_fd_sc_hd__decap_3
XFILLER_43_442 VGND VGND VPWR VPWR sky130_fd_sc_hd__decap_3
XFILLER_43_464 VGND VGND VPWR VPWR sky130_fd_sc_hd__decap_3
XFILLER_62_62 VGND VGND VPWR VPWR sky130_fd_sc_hd__decap_3
XTAP_TAPCELL_ROW_13_323 VGND VPWR sky130_fd_sc_hd__tapvpwrvgnd_1
XFILLER_30_169 VGND VGND VPWR VPWR sky130_fd_sc_hd__decap_3
XFILLER_87_9 VGND VGND VPWR VPWR sky130_fd_sc_hd__decap_3
XFILLER_7_24 VGND VGND VPWR VPWR sky130_fd_sc_hd__decap_3
XFILLER_7_57 VGND VGND VPWR VPWR sky130_fd_sc_hd__decap_3
XFILLER_7_365 VGND VGND VPWR VPWR sky130_fd_sc_hd__decap_3
XFILLER_7_387 VGND VGND VPWR VPWR sky130_fd_sc_hd__decap_3
X_3270_ _3270_/A _3270_/B VGND VGND VPWR VPWR _3271_/A sky130_fd_sc_hd__nor2_2
XFILLER_38_203 VGND VGND VPWR VPWR sky130_fd_sc_hd__decap_3
XFILLER_16_3 VGND VGND VPWR VPWR sky130_fd_sc_hd__fill_2
XFILLER_38_214 VGND VGND VPWR VPWR sky130_fd_sc_hd__decap_3
XFILLER_38_236 VGND VGND VPWR VPWR sky130_fd_sc_hd__decap_3
XFILLER_66_545 VGND VGND VPWR VPWR sky130_fd_sc_hd__decap_3
Xclkbuf_leaf_8_CLK clkbuf_leaf_8_CLK/A VGND VGND VPWR VPWR clkload8/A sky130_fd_sc_hd__clkbuf_8
XFILLER_53_228 VGND VGND VPWR VPWR sky130_fd_sc_hd__decap_3
XFILLER_93_386 VGND VGND VPWR VPWR sky130_fd_sc_hd__decap_3
XFILLER_81_548 VGND VGND VPWR VPWR sky130_fd_sc_hd__decap_3
XFILLER_34_442 VGND VGND VPWR VPWR sky130_fd_sc_hd__decap_3
XFILLER_34_475 VGND VGND VPWR VPWR sky130_fd_sc_hd__fill_1
XFILLER_61_261 VGND VGND VPWR VPWR sky130_fd_sc_hd__decap_3
XFILLER_21_169 VGND VGND VPWR VPWR sky130_fd_sc_hd__decap_3
X_4724_ _4723_/Y _4692_/Y _4802_/A VGND VGND VPWR VPWR _4773_/B sky130_fd_sc_hd__mux2_1
X_2985_ _5186_/Q _3134_/A _5187_/Q VGND VGND VPWR VPWR _3189_/B sky130_fd_sc_hd__or3b_2
X_4655_ _4686_/S _4655_/B VGND VGND VPWR VPWR _4655_/Y sky130_fd_sc_hd__nand2_2
X_4586_ _4585_/X _4706_/A _4802_/A VGND VGND VPWR VPWR _4586_/X sky130_fd_sc_hd__mux2_1
X_3606_ _3604_/X _3605_/X _5129_/Q VGND VGND VPWR VPWR _3606_/X sky130_fd_sc_hd__mux2_1
X_3537_ _3537_/A _3537_/B VGND VGND VPWR VPWR _3541_/A sky130_fd_sc_hd__or2_2
XFILLER_88_114 VGND VGND VPWR VPWR sky130_fd_sc_hd__decap_3
X_3468_ _5187_/Q _4168_/A _3467_/X _3448_/B VGND VGND VPWR VPWR _5187_/D sky130_fd_sc_hd__o211a_2
XFILLER_69_361 VGND VGND VPWR VPWR sky130_fd_sc_hd__decap_3
X_5207_ _5241_/CLK _5207_/D VGND VGND VPWR VPWR _5207_/Q sky130_fd_sc_hd__dfxtp_2
X_3399_ _3387_/A _3389_/Y _3397_/X _2425_/Y VGND VGND VPWR VPWR _3399_/X sky130_fd_sc_hd__a31o_2
X_2419_ _5229_/Q VGND VGND VPWR VPWR _2419_/Y sky130_fd_sc_hd__inv_2
XFILLER_76_309 VGND VGND VPWR VPWR sky130_fd_sc_hd__decap_3
XFILLER_29_214 VGND VGND VPWR VPWR sky130_fd_sc_hd__fill_2
XFILLER_57_523 VGND VGND VPWR VPWR sky130_fd_sc_hd__fill_2
X_5138_ _5177_/CLK _5138_/D VGND VGND VPWR VPWR _5138_/Q sky130_fd_sc_hd__dfxtp_2
XFILLER_29_258 VGND VGND VPWR VPWR sky130_fd_sc_hd__decap_3
XFILLER_72_504 VGND VGND VPWR VPWR sky130_fd_sc_hd__decap_3
X_5069_ _5085_/CLK _5069_/D VGND VGND VPWR VPWR _5069_/Q sky130_fd_sc_hd__dfxtp_2
XTAP_TAPCELL_ROW_55_724 VGND VPWR sky130_fd_sc_hd__tapvpwrvgnd_1
XFILLER_16_44 VGND VGND VPWR VPWR sky130_fd_sc_hd__fill_2
XFILLER_72_548 VGND VGND VPWR VPWR sky130_fd_sc_hd__decap_3
XTAP_TAPCELL_ROW_27_459 VGND VPWR sky130_fd_sc_hd__tapvpwrvgnd_1
XFILLER_40_401 VGND VGND VPWR VPWR sky130_fd_sc_hd__decap_3
XFILLER_12_103 VGND VGND VPWR VPWR sky130_fd_sc_hd__fill_2
XFILLER_16_88 VGND VGND VPWR VPWR sky130_fd_sc_hd__decap_3
XFILLER_40_445 VGND VGND VPWR VPWR sky130_fd_sc_hd__decap_3
XFILLER_52_283 VGND VGND VPWR VPWR sky130_fd_sc_hd__decap_3
XFILLER_52_294 VGND VGND VPWR VPWR sky130_fd_sc_hd__fill_1
XFILLER_40_489 VGND VGND VPWR VPWR sky130_fd_sc_hd__decap_3
XFILLER_4_324 VGND VGND VPWR VPWR sky130_fd_sc_hd__decap_3
XFILLER_79_169 VGND VGND VPWR VPWR sky130_fd_sc_hd__fill_1
XFILLER_75_320 VGND VGND VPWR VPWR sky130_fd_sc_hd__decap_3
XFILLER_75_364 VGND VGND VPWR VPWR sky130_fd_sc_hd__decap_3
XFILLER_35_206 VGND VGND VPWR VPWR sky130_fd_sc_hd__fill_1
XFILLER_35_228 VGND VGND VPWR VPWR sky130_fd_sc_hd__decap_3
XFILLER_63_526 VGND VGND VPWR VPWR sky130_fd_sc_hd__decap_3
XFILLER_90_323 VGND VGND VPWR VPWR sky130_fd_sc_hd__decap_3
XFILLER_16_442 VGND VGND VPWR VPWR sky130_fd_sc_hd__decap_3
XFILLER_43_261 VGND VGND VPWR VPWR sky130_fd_sc_hd__fill_2
XFILLER_73_83 VGND VGND VPWR VPWR sky130_fd_sc_hd__decap_3
XFILLER_90_378 VGND VGND VPWR VPWR sky130_fd_sc_hd__decap_3
XFILLER_31_478 VGND VGND VPWR VPWR sky130_fd_sc_hd__decap_3
XFILLER_85_6 VGND VGND VPWR VPWR sky130_fd_sc_hd__decap_3
X_2770_ _2851_/A _3302_/B VGND VGND VPWR VPWR _2770_/X sky130_fd_sc_hd__and2_2
XFILLER_11_180 VGND VGND VPWR VPWR sky130_fd_sc_hd__decap_3
XFILLER_7_140 VGND VGND VPWR VPWR sky130_fd_sc_hd__decap_3
X_4440_ _4497_/B _4498_/B VGND VGND VPWR VPWR _4441_/B sky130_fd_sc_hd__and2_2
X_4371_ _4371_/A _4371_/B VGND VGND VPWR VPWR _4371_/Y sky130_fd_sc_hd__nor2_2
X_3322_ _3313_/B _3315_/B _3313_/A VGND VGND VPWR VPWR _3324_/B sky130_fd_sc_hd__a21bo_2
XFILLER_58_309 VGND VGND VPWR VPWR sky130_fd_sc_hd__decap_3
X_3253_ _5175_/Q _3227_/X _3252_/X VGND VGND VPWR VPWR _4866_/B sky130_fd_sc_hd__a21oi_2
X_3184_ _2932_/X _3185_/A2 _3185_/B1 _5086_/Q VGND VGND VPWR VPWR _5086_/D sky130_fd_sc_hd__a22o_2
XFILLER_66_353 VGND VGND VPWR VPWR sky130_fd_sc_hd__decap_3
XFILLER_81_323 VGND VGND VPWR VPWR sky130_fd_sc_hd__decap_3
XFILLER_34_250 VGND VGND VPWR VPWR sky130_fd_sc_hd__fill_2
XFILLER_34_261 VGND VGND VPWR VPWR sky130_fd_sc_hd__decap_3
XFILLER_81_367 VGND VGND VPWR VPWR sky130_fd_sc_hd__decap_3
XFILLER_22_412 VGND VGND VPWR VPWR sky130_fd_sc_hd__decap_3
XTAP_TAPCELL_ROW_24_429 VGND VPWR sky130_fd_sc_hd__tapvpwrvgnd_1
X_2968_ _4866_/A _2968_/B VGND VGND VPWR VPWR _2968_/Y sky130_fd_sc_hd__nor2_2
XTAP_TAPCELL_ROW_60_771 VGND VPWR sky130_fd_sc_hd__tapvpwrvgnd_1
X_4707_ _4477_/A _4787_/S _3648_/Y VGND VGND VPWR VPWR _4707_/Y sky130_fd_sc_hd__o21ai_2
X_4638_ _4706_/A _4802_/A VGND VGND VPWR VPWR _4638_/X sky130_fd_sc_hd__or2_2
X_2899_ _5223_/Q _4850_/A _3458_/B _5207_/Q VGND VGND VPWR VPWR _2899_/X sky130_fd_sc_hd__a22o_2
X_4569_ _4569_/A _4569_/B VGND VGND VPWR VPWR _4572_/A sky130_fd_sc_hd__xnor2_2
XFILLER_78_39 VGND VGND VPWR VPWR sky130_fd_sc_hd__decap_3
XFILLER_89_445 VGND VGND VPWR VPWR sky130_fd_sc_hd__decap_3
XFILLER_17_228 VGND VGND VPWR VPWR sky130_fd_sc_hd__fill_2
XFILLER_27_32 VGND VGND VPWR VPWR sky130_fd_sc_hd__decap_3
XFILLER_45_526 VGND VGND VPWR VPWR sky130_fd_sc_hd__decap_3
XFILLER_57_364 VGND VGND VPWR VPWR sky130_fd_sc_hd__decap_3
XFILLER_72_312 VGND VGND VPWR VPWR sky130_fd_sc_hd__decap_3
XFILLER_84_172 VGND VGND VPWR VPWR sky130_fd_sc_hd__decap_3
XFILLER_60_518 VGND VGND VPWR VPWR sky130_fd_sc_hd__fill_2
XFILLER_60_529 VGND VGND VPWR VPWR sky130_fd_sc_hd__decap_3
XFILLER_25_272 VGND VGND VPWR VPWR sky130_fd_sc_hd__decap_3
XFILLER_40_253 VGND VGND VPWR VPWR sky130_fd_sc_hd__fill_2
XFILLER_43_42 VGND VGND VPWR VPWR sky130_fd_sc_hd__decap_3
XFILLER_13_489 VGND VGND VPWR VPWR sky130_fd_sc_hd__decap_3
XFILLER_40_275 VGND VGND VPWR VPWR sky130_fd_sc_hd__decap_3
XFILLER_4_25 VGND VGND VPWR VPWR sky130_fd_sc_hd__decap_3
XFILLER_0_371 VGND VGND VPWR VPWR sky130_fd_sc_hd__decap_3
XFILLER_0_393 VGND VGND VPWR VPWR sky130_fd_sc_hd__fill_2
XFILLER_75_150 VGND VGND VPWR VPWR sky130_fd_sc_hd__decap_3
XFILLER_75_172 VGND VGND VPWR VPWR sky130_fd_sc_hd__decap_3
XTAP_TAPCELL_ROW_89_1051 VGND VPWR sky130_fd_sc_hd__tapvpwrvgnd_1
XFILLER_82_109 VGND VGND VPWR VPWR sky130_fd_sc_hd__decap_3
XFILLER_63_323 VGND VGND VPWR VPWR sky130_fd_sc_hd__fill_1
XFILLER_63_389 VGND VGND VPWR VPWR sky130_fd_sc_hd__decap_3
X_3940_ _3940_/A _3940_/B VGND VGND VPWR VPWR _3940_/Y sky130_fd_sc_hd__nand2_2
XFILLER_31_231 VGND VGND VPWR VPWR sky130_fd_sc_hd__decap_3
X_3871_ _5179_/Q _5177_/Q VGND VGND VPWR VPWR _4003_/B sky130_fd_sc_hd__nand2_2
X_2822_ _2831_/S _2821_/X _2437_/Y VGND VGND VPWR VPWR _2822_/X sky130_fd_sc_hd__o21a_2
XFILLER_83_3 VGND VGND VPWR VPWR sky130_fd_sc_hd__fill_1
X_2753_ _4888_/Q _4872_/Q _5096_/Q _5080_/Q _2812_/S0 _2848_/S1 VGND VGND VPWR VPWR
+ _2754_/B sky130_fd_sc_hd__mux4_2
X_2684_ _2684_/A _2882_/A VGND VGND VPWR VPWR _2884_/A sky130_fd_sc_hd__nand2_2
X_4423_ _4464_/B _4523_/S _4201_/X VGND VGND VPWR VPWR _4423_/Y sky130_fd_sc_hd__o21ai_2
X_4354_ _5220_/Q _4700_/S VGND VGND VPWR VPWR _4354_/X sky130_fd_sc_hd__or2_2
X_3305_ _3291_/A _3302_/X _3303_/X _2425_/Y VGND VGND VPWR VPWR _3306_/B sky130_fd_sc_hd__a31o_2
XFILLER_86_415 VGND VGND VPWR VPWR sky130_fd_sc_hd__decap_3
XFILLER_58_139 VGND VGND VPWR VPWR sky130_fd_sc_hd__fill_1
X_4285_ _4717_/S _4285_/B _4285_/C _4285_/D VGND VGND VPWR VPWR _4285_/X sky130_fd_sc_hd__or4_2
XFILLER_86_448 VGND VGND VPWR VPWR sky130_fd_sc_hd__decap_3
XFILLER_39_331 VGND VGND VPWR VPWR sky130_fd_sc_hd__decap_3
X_3236_ _5171_/Q _3252_/C _3228_/Y _3235_/X VGND VGND VPWR VPWR _5126_/D sky130_fd_sc_hd__o22a_2
XFILLER_54_312 VGND VGND VPWR VPWR sky130_fd_sc_hd__decap_3
XFILLER_66_150 VGND VGND VPWR VPWR sky130_fd_sc_hd__fill_1
X_3167_ _2935_/X _3170_/A2 _3170_/B1 _5071_/Q VGND VGND VPWR VPWR _5071_/D sky130_fd_sc_hd__a22o_2
XFILLER_66_194 VGND VGND VPWR VPWR sky130_fd_sc_hd__fill_2
X_3098_ _3171_/B _3134_/B VGND VGND VPWR VPWR _3098_/Y sky130_fd_sc_hd__nor2_2
XFILLER_54_356 VGND VGND VPWR VPWR sky130_fd_sc_hd__decap_3
XTAP_TAPCELL_ROW_37_554 VGND VPWR sky130_fd_sc_hd__tapvpwrvgnd_1
XFILLER_81_153 VGND VGND VPWR VPWR sky130_fd_sc_hd__decap_3
XFILLER_81_197 VGND VGND VPWR VPWR sky130_fd_sc_hd__decap_3
XFILLER_80_29 VGND VGND VPWR VPWR sky130_fd_sc_hd__decap_3
XFILLER_80_18 VGND VGND VPWR VPWR sky130_fd_sc_hd__decap_3
XFILLER_22_253 VGND VGND VPWR VPWR sky130_fd_sc_hd__decap_3
XFILLER_1_113 VGND VGND VPWR VPWR sky130_fd_sc_hd__fill_2
XPHY_EDGE_ROW_8_Left_102 VGND VGND VPWR VPWR sky130_fd_sc_hd__decap_3
XFILLER_89_231 VGND VGND VPWR VPWR sky130_fd_sc_hd__decap_3
XFILLER_1_135 VGND VGND VPWR VPWR sky130_fd_sc_hd__decap_3
XFILLER_89_264 VGND VGND VPWR VPWR sky130_fd_sc_hd__decap_3
XFILLER_49_139 VGND VGND VPWR VPWR sky130_fd_sc_hd__fill_1
XFILLER_92_407 VGND VGND VPWR VPWR sky130_fd_sc_hd__decap_3
XFILLER_18_504 VGND VGND VPWR VPWR sky130_fd_sc_hd__fill_2
XFILLER_64_109 VGND VGND VPWR VPWR sky130_fd_sc_hd__decap_3
XFILLER_45_334 VGND VGND VPWR VPWR sky130_fd_sc_hd__fill_2
XFILLER_72_120 VGND VGND VPWR VPWR sky130_fd_sc_hd__decap_3
XFILLER_45_356 VGND VGND VPWR VPWR sky130_fd_sc_hd__decap_3
XFILLER_60_304 VGND VGND VPWR VPWR sky130_fd_sc_hd__decap_3
XFILLER_72_153 VGND VGND VPWR VPWR sky130_fd_sc_hd__decap_3
XFILLER_54_63 VGND VGND VPWR VPWR sky130_fd_sc_hd__decap_3
XFILLER_60_315 VGND VGND VPWR VPWR sky130_fd_sc_hd__decap_3
XTAP_TAPCELL_ROW_0_190 VGND VPWR sky130_fd_sc_hd__tapvpwrvgnd_1
XFILLER_13_231 VGND VGND VPWR VPWR sky130_fd_sc_hd__decap_3
XFILLER_41_551 VGND VGND VPWR VPWR sky130_fd_sc_hd__fill_2
XFILLER_60_348 VGND VGND VPWR VPWR sky130_fd_sc_hd__decap_3
XTAP_TAPCELL_ROW_71_877 VGND VPWR sky130_fd_sc_hd__tapvpwrvgnd_1
XFILLER_70_51 VGND VGND VPWR VPWR sky130_fd_sc_hd__fill_1
XFILLER_70_73 VGND VGND VPWR VPWR sky130_fd_sc_hd__fill_1
Xclkload16 _5262_/CLK VGND VGND VPWR VPWR clkload16/X sky130_fd_sc_hd__clkbuf_8
XFILLER_9_279 VGND VGND VPWR VPWR sky130_fd_sc_hd__fill_1
Xclkload27 _5007_/CLK VGND VGND VPWR VPWR clkload27/X sky130_fd_sc_hd__clkbuf_4
XFILLER_5_496 VGND VGND VPWR VPWR sky130_fd_sc_hd__decap_3
XFILLER_79_71 VGND VGND VPWR VPWR sky130_fd_sc_hd__fill_2
XFILLER_68_404 VGND VGND VPWR VPWR sky130_fd_sc_hd__decap_3
XFILLER_68_426 VGND VGND VPWR VPWR sky130_fd_sc_hd__decap_3
XFILLER_68_437 VGND VGND VPWR VPWR sky130_fd_sc_hd__decap_3
XFILLER_0_190 VGND VGND VPWR VPWR sky130_fd_sc_hd__decap_3
X_4070_ _4297_/A _4070_/B VGND VGND VPWR VPWR _4071_/B sky130_fd_sc_hd__or2_2
XTAP_TAPCELL_ROW_79_955 VGND VPWR sky130_fd_sc_hd__tapvpwrvgnd_1
XFILLER_48_150 VGND VGND VPWR VPWR sky130_fd_sc_hd__fill_1
X_3021_ _2941_/X _3006_/B _3006_/Y _4945_/Q VGND VGND VPWR VPWR _4945_/D sky130_fd_sc_hd__a22o_2
XFILLER_24_507 VGND VGND VPWR VPWR sky130_fd_sc_hd__decap_3
XFILLER_24_529 VGND VGND VPWR VPWR sky130_fd_sc_hd__decap_3
XFILLER_51_326 VGND VGND VPWR VPWR sky130_fd_sc_hd__decap_3
XFILLER_51_337 VGND VGND VPWR VPWR sky130_fd_sc_hd__fill_1
XFILLER_63_175 VGND VGND VPWR VPWR sky130_fd_sc_hd__decap_3
X_4972_ _5117_/CLK _4972_/D VGND VGND VPWR VPWR _4972_/Q sky130_fd_sc_hd__dfxtp_2
XTAP_TAPCELL_ROW_34_524 VGND VPWR sky130_fd_sc_hd__tapvpwrvgnd_1
XFILLER_32_551 VGND VGND VPWR VPWR sky130_fd_sc_hd__fill_2
X_3923_ _5158_/Q _3923_/B VGND VGND VPWR VPWR _3923_/X sky130_fd_sc_hd__or2_2
X_3854_ _5155_/Q _4397_/A _4404_/S VGND VGND VPWR VPWR _4200_/B sky130_fd_sc_hd__mux2_1
X_2805_ _5134_/Q _2800_/X _2802_/X _2804_/X VGND VGND VPWR VPWR _3341_/B sky130_fd_sc_hd__a22o_2
X_3785_ _5129_/Q _3782_/X _5130_/Q VGND VGND VPWR VPWR _3785_/X sky130_fd_sc_hd__o21a_2
X_2736_ _5062_/Q _5046_/Q _5030_/Q _5014_/Q _2812_/S0 _2848_/S1 VGND VGND VPWR VPWR
+ _2736_/X sky130_fd_sc_hd__mux4_2
X_2667_ _2667_/A _2667_/B VGND VGND VPWR VPWR _2667_/X sky130_fd_sc_hd__or2_2
X_4406_ _4406_/A _4406_/B VGND VGND VPWR VPWR _4406_/Y sky130_fd_sc_hd__nor2_2
XFILLER_5_90 VGND VGND VPWR VPWR sky130_fd_sc_hd__decap_3
X_2598_ _2667_/A _2597_/X _5126_/Q VGND VGND VPWR VPWR _2598_/X sky130_fd_sc_hd__o21a_2
XFILLER_59_426 VGND VGND VPWR VPWR sky130_fd_sc_hd__fill_1
X_4337_ _3947_/X _4313_/D _3681_/B VGND VGND VPWR VPWR _4337_/Y sky130_fd_sc_hd__a21oi_2
XFILLER_75_18 VGND VGND VPWR VPWR sky130_fd_sc_hd__decap_3
X_4268_ _4339_/A _4268_/B VGND VGND VPWR VPWR _4268_/Y sky130_fd_sc_hd__nor2_2
XFILLER_67_470 VGND VGND VPWR VPWR sky130_fd_sc_hd__decap_3
X_3219_ _2929_/X _3221_/A2 _3208_/Y _5117_/Q VGND VGND VPWR VPWR _5117_/D sky130_fd_sc_hd__a22o_2
XFILLER_39_172 VGND VGND VPWR VPWR sky130_fd_sc_hd__decap_3
X_4199_ _4196_/A _3902_/B _4246_/A VGND VGND VPWR VPWR _4199_/Y sky130_fd_sc_hd__a21oi_2
XFILLER_27_367 VGND VGND VPWR VPWR sky130_fd_sc_hd__decap_3
XFILLER_54_131 VGND VGND VPWR VPWR sky130_fd_sc_hd__decap_3
XFILLER_54_153 VGND VGND VPWR VPWR sky130_fd_sc_hd__decap_3
XFILLER_82_440 VGND VGND VPWR VPWR sky130_fd_sc_hd__decap_3
XFILLER_54_186 VGND VGND VPWR VPWR sky130_fd_sc_hd__decap_3
XFILLER_54_197 VGND VGND VPWR VPWR sky130_fd_sc_hd__decap_3
XFILLER_23_551 VGND VGND VPWR VPWR sky130_fd_sc_hd__fill_2
XFILLER_24_22 VGND VGND VPWR VPWR sky130_fd_sc_hd__decap_3
XFILLER_42_348 VGND VGND VPWR VPWR sky130_fd_sc_hd__decap_3
XFILLER_24_44 VGND VGND VPWR VPWR sky130_fd_sc_hd__decap_3
XFILLER_24_66 VGND VGND VPWR VPWR sky130_fd_sc_hd__fill_2
XFILLER_10_212 VGND VGND VPWR VPWR sky130_fd_sc_hd__decap_3
XFILLER_50_381 VGND VGND VPWR VPWR sky130_fd_sc_hd__decap_3
XFILLER_10_245 VGND VGND VPWR VPWR sky130_fd_sc_hd__decap_3
XFILLER_10_256 VGND VGND VPWR VPWR sky130_fd_sc_hd__decap_3
XFILLER_2_455 VGND VGND VPWR VPWR sky130_fd_sc_hd__decap_3
XFILLER_77_223 VGND VGND VPWR VPWR sky130_fd_sc_hd__fill_1
XFILLER_77_256 VGND VGND VPWR VPWR sky130_fd_sc_hd__decap_3
XTAP_TAPCELL_ROW_76_925 VGND VPWR sky130_fd_sc_hd__tapvpwrvgnd_1
XFILLER_18_312 VGND VGND VPWR VPWR sky130_fd_sc_hd__decap_3
XFILLER_45_120 VGND VGND VPWR VPWR sky130_fd_sc_hd__fill_2
XTAP_TAPCELL_ROW_86_1021 VGND VPWR sky130_fd_sc_hd__tapvpwrvgnd_1
XFILLER_18_356 VGND VGND VPWR VPWR sky130_fd_sc_hd__decap_3
XFILLER_45_131 VGND VGND VPWR VPWR sky130_fd_sc_hd__decap_3
XFILLER_92_259 VGND VGND VPWR VPWR sky130_fd_sc_hd__decap_3
XFILLER_33_315 VGND VGND VPWR VPWR sky130_fd_sc_hd__decap_3
XFILLER_33_337 VGND VGND VPWR VPWR sky130_fd_sc_hd__decap_3
XFILLER_45_164 VGND VGND VPWR VPWR sky130_fd_sc_hd__decap_3
XFILLER_45_175 VGND VGND VPWR VPWR sky130_fd_sc_hd__decap_3
XFILLER_65_95 VGND VGND VPWR VPWR sky130_fd_sc_hd__decap_3
XFILLER_73_495 VGND VGND VPWR VPWR sky130_fd_sc_hd__decap_3
XFILLER_41_370 VGND VGND VPWR VPWR sky130_fd_sc_hd__decap_3
XFILLER_81_83 VGND VGND VPWR VPWR sky130_fd_sc_hd__fill_2
X_3570_ _3570_/A _3570_/B VGND VGND VPWR VPWR _3570_/Y sky130_fd_sc_hd__xnor2_2
X_2521_ _4954_/Q _4938_/Q _4922_/Q _4906_/Q _5123_/Q _2671_/S1 VGND VGND VPWR VPWR
+ _2521_/X sky130_fd_sc_hd__mux4_2
X_5240_ _5241_/CLK _5240_/D VGND VGND VPWR VPWR _5240_/Q sky130_fd_sc_hd__dfxtp_2
XFILLER_5_293 VGND VGND VPWR VPWR sky130_fd_sc_hd__decap_3
X_2452_ _5176_/Q _3995_/B VGND VGND VPWR VPWR _2452_/Y sky130_fd_sc_hd__nor2_2
X_5171_ clkload4/A _5171_/D VGND VGND VPWR VPWR _5171_/Q sky130_fd_sc_hd__dfxtp_2
XPHY_EDGE_ROW_18_Right_18 VGND VGND VPWR VPWR sky130_fd_sc_hd__decap_3
X_4122_ _4139_/A _4121_/B _4546_/A VGND VGND VPWR VPWR _4122_/X sky130_fd_sc_hd__a21o_2
XFILLER_28_109 VGND VGND VPWR VPWR sky130_fd_sc_hd__decap_3
XFILLER_56_407 VGND VGND VPWR VPWR sky130_fd_sc_hd__decap_3
X_4053_ _4053_/A _4053_/B _4053_/C _4053_/D VGND VGND VPWR VPWR _4053_/X sky130_fd_sc_hd__or4_2
XFILLER_36_120 VGND VGND VPWR VPWR sky130_fd_sc_hd__decap_3
XFILLER_49_481 VGND VGND VPWR VPWR sky130_fd_sc_hd__fill_2
XFILLER_49_492 VGND VGND VPWR VPWR sky130_fd_sc_hd__fill_2
Xinput3 INSTR_STREAM[11] VGND VGND VPWR VPWR input3/X sky130_fd_sc_hd__clkdlybuf4s25_1
X_3004_ _3134_/A _3004_/B VGND VGND VPWR VPWR _3023_/B sky130_fd_sc_hd__or2_2
XFILLER_83_237 VGND VGND VPWR VPWR sky130_fd_sc_hd__decap_3
XFILLER_24_315 VGND VGND VPWR VPWR sky130_fd_sc_hd__decap_3
XFILLER_24_348 VGND VGND VPWR VPWR sky130_fd_sc_hd__decap_3
XFILLER_36_197 VGND VGND VPWR VPWR sky130_fd_sc_hd__decap_3
X_4955_ _5103_/CLK _4955_/D VGND VGND VPWR VPWR _4955_/Q sky130_fd_sc_hd__dfxtp_2
XTAP_TAPCELL_ROW_19_384 VGND VPWR sky130_fd_sc_hd__tapvpwrvgnd_1
XPHY_EDGE_ROW_27_Right_27 VGND VGND VPWR VPWR sky130_fd_sc_hd__decap_3
XFILLER_51_156 VGND VGND VPWR VPWR sky130_fd_sc_hd__decap_3
XFILLER_51_167 VGND VGND VPWR VPWR sky130_fd_sc_hd__fill_1
XFILLER_51_178 VGND VGND VPWR VPWR sky130_fd_sc_hd__decap_3
X_3906_ _4249_/A _3703_/B _3905_/Y VGND VGND VPWR VPWR _3906_/Y sky130_fd_sc_hd__o21bai_2
XFILLER_20_510 VGND VGND VPWR VPWR sky130_fd_sc_hd__decap_3
X_4886_ _5078_/CLK _4886_/D VGND VGND VPWR VPWR _4886_/Q sky130_fd_sc_hd__dfxtp_2
X_3837_ _4466_/B _3886_/B VGND VGND VPWR VPWR _4646_/S sky130_fd_sc_hd__nor2_2
X_3768_ _4794_/S _3768_/B VGND VGND VPWR VPWR _4335_/A sky130_fd_sc_hd__nor2_2
X_2719_ _2717_/X _2718_/X _5133_/Q VGND VGND VPWR VPWR _2719_/X sky130_fd_sc_hd__mux2_1
XFILLER_10_35 VGND VGND VPWR VPWR sky130_fd_sc_hd__fill_2
X_3699_ _4956_/Q _4940_/Q _4924_/Q _4908_/Q _3834_/S0 _3834_/S1 VGND VGND VPWR VPWR
+ _3699_/X sky130_fd_sc_hd__mux4_2
XPHY_EDGE_ROW_36_Right_36 VGND VGND VPWR VPWR sky130_fd_sc_hd__decap_3
XFILLER_59_245 VGND VGND VPWR VPWR sky130_fd_sc_hd__decap_3
XFILLER_87_532 VGND VGND VPWR VPWR sky130_fd_sc_hd__fill_1
XFILLER_86_39 VGND VGND VPWR VPWR sky130_fd_sc_hd__fill_1
XFILLER_19_109 VGND VGND VPWR VPWR sky130_fd_sc_hd__decap_3
XFILLER_19_33 VGND VGND VPWR VPWR sky130_fd_sc_hd__decap_3
XFILLER_47_418 VGND VGND VPWR VPWR sky130_fd_sc_hd__decap_3
XFILLER_59_267 VGND VGND VPWR VPWR sky130_fd_sc_hd__decap_3
XFILLER_74_259 VGND VGND VPWR VPWR sky130_fd_sc_hd__fill_2
XFILLER_42_112 VGND VGND VPWR VPWR sky130_fd_sc_hd__decap_3
XFILLER_70_410 VGND VGND VPWR VPWR sky130_fd_sc_hd__decap_3
XFILLER_70_421 VGND VGND VPWR VPWR sky130_fd_sc_hd__decap_3
XPHY_EDGE_ROW_45_Right_45 VGND VGND VPWR VPWR sky130_fd_sc_hd__decap_3
XFILLER_70_454 VGND VGND VPWR VPWR sky130_fd_sc_hd__decap_3
XFILLER_82_292 VGND VGND VPWR VPWR sky130_fd_sc_hd__decap_3
XTAP_TAPCELL_ROW_81_972 VGND VPWR sky130_fd_sc_hd__tapvpwrvgnd_1
XFILLER_23_370 VGND VGND VPWR VPWR sky130_fd_sc_hd__fill_2
XFILLER_11_543 VGND VGND VPWR VPWR sky130_fd_sc_hd__decap_3
XFILLER_51_53 VGND VGND VPWR VPWR sky130_fd_sc_hd__decap_3
XPHY_EDGE_ROW_54_Right_54 VGND VGND VPWR VPWR sky130_fd_sc_hd__decap_3
XFILLER_2_230 VGND VGND VPWR VPWR sky130_fd_sc_hd__decap_3
XTAP_TAPCELL_ROW_92_1080 VGND VPWR sky130_fd_sc_hd__tapvpwrvgnd_1
XFILLER_38_418 VGND VGND VPWR VPWR sky130_fd_sc_hd__fill_2
XFILLER_38_429 VGND VGND VPWR VPWR sky130_fd_sc_hd__decap_3
XFILLER_65_215 VGND VGND VPWR VPWR sky130_fd_sc_hd__decap_3
XPHY_EDGE_ROW_63_Right_63 VGND VGND VPWR VPWR sky130_fd_sc_hd__decap_3
XFILLER_18_175 VGND VGND VPWR VPWR sky130_fd_sc_hd__decap_3
XFILLER_46_473 VGND VGND VPWR VPWR sky130_fd_sc_hd__decap_3
XFILLER_46_495 VGND VGND VPWR VPWR sky130_fd_sc_hd__decap_3
XFILLER_18_197 VGND VGND VPWR VPWR sky130_fd_sc_hd__decap_3
XFILLER_33_134 VGND VGND VPWR VPWR sky130_fd_sc_hd__decap_3
XFILLER_61_443 VGND VGND VPWR VPWR sky130_fd_sc_hd__decap_3
XFILLER_73_281 VGND VGND VPWR VPWR sky130_fd_sc_hd__decap_3
XFILLER_33_167 VGND VGND VPWR VPWR sky130_fd_sc_hd__fill_1
XFILLER_61_476 VGND VGND VPWR VPWR sky130_fd_sc_hd__decap_3
XTAP_TAPCELL_ROW_16_354 VGND VPWR sky130_fd_sc_hd__tapvpwrvgnd_1
X_4740_ _4253_/X _4735_/X _4739_/X _4136_/Y VGND VGND VPWR VPWR _4740_/X sky130_fd_sc_hd__a31o_2
X_4671_ _4671_/A _4671_/B VGND VGND VPWR VPWR _4671_/Y sky130_fd_sc_hd__nand2_2
X_3622_ _5107_/Q _4995_/Q _4979_/Q _4963_/Q _3834_/S0 _3834_/S1 VGND VGND VPWR VPWR
+ _3622_/X sky130_fd_sc_hd__mux4_2
XPHY_EDGE_ROW_72_Right_72 VGND VGND VPWR VPWR sky130_fd_sc_hd__decap_3
X_3553_ _5163_/Q _5144_/Q VGND VGND VPWR VPWR _3555_/B sky130_fd_sc_hd__nor2_2
X_3484_ _5154_/Q _5135_/Q VGND VGND VPWR VPWR _3488_/A sky130_fd_sc_hd__or2_2
X_2504_ _5071_/Q _5055_/Q _5039_/Q _5023_/Q _2658_/S0 _2671_/S1 VGND VGND VPWR VPWR
+ _2505_/B sky130_fd_sc_hd__mux4_2
X_5223_ clkload8/A _5223_/D VGND VGND VPWR VPWR _5223_/Q sky130_fd_sc_hd__dfxtp_2
X_2435_ _5126_/Q VGND VGND VPWR VPWR _2435_/Y sky130_fd_sc_hd__inv_2
X_5154_ clkload4/A _5154_/D VGND VGND VPWR VPWR _5154_/Q sky130_fd_sc_hd__dfxtp_2
X_4105_ _4173_/A _3671_/X _4076_/Y VGND VGND VPWR VPWR _4105_/X sky130_fd_sc_hd__o21a_2
XFILLER_56_226 VGND VGND VPWR VPWR sky130_fd_sc_hd__fill_2
X_5085_ _5085_/CLK _5085_/D VGND VGND VPWR VPWR _5085_/Q sky130_fd_sc_hd__dfxtp_2
XPHY_EDGE_ROW_81_Right_81 VGND VGND VPWR VPWR sky130_fd_sc_hd__decap_3
XFILLER_84_524 VGND VGND VPWR VPWR sky130_fd_sc_hd__decap_3
XFILLER_56_248 VGND VGND VPWR VPWR sky130_fd_sc_hd__decap_3
XFILLER_56_259 VGND VGND VPWR VPWR sky130_fd_sc_hd__decap_3
X_4036_ _4034_/X _4035_/X _4173_/A VGND VGND VPWR VPWR _4036_/X sky130_fd_sc_hd__mux2_1
XFILLER_71_218 VGND VGND VPWR VPWR sky130_fd_sc_hd__fill_1
XFILLER_24_123 VGND VGND VPWR VPWR sky130_fd_sc_hd__decap_3
XFILLER_52_421 VGND VGND VPWR VPWR sky130_fd_sc_hd__decap_3
XFILLER_64_281 VGND VGND VPWR VPWR sky130_fd_sc_hd__decap_3
XFILLER_52_454 VGND VGND VPWR VPWR sky130_fd_sc_hd__decap_3
XFILLER_12_329 VGND VGND VPWR VPWR sky130_fd_sc_hd__decap_3
XFILLER_52_498 VGND VGND VPWR VPWR sky130_fd_sc_hd__decap_3
X_4938_ _5117_/CLK _4938_/D VGND VGND VPWR VPWR _4938_/Q sky130_fd_sc_hd__dfxtp_2
X_4869_ _5078_/CLK _4869_/D VGND VGND VPWR VPWR _4869_/Q sky130_fd_sc_hd__dfxtp_2
XFILLER_21_12 VGND VGND VPWR VPWR sky130_fd_sc_hd__fill_1
XTAP_TAPCELL_ROW_50_677 VGND VPWR sky130_fd_sc_hd__tapvpwrvgnd_1
XPHY_EDGE_ROW_90_Right_90 VGND VGND VPWR VPWR sky130_fd_sc_hd__decap_3
XFILLER_20_395 VGND VGND VPWR VPWR sky130_fd_sc_hd__decap_3
XFILLER_21_78 VGND VGND VPWR VPWR sky130_fd_sc_hd__fill_2
XFILLER_87_373 VGND VGND VPWR VPWR sky130_fd_sc_hd__decap_3
XFILLER_47_237 VGND VGND VPWR VPWR sky130_fd_sc_hd__decap_3
XFILLER_75_546 VGND VGND VPWR VPWR sky130_fd_sc_hd__decap_3
XTAP_TAPCELL_ROW_58_755 VGND VPWR sky130_fd_sc_hd__tapvpwrvgnd_1
XFILLER_62_207 VGND VGND VPWR VPWR sky130_fd_sc_hd__decap_3
XFILLER_55_281 VGND VGND VPWR VPWR sky130_fd_sc_hd__decap_3
XFILLER_70_273 VGND VGND VPWR VPWR sky130_fd_sc_hd__decap_3
XFILLER_70_284 VGND VGND VPWR VPWR sky130_fd_sc_hd__decap_3
XTAP_TAPCELL_ROW_13_324 VGND VPWR sky130_fd_sc_hd__tapvpwrvgnd_1
XFILLER_11_340 VGND VGND VPWR VPWR sky130_fd_sc_hd__decap_3
XFILLER_62_74 VGND VGND VPWR VPWR sky130_fd_sc_hd__decap_3
XFILLER_7_36 VGND VGND VPWR VPWR sky130_fd_sc_hd__decap_3
XFILLER_87_93 VGND VGND VPWR VPWR sky130_fd_sc_hd__decap_3
XFILLER_87_71 VGND VGND VPWR VPWR sky130_fd_sc_hd__decap_3
XFILLER_78_351 VGND VGND VPWR VPWR sky130_fd_sc_hd__decap_3
XFILLER_66_513 VGND VGND VPWR VPWR sky130_fd_sc_hd__decap_3
XFILLER_78_384 VGND VGND VPWR VPWR sky130_fd_sc_hd__fill_1
XFILLER_38_248 VGND VGND VPWR VPWR sky130_fd_sc_hd__decap_3
XFILLER_93_365 VGND VGND VPWR VPWR sky130_fd_sc_hd__decap_3
XFILLER_93_343 VGND VGND VPWR VPWR sky130_fd_sc_hd__decap_3
XFILLER_19_473 VGND VGND VPWR VPWR sky130_fd_sc_hd__decap_3
XFILLER_19_484 VGND VGND VPWR VPWR sky130_fd_sc_hd__decap_3
XFILLER_53_207 VGND VGND VPWR VPWR sky130_fd_sc_hd__decap_3
XFILLER_81_527 VGND VGND VPWR VPWR sky130_fd_sc_hd__decap_3
XFILLER_34_421 VGND VGND VPWR VPWR sky130_fd_sc_hd__decap_3
XFILLER_34_454 VGND VGND VPWR VPWR sky130_fd_sc_hd__decap_3
XFILLER_61_240 VGND VGND VPWR VPWR sky130_fd_sc_hd__decap_3
XFILLER_21_126 VGND VGND VPWR VPWR sky130_fd_sc_hd__decap_3
XFILLER_61_284 VGND VGND VPWR VPWR sky130_fd_sc_hd__fill_1
X_2984_ _2944_/X _2984_/A2 _2968_/Y _4914_/Q VGND VGND VPWR VPWR _4914_/D sky130_fd_sc_hd__a22o_2
X_4723_ _4468_/A _4787_/S _3961_/Y VGND VGND VPWR VPWR _4723_/Y sky130_fd_sc_hd__o21ai_2
X_4654_ _4654_/A _4671_/B VGND VGND VPWR VPWR _4654_/Y sky130_fd_sc_hd__nand2_2
X_4585_ _4067_/A _4787_/S _3640_/C VGND VGND VPWR VPWR _4585_/X sky130_fd_sc_hd__o21a_2
X_3605_ _4949_/Q _4933_/Q _4917_/Q _4901_/Q _3834_/S0 _3834_/S1 VGND VGND VPWR VPWR
+ _3605_/X sky130_fd_sc_hd__mux4_2
X_3536_ _4714_/A _3536_/B VGND VGND VPWR VPWR _5198_/D sky130_fd_sc_hd__nor2_2
X_5206_ clkload8/A _5206_/D VGND VGND VPWR VPWR _5206_/Q sky130_fd_sc_hd__dfxtp_2
X_3467_ _5173_/Q _3453_/X _4850_/B VGND VGND VPWR VPWR _3467_/X sky130_fd_sc_hd__a21o_2
XFILLER_69_340 VGND VGND VPWR VPWR sky130_fd_sc_hd__decap_3
X_3398_ _3387_/A _3389_/Y _3397_/X VGND VGND VPWR VPWR _3398_/Y sky130_fd_sc_hd__a21oi_2
XFILLER_29_204 VGND VGND VPWR VPWR sky130_fd_sc_hd__fill_2
XFILLER_69_373 VGND VGND VPWR VPWR sky130_fd_sc_hd__decap_3
X_5137_ _5177_/CLK _5137_/D VGND VGND VPWR VPWR _5137_/Q sky130_fd_sc_hd__dfxtp_2
XFILLER_84_321 VGND VGND VPWR VPWR sky130_fd_sc_hd__decap_3
XFILLER_57_546 VGND VGND VPWR VPWR sky130_fd_sc_hd__decap_3
X_5068_ _5100_/CLK _5068_/D VGND VGND VPWR VPWR _5068_/Q sky130_fd_sc_hd__dfxtp_2
XFILLER_84_354 VGND VGND VPWR VPWR sky130_fd_sc_hd__fill_2
XFILLER_44_207 VGND VGND VPWR VPWR sky130_fd_sc_hd__decap_3
XFILLER_72_516 VGND VGND VPWR VPWR sky130_fd_sc_hd__decap_3
X_4019_ _4866_/A _4019_/B VGND VGND VPWR VPWR _5207_/D sky130_fd_sc_hd__nor2_2
XTAP_TAPCELL_ROW_55_725 VGND VPWR sky130_fd_sc_hd__tapvpwrvgnd_1
XFILLER_84_365 VGND VGND VPWR VPWR sky130_fd_sc_hd__decap_3
XFILLER_37_281 VGND VGND VPWR VPWR sky130_fd_sc_hd__decap_3
XFILLER_52_240 VGND VGND VPWR VPWR sky130_fd_sc_hd__decap_3
XFILLER_52_262 VGND VGND VPWR VPWR sky130_fd_sc_hd__decap_3
XPHY_EDGE_ROW_0_Right_0 VGND VGND VPWR VPWR sky130_fd_sc_hd__decap_3
XFILLER_25_498 VGND VGND VPWR VPWR sky130_fd_sc_hd__decap_3
XFILLER_40_413 VGND VGND VPWR VPWR sky130_fd_sc_hd__decap_3
XFILLER_40_424 VGND VGND VPWR VPWR sky130_fd_sc_hd__decap_3
XFILLER_40_457 VGND VGND VPWR VPWR sky130_fd_sc_hd__decap_3
XFILLER_20_192 VGND VGND VPWR VPWR sky130_fd_sc_hd__decap_3
XFILLER_32_88 VGND VGND VPWR VPWR sky130_fd_sc_hd__fill_2
XFILLER_4_303 VGND VGND VPWR VPWR sky130_fd_sc_hd__fill_1
XFILLER_4_347 VGND VGND VPWR VPWR sky130_fd_sc_hd__decap_3
XFILLER_0_531 VGND VGND VPWR VPWR sky130_fd_sc_hd__fill_1
XFILLER_79_148 VGND VGND VPWR VPWR sky130_fd_sc_hd__decap_3
XFILLER_79_137 VGND VGND VPWR VPWR sky130_fd_sc_hd__decap_3
XFILLER_0_542 VGND VGND VPWR VPWR sky130_fd_sc_hd__decap_3
XFILLER_48_513 VGND VGND VPWR VPWR sky130_fd_sc_hd__decap_3
XFILLER_57_30 VGND VGND VPWR VPWR sky130_fd_sc_hd__decap_3
XFILLER_87_181 VGND VGND VPWR VPWR sky130_fd_sc_hd__decap_3
XFILLER_57_63 VGND VGND VPWR VPWR sky130_fd_sc_hd__decap_3
XFILLER_75_332 VGND VGND VPWR VPWR sky130_fd_sc_hd__decap_3
XFILLER_63_505 VGND VGND VPWR VPWR sky130_fd_sc_hd__decap_3
XFILLER_63_538 VGND VGND VPWR VPWR sky130_fd_sc_hd__decap_3
XFILLER_75_376 VGND VGND VPWR VPWR sky130_fd_sc_hd__decap_3
XFILLER_16_432 VGND VGND VPWR VPWR sky130_fd_sc_hd__fill_2
XFILLER_73_40 VGND VGND VPWR VPWR sky130_fd_sc_hd__decap_3
XFILLER_75_398 VGND VGND VPWR VPWR sky130_fd_sc_hd__decap_3
XPHY_EDGE_ROW_35_Left_129 VGND VGND VPWR VPWR sky130_fd_sc_hd__decap_3
XFILLER_31_424 VGND VGND VPWR VPWR sky130_fd_sc_hd__decap_3
XFILLER_43_284 VGND VGND VPWR VPWR sky130_fd_sc_hd__decap_3
XFILLER_73_95 VGND VGND VPWR VPWR sky130_fd_sc_hd__decap_3
XFILLER_11_192 VGND VGND VPWR VPWR sky130_fd_sc_hd__decap_3
XPHY_EDGE_ROW_44_Left_138 VGND VGND VPWR VPWR sky130_fd_sc_hd__decap_3
X_4370_ _4360_/A _4380_/B _4000_/X _4361_/A VGND VGND VPWR VPWR _4375_/A sky130_fd_sc_hd__a2bb2o_2
X_3321_ _5140_/Q _3265_/B _3320_/X _3448_/B VGND VGND VPWR VPWR _5140_/D sky130_fd_sc_hd__o211a_2
XFILLER_3_391 VGND VGND VPWR VPWR sky130_fd_sc_hd__fill_1
X_3252_ _5260_/Q _3252_/B _3252_/C VGND VGND VPWR VPWR _3252_/X sky130_fd_sc_hd__and3_2
X_3183_ _2929_/X _3185_/A2 _3185_/B1 _5085_/Q VGND VGND VPWR VPWR _5085_/D sky130_fd_sc_hd__a22o_2
XFILLER_78_170 VGND VGND VPWR VPWR sky130_fd_sc_hd__decap_3
XFILLER_66_332 VGND VGND VPWR VPWR sky130_fd_sc_hd__decap_3
XFILLER_26_218 VGND VGND VPWR VPWR sky130_fd_sc_hd__decap_3
XFILLER_66_365 VGND VGND VPWR VPWR sky130_fd_sc_hd__decap_3
XFILLER_66_387 VGND VGND VPWR VPWR sky130_fd_sc_hd__decap_3
XPHY_EDGE_ROW_53_Left_147 VGND VGND VPWR VPWR sky130_fd_sc_hd__decap_3
XFILLER_19_270 VGND VGND VPWR VPWR sky130_fd_sc_hd__decap_3
XFILLER_93_195 VGND VGND VPWR VPWR sky130_fd_sc_hd__fill_1
XFILLER_81_346 VGND VGND VPWR VPWR sky130_fd_sc_hd__decap_3
XFILLER_81_335 VGND VGND VPWR VPWR sky130_fd_sc_hd__fill_1
XFILLER_81_379 VGND VGND VPWR VPWR sky130_fd_sc_hd__fill_1
XFILLER_22_424 VGND VGND VPWR VPWR sky130_fd_sc_hd__decap_3
XFILLER_22_457 VGND VGND VPWR VPWR sky130_fd_sc_hd__decap_3
XFILLER_34_295 VGND VGND VPWR VPWR sky130_fd_sc_hd__decap_3
X_2967_ _3171_/B _3004_/B VGND VGND VPWR VPWR _2968_/B sky130_fd_sc_hd__nor2_2
XTAP_TAPCELL_ROW_60_772 VGND VPWR sky130_fd_sc_hd__tapvpwrvgnd_1
X_4706_ _4706_/A _4802_/A _4607_/A VGND VGND VPWR VPWR _4706_/X sky130_fd_sc_hd__or3b_2
X_2898_ _2891_/X _2936_/B2 _2936_/A2 _4867_/Q VGND VGND VPWR VPWR _4867_/D sky130_fd_sc_hd__a22o_2
XPHY_EDGE_ROW_62_Left_156 VGND VGND VPWR VPWR sky130_fd_sc_hd__decap_3
X_4637_ _4636_/X _4585_/X _4802_/A VGND VGND VPWR VPWR _4637_/X sky130_fd_sc_hd__mux2_1
X_4568_ _4568_/A _4568_/B VGND VGND VPWR VPWR _4569_/B sky130_fd_sc_hd__nor2_2
XFILLER_89_402 VGND VGND VPWR VPWR sky130_fd_sc_hd__decap_3
XFILLER_78_29 VGND VGND VPWR VPWR sky130_fd_sc_hd__decap_3
X_4499_ _4497_/X _4498_/Y _4563_/A VGND VGND VPWR VPWR _4504_/A sky130_fd_sc_hd__o21ai_2
X_3519_ _3519_/A _3519_/B VGND VGND VPWR VPWR _3519_/Y sky130_fd_sc_hd__xnor2_2
XFILLER_57_310 VGND VGND VPWR VPWR sky130_fd_sc_hd__decap_3
XFILLER_76_118 VGND VGND VPWR VPWR sky130_fd_sc_hd__decap_3
XFILLER_57_343 VGND VGND VPWR VPWR sky130_fd_sc_hd__decap_3
XFILLER_69_181 VGND VGND VPWR VPWR sky130_fd_sc_hd__decap_3
XTAP_TAPCELL_ROW_68_850 VGND VPWR sky130_fd_sc_hd__tapvpwrvgnd_1
XPHY_EDGE_ROW_71_Left_165 VGND VGND VPWR VPWR sky130_fd_sc_hd__decap_3
XFILLER_45_505 VGND VGND VPWR VPWR sky130_fd_sc_hd__decap_3
XFILLER_57_376 VGND VGND VPWR VPWR sky130_fd_sc_hd__decap_3
XFILLER_27_77 VGND VGND VPWR VPWR sky130_fd_sc_hd__decap_3
XFILLER_84_195 VGND VGND VPWR VPWR sky130_fd_sc_hd__fill_1
XFILLER_25_240 VGND VGND VPWR VPWR sky130_fd_sc_hd__decap_3
XFILLER_72_379 VGND VGND VPWR VPWR sky130_fd_sc_hd__decap_3
XFILLER_25_284 VGND VGND VPWR VPWR sky130_fd_sc_hd__decap_3
XFILLER_13_446 VGND VGND VPWR VPWR sky130_fd_sc_hd__fill_2
XFILLER_13_457 VGND VGND VPWR VPWR sky130_fd_sc_hd__decap_3
XFILLER_40_221 VGND VGND VPWR VPWR sky130_fd_sc_hd__decap_3
XFILLER_40_232 VGND VGND VPWR VPWR sky130_fd_sc_hd__decap_3
XFILLER_40_287 VGND VGND VPWR VPWR sky130_fd_sc_hd__decap_3
XFILLER_43_76 VGND VGND VPWR VPWR sky130_fd_sc_hd__decap_3
XPHY_EDGE_ROW_80_Left_174 VGND VGND VPWR VPWR sky130_fd_sc_hd__decap_3
XFILLER_9_428 VGND VGND VPWR VPWR sky130_fd_sc_hd__decap_3
XFILLER_4_144 VGND VGND VPWR VPWR sky130_fd_sc_hd__decap_3
XFILLER_4_48 VGND VGND VPWR VPWR sky130_fd_sc_hd__decap_3
XFILLER_68_95 VGND VGND VPWR VPWR sky130_fd_sc_hd__fill_1
XFILLER_48_354 VGND VGND VPWR VPWR sky130_fd_sc_hd__decap_3
XFILLER_48_365 VGND VGND VPWR VPWR sky130_fd_sc_hd__decap_3
XFILLER_36_549 VGND VGND VPWR VPWR sky130_fd_sc_hd__decap_3
XFILLER_63_346 VGND VGND VPWR VPWR sky130_fd_sc_hd__fill_1
XFILLER_75_184 VGND VGND VPWR VPWR sky130_fd_sc_hd__fill_2
XFILLER_84_72 VGND VGND VPWR VPWR sky130_fd_sc_hd__decap_3
XFILLER_16_273 VGND VGND VPWR VPWR sky130_fd_sc_hd__decap_3
XFILLER_31_221 VGND VGND VPWR VPWR sky130_fd_sc_hd__decap_3
X_3870_ _5176_/Q _3999_/B VGND VGND VPWR VPWR _4371_/B sky130_fd_sc_hd__or2_2
X_2821_ _4959_/Q _4943_/Q _4927_/Q _4911_/Q _5131_/Q _2848_/S1 VGND VGND VPWR VPWR
+ _2821_/X sky130_fd_sc_hd__mux4_2
XFILLER_31_287 VGND VGND VPWR VPWR sky130_fd_sc_hd__decap_3
XFILLER_31_298 VGND VGND VPWR VPWR sky130_fd_sc_hd__fill_1
X_2752_ _2851_/A _3280_/B VGND VGND VPWR VPWR _2752_/X sky130_fd_sc_hd__and2_2
XFILLER_76_3 VGND VGND VPWR VPWR sky130_fd_sc_hd__decap_3
XFILLER_8_450 VGND VGND VPWR VPWR sky130_fd_sc_hd__decap_3
X_4422_ _3934_/B _3924_/B _4523_/S VGND VGND VPWR VPWR _4422_/X sky130_fd_sc_hd__mux2_1
X_2683_ _2881_/B _2881_/C _4292_/A VGND VGND VPWR VPWR _2882_/A sky130_fd_sc_hd__a21bo_2
XFILLER_8_483 VGND VGND VPWR VPWR sky130_fd_sc_hd__decap_3
X_4353_ _4546_/A _4332_/X _4333_/X _4352_/Y VGND VGND VPWR VPWR _4353_/X sky130_fd_sc_hd__o22a_2
X_4284_ _4704_/S _4284_/B _4285_/B _4285_/C VGND VGND VPWR VPWR _4284_/Y sky130_fd_sc_hd__nor4_2
X_3304_ _3291_/A _3303_/X _3302_/X VGND VGND VPWR VPWR _3306_/A sky130_fd_sc_hd__a21oi_2
X_3235_ _5260_/Q _3448_/B _3235_/C VGND VGND VPWR VPWR _3235_/X sky130_fd_sc_hd__and3_2
XFILLER_39_376 VGND VGND VPWR VPWR sky130_fd_sc_hd__decap_3
X_3166_ _2932_/X _3170_/A2 _3170_/B1 _5070_/Q VGND VGND VPWR VPWR _5070_/D sky130_fd_sc_hd__a22o_2
X_3097_ _5189_/Q _5188_/Q VGND VGND VPWR VPWR _3134_/B sky130_fd_sc_hd__nand2_2
XTAP_TAPCELL_ROW_65_820 VGND VPWR sky130_fd_sc_hd__tapvpwrvgnd_1
XFILLER_54_368 VGND VGND VPWR VPWR sky130_fd_sc_hd__decap_3
XTAP_TAPCELL_ROW_37_555 VGND VPWR sky130_fd_sc_hd__tapvpwrvgnd_1
XFILLER_81_165 VGND VGND VPWR VPWR sky130_fd_sc_hd__decap_3
XFILLER_22_232 VGND VGND VPWR VPWR sky130_fd_sc_hd__decap_3
XFILLER_50_541 VGND VGND VPWR VPWR sky130_fd_sc_hd__decap_3
XFILLER_22_276 VGND VGND VPWR VPWR sky130_fd_sc_hd__decap_3
X_3999_ _3999_/A _3999_/B VGND VGND VPWR VPWR _4380_/B sky130_fd_sc_hd__or2_2
XFILLER_10_427 VGND VGND VPWR VPWR sky130_fd_sc_hd__decap_3
XFILLER_10_449 VGND VGND VPWR VPWR sky130_fd_sc_hd__fill_2
XFILLER_22_287 VGND VGND VPWR VPWR sky130_fd_sc_hd__decap_3
XFILLER_13_68 VGND VGND VPWR VPWR sky130_fd_sc_hd__decap_3
XFILLER_8_6 VGND VGND VPWR VPWR sky130_fd_sc_hd__decap_3
XFILLER_1_147 VGND VGND VPWR VPWR sky130_fd_sc_hd__decap_3
XFILLER_89_243 VGND VGND VPWR VPWR sky130_fd_sc_hd__decap_3
XFILLER_77_405 VGND VGND VPWR VPWR sky130_fd_sc_hd__decap_3
XFILLER_89_287 VGND VGND VPWR VPWR sky130_fd_sc_hd__decap_3
XFILLER_77_438 VGND VGND VPWR VPWR sky130_fd_sc_hd__decap_3
XFILLER_38_54 VGND VGND VPWR VPWR sky130_fd_sc_hd__decap_3
XFILLER_77_449 VGND VGND VPWR VPWR sky130_fd_sc_hd__decap_3
XFILLER_57_162 VGND VGND VPWR VPWR sky130_fd_sc_hd__decap_3
XFILLER_92_419 VGND VGND VPWR VPWR sky130_fd_sc_hd__fill_1
XFILLER_45_313 VGND VGND VPWR VPWR sky130_fd_sc_hd__decap_3
XFILLER_57_195 VGND VGND VPWR VPWR sky130_fd_sc_hd__decap_3
XFILLER_85_493 VGND VGND VPWR VPWR sky130_fd_sc_hd__fill_2
XFILLER_33_508 VGND VGND VPWR VPWR sky130_fd_sc_hd__decap_3
XFILLER_45_379 VGND VGND VPWR VPWR sky130_fd_sc_hd__decap_3
XTAP_TAPCELL_ROW_0_191 VGND VPWR sky130_fd_sc_hd__tapvpwrvgnd_1
XFILLER_13_254 VGND VGND VPWR VPWR sky130_fd_sc_hd__decap_3
XTAP_TAPCELL_ROW_71_878 VGND VPWR sky130_fd_sc_hd__tapvpwrvgnd_1
XFILLER_9_225 VGND VGND VPWR VPWR sky130_fd_sc_hd__decap_3
XFILLER_70_85 VGND VGND VPWR VPWR sky130_fd_sc_hd__decap_3
Xclkload17 _5164_/CLK VGND VGND VPWR VPWR clkload17/Y sky130_fd_sc_hd__bufinv_16
Xclkload28 _5063_/CLK VGND VGND VPWR VPWR clkload28/X sky130_fd_sc_hd__clkbuf_8
XTAP_TAPCELL_ROW_8_280 VGND VPWR sky130_fd_sc_hd__tapvpwrvgnd_1
XFILLER_68_449 VGND VGND VPWR VPWR sky130_fd_sc_hd__decap_3
XTAP_TAPCELL_ROW_79_956 VGND VPWR sky130_fd_sc_hd__tapvpwrvgnd_1
X_3020_ _2938_/X _3006_/B _3006_/Y _4944_/Q VGND VGND VPWR VPWR _4944_/D sky130_fd_sc_hd__a22o_2
XFILLER_76_471 VGND VGND VPWR VPWR sky130_fd_sc_hd__decap_3
XFILLER_48_195 VGND VGND VPWR VPWR sky130_fd_sc_hd__fill_1
XFILLER_63_143 VGND VGND VPWR VPWR sky130_fd_sc_hd__decap_3
XFILLER_51_305 VGND VGND VPWR VPWR sky130_fd_sc_hd__decap_3
X_4971_ _5121_/CLK _4971_/D VGND VGND VPWR VPWR _4971_/Q sky130_fd_sc_hd__dfxtp_2
XTAP_TAPCELL_ROW_34_525 VGND VPWR sky130_fd_sc_hd__tapvpwrvgnd_1
XFILLER_91_485 VGND VGND VPWR VPWR sky130_fd_sc_hd__decap_3
X_3922_ _3922_/A _3922_/B VGND VGND VPWR VPWR _3922_/Y sky130_fd_sc_hd__nor2_2
X_3853_ _3867_/A _4642_/A VGND VGND VPWR VPWR _4404_/S sky130_fd_sc_hd__or2_2
X_2804_ _5133_/Q _2803_/X _2437_/Y VGND VGND VPWR VPWR _2804_/X sky130_fd_sc_hd__o21a_2
X_3784_ _3831_/A _3784_/B VGND VGND VPWR VPWR _3784_/X sky130_fd_sc_hd__or2_2
X_2735_ _4886_/Q _4870_/Q _5094_/Q _5078_/Q _2812_/S0 _2848_/S1 VGND VGND VPWR VPWR
+ _2735_/X sky130_fd_sc_hd__mux4_2
X_2666_ _5069_/Q _5053_/Q _5037_/Q _5021_/Q _5123_/Q _2671_/S1 VGND VGND VPWR VPWR
+ _2667_/B sky130_fd_sc_hd__mux4_2
X_4405_ _4405_/A _4405_/B VGND VGND VPWR VPWR _4406_/B sky130_fd_sc_hd__and2_2
X_4336_ _4335_/A _4335_/B _4246_/A VGND VGND VPWR VPWR _4336_/X sky130_fd_sc_hd__a21o_2
X_2597_ _5059_/Q _5043_/Q _5027_/Q _5011_/Q _2658_/S0 _2671_/S1 VGND VGND VPWR VPWR
+ _2597_/X sky130_fd_sc_hd__mux4_2
XFILLER_59_405 VGND VGND VPWR VPWR sky130_fd_sc_hd__decap_3
XFILLER_59_449 VGND VGND VPWR VPWR sky130_fd_sc_hd__decap_3
X_4267_ _4297_/A _4267_/B VGND VGND VPWR VPWR _4267_/Y sky130_fd_sc_hd__nor2_2
XFILLER_39_151 VGND VGND VPWR VPWR sky130_fd_sc_hd__decap_3
XFILLER_74_408 VGND VGND VPWR VPWR sky130_fd_sc_hd__decap_3
X_4198_ _4198_/A _4702_/S _4198_/C VGND VGND VPWR VPWR _4198_/Y sky130_fd_sc_hd__nor3_2
X_3218_ _2926_/X _3221_/A2 _3208_/Y _5116_/Q VGND VGND VPWR VPWR _5116_/D sky130_fd_sc_hd__a22o_2
XFILLER_86_279 VGND VGND VPWR VPWR sky130_fd_sc_hd__decap_3
XFILLER_39_184 VGND VGND VPWR VPWR sky130_fd_sc_hd__decap_3
XFILLER_67_482 VGND VGND VPWR VPWR sky130_fd_sc_hd__decap_3
X_3149_ _2935_/X _3152_/A2 _3136_/Y _5055_/Q VGND VGND VPWR VPWR _5055_/D sky130_fd_sc_hd__a22o_2
XFILLER_15_508 VGND VGND VPWR VPWR sky130_fd_sc_hd__decap_3
XFILLER_24_12 VGND VGND VPWR VPWR sky130_fd_sc_hd__fill_2
XFILLER_24_56 VGND VGND VPWR VPWR sky130_fd_sc_hd__decap_3
XFILLER_50_371 VGND VGND VPWR VPWR sky130_fd_sc_hd__fill_2
XFILLER_50_393 VGND VGND VPWR VPWR sky130_fd_sc_hd__decap_3
XFILLER_6_206 VGND VGND VPWR VPWR sky130_fd_sc_hd__decap_3
XFILLER_6_239 VGND VGND VPWR VPWR sky130_fd_sc_hd__decap_3
XFILLER_40_55 VGND VGND VPWR VPWR sky130_fd_sc_hd__decap_3
XFILLER_40_88 VGND VGND VPWR VPWR sky130_fd_sc_hd__decap_3
XFILLER_6_3 VGND VGND VPWR VPWR sky130_fd_sc_hd__decap_3
XFILLER_49_31 VGND VGND VPWR VPWR sky130_fd_sc_hd__fill_1
XFILLER_1_27 VGND VGND VPWR VPWR sky130_fd_sc_hd__decap_3
XFILLER_65_408 VGND VGND VPWR VPWR sky130_fd_sc_hd__decap_3
XTAP_TAPCELL_ROW_76_926 VGND VPWR sky130_fd_sc_hd__tapvpwrvgnd_1
XTAP_TAPCELL_ROW_5_250 VGND VPWR sky130_fd_sc_hd__tapvpwrvgnd_1
XFILLER_77_268 VGND VGND VPWR VPWR sky130_fd_sc_hd__decap_3
XFILLER_18_324 VGND VGND VPWR VPWR sky130_fd_sc_hd__decap_3
XFILLER_92_249 VGND VGND VPWR VPWR sky130_fd_sc_hd__decap_3
XFILLER_18_368 VGND VGND VPWR VPWR sky130_fd_sc_hd__fill_1
XFILLER_45_143 VGND VGND VPWR VPWR sky130_fd_sc_hd__decap_3
XFILLER_65_74 VGND VGND VPWR VPWR sky130_fd_sc_hd__fill_2
XTAP_TAPCELL_ROW_86_1022 VGND VPWR sky130_fd_sc_hd__tapvpwrvgnd_1
XFILLER_85_290 VGND VGND VPWR VPWR sky130_fd_sc_hd__decap_3
XFILLER_33_327 VGND VGND VPWR VPWR sky130_fd_sc_hd__decap_3
XFILLER_14_530 VGND VGND VPWR VPWR sky130_fd_sc_hd__fill_2
XFILLER_33_349 VGND VGND VPWR VPWR sky130_fd_sc_hd__decap_3
XFILLER_14_552 VGND VGND VPWR VPWR sky130_fd_sc_hd__fill_1
XFILLER_81_51 VGND VGND VPWR VPWR sky130_fd_sc_hd__decap_3
XFILLER_41_382 VGND VGND VPWR VPWR sky130_fd_sc_hd__decap_3
XFILLER_60_6 VGND VGND VPWR VPWR sky130_fd_sc_hd__fill_2
X_2520_ _2667_/A _2519_/X _5126_/Q VGND VGND VPWR VPWR _2520_/X sky130_fd_sc_hd__o21a_2
X_2451_ _5179_/Q _5178_/Q _5177_/Q VGND VGND VPWR VPWR _3995_/B sky130_fd_sc_hd__or3b_2
XFILLER_68_213 VGND VGND VPWR VPWR sky130_fd_sc_hd__fill_2
X_5170_ clkload4/A _5170_/D VGND VGND VPWR VPWR _5170_/Q sky130_fd_sc_hd__dfxtp_2
XFILLER_68_235 VGND VGND VPWR VPWR sky130_fd_sc_hd__decap_3
X_4121_ _4139_/A _4121_/B VGND VGND VPWR VPWR _4121_/Y sky130_fd_sc_hd__nor2_2
XFILLER_56_419 VGND VGND VPWR VPWR sky130_fd_sc_hd__fill_1
XFILLER_68_268 VGND VGND VPWR VPWR sky130_fd_sc_hd__decap_3
X_4052_ _3892_/A _4360_/B _4042_/X _4051_/X VGND VGND VPWR VPWR _4053_/D sky130_fd_sc_hd__a31o_2
Xinput4 INSTR_STREAM[12] VGND VGND VPWR VPWR input4/X sky130_fd_sc_hd__clkdlybuf4s25_1
X_3003_ _2944_/X _2987_/B _2987_/Y _4930_/Q VGND VGND VPWR VPWR _4930_/D sky130_fd_sc_hd__a22o_2
XTAP_TAPCELL_ROW_47_650 VGND VPWR sky130_fd_sc_hd__tapvpwrvgnd_1
XFILLER_51_113 VGND VGND VPWR VPWR sky130_fd_sc_hd__decap_3
X_4954_ _5117_/CLK _4954_/D VGND VGND VPWR VPWR _4954_/Q sky130_fd_sc_hd__dfxtp_2
XTAP_TAPCELL_ROW_19_385 VGND VPWR sky130_fd_sc_hd__tapvpwrvgnd_1
XFILLER_32_360 VGND VGND VPWR VPWR sky130_fd_sc_hd__decap_3
X_3905_ _4218_/A _3905_/B VGND VGND VPWR VPWR _3905_/Y sky130_fd_sc_hd__nor2_2
XFILLER_32_382 VGND VGND VPWR VPWR sky130_fd_sc_hd__decap_3
X_4885_ _5078_/CLK _4885_/D VGND VGND VPWR VPWR _4885_/Q sky130_fd_sc_hd__dfxtp_2
XFILLER_20_544 VGND VGND VPWR VPWR sky130_fd_sc_hd__decap_3
X_3836_ _3831_/X _3832_/X _3835_/X _2432_/Y VGND VGND VPWR VPWR _3886_/B sky130_fd_sc_hd__a22o_2
X_3767_ _4551_/A _3767_/B VGND VGND VPWR VPWR _3768_/B sky130_fd_sc_hd__and2_2
X_2718_ _5060_/Q _5044_/Q _5028_/Q _5012_/Q _2812_/S0 _2848_/S1 VGND VGND VPWR VPWR
+ _2718_/X sky130_fd_sc_hd__mux4_2
X_3698_ _5116_/Q _5004_/Q _4988_/Q _4972_/Q _3834_/S0 _3834_/S1 VGND VGND VPWR VPWR
+ _3698_/X sky130_fd_sc_hd__mux4_2
X_2649_ _5160_/Q _4477_/A VGND VGND VPWR VPWR _2649_/Y sky130_fd_sc_hd__nand2_2
XFILLER_59_213 VGND VGND VPWR VPWR sky130_fd_sc_hd__decap_3
X_4319_ _3668_/B _4132_/B _4172_/X VGND VGND VPWR VPWR _4323_/B sky130_fd_sc_hd__o21a_2
XFILLER_87_544 VGND VGND VPWR VPWR sky130_fd_sc_hd__decap_3
XFILLER_59_279 VGND VGND VPWR VPWR sky130_fd_sc_hd__fill_1
XFILLER_27_110 VGND VGND VPWR VPWR sky130_fd_sc_hd__fill_2
XFILLER_74_216 VGND VGND VPWR VPWR sky130_fd_sc_hd__decap_3
XTAP_TAPCELL_ROW_2_220 VGND VPWR sky130_fd_sc_hd__tapvpwrvgnd_1
XFILLER_55_441 VGND VGND VPWR VPWR sky130_fd_sc_hd__fill_1
XFILLER_55_452 VGND VGND VPWR VPWR sky130_fd_sc_hd__decap_3
XFILLER_67_290 VGND VGND VPWR VPWR sky130_fd_sc_hd__decap_3
XFILLER_27_154 VGND VGND VPWR VPWR sky130_fd_sc_hd__decap_3
XFILLER_35_22 VGND VGND VPWR VPWR sky130_fd_sc_hd__fill_1
XFILLER_55_485 VGND VGND VPWR VPWR sky130_fd_sc_hd__decap_3
XFILLER_82_271 VGND VGND VPWR VPWR sky130_fd_sc_hd__decap_3
XFILLER_27_198 VGND VGND VPWR VPWR sky130_fd_sc_hd__decap_3
XFILLER_35_55 VGND VGND VPWR VPWR sky130_fd_sc_hd__fill_1
XFILLER_70_433 VGND VGND VPWR VPWR sky130_fd_sc_hd__decap_3
XFILLER_70_477 VGND VGND VPWR VPWR sky130_fd_sc_hd__fill_2
XTAP_TAPCELL_ROW_81_973 VGND VPWR sky130_fd_sc_hd__tapvpwrvgnd_1
XFILLER_11_500 VGND VGND VPWR VPWR sky130_fd_sc_hd__decap_3
XFILLER_23_393 VGND VGND VPWR VPWR sky130_fd_sc_hd__decap_3
XFILLER_51_32 VGND VGND VPWR VPWR sky130_fd_sc_hd__decap_3
XFILLER_51_87 VGND VGND VPWR VPWR sky130_fd_sc_hd__fill_1
XFILLER_7_548 VGND VGND VPWR VPWR sky130_fd_sc_hd__decap_3
XFILLER_2_253 VGND VGND VPWR VPWR sky130_fd_sc_hd__decap_3
XFILLER_78_533 VGND VGND VPWR VPWR sky130_fd_sc_hd__fill_2
XFILLER_25_9 VGND VGND VPWR VPWR sky130_fd_sc_hd__fill_2
XFILLER_93_514 VGND VGND VPWR VPWR sky130_fd_sc_hd__decap_3
XFILLER_76_40 VGND VGND VPWR VPWR sky130_fd_sc_hd__fill_1
XFILLER_93_536 VGND VGND VPWR VPWR sky130_fd_sc_hd__decap_3
XFILLER_46_430 VGND VGND VPWR VPWR sky130_fd_sc_hd__decap_3
XFILLER_61_411 VGND VGND VPWR VPWR sky130_fd_sc_hd__decap_3
XFILLER_73_293 VGND VGND VPWR VPWR sky130_fd_sc_hd__decap_3
XTAP_TAPCELL_ROW_44_620 VGND VPWR sky130_fd_sc_hd__tapvpwrvgnd_1
XFILLER_61_455 VGND VGND VPWR VPWR sky130_fd_sc_hd__decap_3
XFILLER_61_488 VGND VGND VPWR VPWR sky130_fd_sc_hd__decap_3
XTAP_TAPCELL_ROW_16_355 VGND VPWR sky130_fd_sc_hd__tapvpwrvgnd_1
XFILLER_14_371 VGND VGND VPWR VPWR sky130_fd_sc_hd__decap_3
X_4670_ _5228_/Q _4850_/B VGND VGND VPWR VPWR _4670_/Y sky130_fd_sc_hd__nand2_2
X_3621_ _5129_/Q _3618_/X _5130_/Q VGND VGND VPWR VPWR _3621_/X sky130_fd_sc_hd__o21a_2
X_3552_ _3549_/A _3549_/B _3549_/C _3546_/A VGND VGND VPWR VPWR _3555_/A sky130_fd_sc_hd__o31a_2
X_2503_ _5165_/Q _4471_/A VGND VGND VPWR VPWR _2886_/B sky130_fd_sc_hd__nand2_2
X_3483_ _5192_/Q _4850_/B VGND VGND VPWR VPWR _3483_/Y sky130_fd_sc_hd__nand2_2
XFILLER_69_511 VGND VGND VPWR VPWR sky130_fd_sc_hd__decap_3
X_5222_ clkload8/A _5222_/D VGND VGND VPWR VPWR _5222_/Q sky130_fd_sc_hd__dfxtp_2
X_2434_ _5125_/Q VGND VGND VPWR VPWR _2667_/A sky130_fd_sc_hd__inv_2
XFILLER_88_319 VGND VGND VPWR VPWR sky130_fd_sc_hd__fill_2
X_5153_ clkload4/A _5153_/D VGND VGND VPWR VPWR _5153_/Q sky130_fd_sc_hd__dfxtp_2
X_4104_ _4173_/A _3665_/X _4103_/Y _4172_/A VGND VGND VPWR VPWR _4104_/X sky130_fd_sc_hd__o211a_2
X_5084_ _5085_/CLK _5084_/D VGND VGND VPWR VPWR _5084_/Q sky130_fd_sc_hd__dfxtp_2
XFILLER_37_441 VGND VGND VPWR VPWR sky130_fd_sc_hd__decap_3
XFILLER_37_452 VGND VGND VPWR VPWR sky130_fd_sc_hd__decap_3
X_4035_ _3663_/X _3674_/B _4077_/S VGND VGND VPWR VPWR _4035_/X sky130_fd_sc_hd__mux2_1
XFILLER_37_474 VGND VGND VPWR VPWR sky130_fd_sc_hd__decap_3
XFILLER_52_400 VGND VGND VPWR VPWR sky130_fd_sc_hd__decap_3
XFILLER_52_433 VGND VGND VPWR VPWR sky130_fd_sc_hd__decap_3
XFILLER_52_466 VGND VGND VPWR VPWR sky130_fd_sc_hd__decap_3
XFILLER_52_477 VGND VGND VPWR VPWR sky130_fd_sc_hd__decap_3
X_4937_ clkload9/A _4937_/D VGND VGND VPWR VPWR _4937_/Q sky130_fd_sc_hd__dfxtp_2
X_4868_ _5092_/CLK _4868_/D VGND VGND VPWR VPWR _4868_/Q sky130_fd_sc_hd__dfxtp_2
X_3819_ _4664_/S VGND VGND VPWR VPWR _4148_/A sky130_fd_sc_hd__inv_2
XTAP_TAPCELL_ROW_50_678 VGND VPWR sky130_fd_sc_hd__tapvpwrvgnd_1
X_4799_ _4866_/A _4799_/B VGND VGND VPWR VPWR _5236_/D sky130_fd_sc_hd__nor2_2
XFILLER_21_57 VGND VGND VPWR VPWR sky130_fd_sc_hd__decap_3
XFILLER_79_319 VGND VGND VPWR VPWR sky130_fd_sc_hd__fill_2
XFILLER_87_352 VGND VGND VPWR VPWR sky130_fd_sc_hd__decap_3
XFILLER_75_503 VGND VGND VPWR VPWR sky130_fd_sc_hd__fill_1
XFILLER_47_216 VGND VGND VPWR VPWR sky130_fd_sc_hd__decap_3
XFILLER_87_396 VGND VGND VPWR VPWR sky130_fd_sc_hd__decap_3
XFILLER_87_385 VGND VGND VPWR VPWR sky130_fd_sc_hd__decap_3
XFILLER_28_430 VGND VGND VPWR VPWR sky130_fd_sc_hd__decap_3
XTAP_TAPCELL_ROW_58_756 VGND VPWR sky130_fd_sc_hd__tapvpwrvgnd_1
XFILLER_28_463 VGND VGND VPWR VPWR sky130_fd_sc_hd__decap_3
XFILLER_46_54 VGND VGND VPWR VPWR sky130_fd_sc_hd__decap_3
XFILLER_90_517 VGND VGND VPWR VPWR sky130_fd_sc_hd__decap_3
XFILLER_43_411 VGND VGND VPWR VPWR sky130_fd_sc_hd__decap_3
XFILLER_46_98 VGND VGND VPWR VPWR sky130_fd_sc_hd__decap_3
XFILLER_70_296 VGND VGND VPWR VPWR sky130_fd_sc_hd__decap_3
XTAP_TAPCELL_ROW_13_325 VGND VPWR sky130_fd_sc_hd__tapvpwrvgnd_1
XFILLER_7_15 VGND VGND VPWR VPWR sky130_fd_sc_hd__decap_3
XFILLER_7_48 VGND VGND VPWR VPWR sky130_fd_sc_hd__decap_3
XFILLER_7_356 VGND VGND VPWR VPWR sky130_fd_sc_hd__decap_3
XFILLER_7_378 VGND VGND VPWR VPWR sky130_fd_sc_hd__decap_3
XFILLER_3_540 VGND VGND VPWR VPWR sky130_fd_sc_hd__decap_3
XFILLER_23_6 VGND VGND VPWR VPWR sky130_fd_sc_hd__decap_3
XFILLER_87_83 VGND VGND VPWR VPWR sky130_fd_sc_hd__fill_1
XFILLER_78_330 VGND VGND VPWR VPWR sky130_fd_sc_hd__decap_3
XFILLER_66_525 VGND VGND VPWR VPWR sky130_fd_sc_hd__decap_3
XFILLER_66_536 VGND VGND VPWR VPWR sky130_fd_sc_hd__decap_3
XFILLER_78_396 VGND VGND VPWR VPWR sky130_fd_sc_hd__decap_3
XFILLER_19_430 VGND VGND VPWR VPWR sky130_fd_sc_hd__fill_1
XFILLER_53_219 VGND VGND VPWR VPWR sky130_fd_sc_hd__decap_3
XFILLER_93_377 VGND VGND VPWR VPWR sky130_fd_sc_hd__decap_3
XFILLER_81_539 VGND VGND VPWR VPWR sky130_fd_sc_hd__decap_3
XFILLER_81_517 VGND VGND VPWR VPWR sky130_fd_sc_hd__fill_1
XFILLER_34_411 VGND VGND VPWR VPWR sky130_fd_sc_hd__decap_3
XFILLER_34_433 VGND VGND VPWR VPWR sky130_fd_sc_hd__decap_3
XTAP_TAPCELL_ROW_29_480 VGND VPWR sky130_fd_sc_hd__tapvpwrvgnd_1
XFILLER_34_477 VGND VGND VPWR VPWR sky130_fd_sc_hd__decap_3
XFILLER_61_252 VGND VGND VPWR VPWR sky130_fd_sc_hd__decap_3
XFILLER_21_116 VGND VGND VPWR VPWR sky130_fd_sc_hd__fill_2
XFILLER_34_499 VGND VGND VPWR VPWR sky130_fd_sc_hd__decap_3
X_2983_ _2941_/X _2984_/A2 _2968_/Y _4913_/Q VGND VGND VPWR VPWR _4913_/D sky130_fd_sc_hd__a22o_2
X_4722_ _4804_/A _4722_/B VGND VGND VPWR VPWR _4722_/Y sky130_fd_sc_hd__nand2_2
X_4653_ _5227_/Q _4850_/B VGND VGND VPWR VPWR _4653_/Y sky130_fd_sc_hd__nand2_2
Xinput40 MEM_LD_DATA[1] VGND VGND VPWR VPWR input40/X sky130_fd_sc_hd__clkdlybuf4s25_1
X_4584_ _4687_/A _4580_/Y _4583_/X _4641_/B VGND VGND VPWR VPWR _4584_/X sky130_fd_sc_hd__o22a_2
X_3604_ _5109_/Q _4997_/Q _4981_/Q _4965_/Q _3834_/S0 _3834_/S1 VGND VGND VPWR VPWR
+ _3604_/X sky130_fd_sc_hd__mux4_2
X_3535_ _3585_/A _3533_/Y _3537_/B _4168_/A _2423_/Y VGND VGND VPWR VPWR _3536_/B
+ sky130_fd_sc_hd__o32a_2
X_3466_ _5186_/Q _4168_/A _3454_/X _3448_/B VGND VGND VPWR VPWR _5186_/D sky130_fd_sc_hd__o211a_2
XFILLER_88_105 VGND VGND VPWR VPWR sky130_fd_sc_hd__decap_3
X_5205_ _5262_/CLK _5205_/D VGND VGND VPWR VPWR _5205_/Q sky130_fd_sc_hd__dfxtp_2
XFILLER_69_352 VGND VGND VPWR VPWR sky130_fd_sc_hd__decap_3
X_3397_ _5167_/Q _3397_/B VGND VGND VPWR VPWR _3397_/X sky130_fd_sc_hd__xor2_2
XFILLER_57_514 VGND VGND VPWR VPWR sky130_fd_sc_hd__decap_3
XFILLER_69_396 VGND VGND VPWR VPWR sky130_fd_sc_hd__fill_2
X_5136_ _5177_/CLK _5136_/D VGND VGND VPWR VPWR _5136_/Q sky130_fd_sc_hd__dfxtp_2
X_5067_ _5106_/CLK _5067_/D VGND VGND VPWR VPWR _5067_/Q sky130_fd_sc_hd__dfxtp_2
XFILLER_44_219 VGND VGND VPWR VPWR sky130_fd_sc_hd__decap_3
XFILLER_72_528 VGND VGND VPWR VPWR sky130_fd_sc_hd__decap_3
X_4018_ _5207_/Q _4850_/B _4016_/X _4017_/X VGND VGND VPWR VPWR _4019_/B sky130_fd_sc_hd__o2bb2a_2
XTAP_TAPCELL_ROW_55_726 VGND VPWR sky130_fd_sc_hd__tapvpwrvgnd_1
XFILLER_84_377 VGND VGND VPWR VPWR sky130_fd_sc_hd__decap_3
XFILLER_16_35 VGND VGND VPWR VPWR sky130_fd_sc_hd__decap_3
XFILLER_72_539 VGND VGND VPWR VPWR sky130_fd_sc_hd__decap_3
XFILLER_84_399 VGND VGND VPWR VPWR sky130_fd_sc_hd__decap_3
XFILLER_25_466 VGND VGND VPWR VPWR sky130_fd_sc_hd__fill_2
XFILLER_80_550 VGND VGND VPWR VPWR sky130_fd_sc_hd__decap_3
XFILLER_12_127 VGND VGND VPWR VPWR sky130_fd_sc_hd__decap_3
XFILLER_40_436 VGND VGND VPWR VPWR sky130_fd_sc_hd__decap_3
XFILLER_52_274 VGND VGND VPWR VPWR sky130_fd_sc_hd__decap_3
XFILLER_20_171 VGND VGND VPWR VPWR sky130_fd_sc_hd__decap_3
XFILLER_4_315 VGND VGND VPWR VPWR sky130_fd_sc_hd__decap_3
XFILLER_57_42 VGND VGND VPWR VPWR sky130_fd_sc_hd__decap_3
XFILLER_75_311 VGND VGND VPWR VPWR sky130_fd_sc_hd__fill_2
XFILLER_57_75 VGND VGND VPWR VPWR sky130_fd_sc_hd__decap_3
XFILLER_75_355 VGND VGND VPWR VPWR sky130_fd_sc_hd__decap_3
XFILLER_63_517 VGND VGND VPWR VPWR sky130_fd_sc_hd__decap_3
XFILLER_75_388 VGND VGND VPWR VPWR sky130_fd_sc_hd__decap_3
XFILLER_43_252 VGND VGND VPWR VPWR sky130_fd_sc_hd__decap_3
XFILLER_73_74 VGND VGND VPWR VPWR sky130_fd_sc_hd__decap_3
XFILLER_16_477 VGND VGND VPWR VPWR sky130_fd_sc_hd__decap_3
XTAP_TAPCELL_ROW_26_450 VGND VPWR sky130_fd_sc_hd__tapvpwrvgnd_1
XFILLER_31_469 VGND VGND VPWR VPWR sky130_fd_sc_hd__decap_3
XFILLER_43_296 VGND VGND VPWR VPWR sky130_fd_sc_hd__decap_3
XFILLER_7_175 VGND VGND VPWR VPWR sky130_fd_sc_hd__fill_1
X_3320_ _3315_/Y _3316_/X _3319_/Y _3265_/Y VGND VGND VPWR VPWR _3320_/X sky130_fd_sc_hd__a22o_2
X_3251_ _5174_/Q _3252_/C _3250_/X _3448_/B VGND VGND VPWR VPWR _5133_/D sky130_fd_sc_hd__o211a_2
XFILLER_21_3 VGND VGND VPWR VPWR sky130_fd_sc_hd__decap_3
XFILLER_39_514 VGND VGND VPWR VPWR sky130_fd_sc_hd__decap_3
X_3182_ _2926_/X _3185_/A2 _3185_/B1 _5084_/Q VGND VGND VPWR VPWR _5084_/D sky130_fd_sc_hd__a22o_2
XFILLER_66_344 VGND VGND VPWR VPWR sky130_fd_sc_hd__decap_3
XFILLER_78_182 VGND VGND VPWR VPWR sky130_fd_sc_hd__fill_1
XFILLER_54_517 VGND VGND VPWR VPWR sky130_fd_sc_hd__decap_3
XFILLER_93_141 VGND VGND VPWR VPWR sky130_fd_sc_hd__decap_3
XFILLER_81_314 VGND VGND VPWR VPWR sky130_fd_sc_hd__decap_3
XFILLER_34_241 VGND VGND VPWR VPWR sky130_fd_sc_hd__decap_3
X_2966_ _5189_/Q _5188_/Q VGND VGND VPWR VPWR _3004_/B sky130_fd_sc_hd__nand2b_2
XTAP_TAPCELL_ROW_60_773 VGND VPWR sky130_fd_sc_hd__tapvpwrvgnd_1
XFILLER_30_480 VGND VGND VPWR VPWR sky130_fd_sc_hd__decap_3
X_4705_ _4196_/A _4246_/A _4703_/Y _4704_/X VGND VGND VPWR VPWR _4705_/X sky130_fd_sc_hd__o211a_2
X_2897_ _4866_/A _2897_/B VGND VGND VPWR VPWR _2897_/Y sky130_fd_sc_hd__nor2_2
X_4636_ _3934_/B _4493_/A _4787_/S VGND VGND VPWR VPWR _4636_/X sky130_fd_sc_hd__mux2_1
X_4567_ _4567_/A _4567_/B _4567_/C VGND VGND VPWR VPWR _4568_/B sky130_fd_sc_hd__nor3_2
XFILLER_89_414 VGND VGND VPWR VPWR sky130_fd_sc_hd__decap_3
X_4498_ _4498_/A _4498_/B VGND VGND VPWR VPWR _4498_/Y sky130_fd_sc_hd__nand2_2
X_3518_ _3518_/A _3518_/B VGND VGND VPWR VPWR _3519_/B sky130_fd_sc_hd__nand2_2
X_3449_ _5182_/Q _3226_/Y _3228_/Y _3448_/X VGND VGND VPWR VPWR _5182_/D sky130_fd_sc_hd__o22a_2
XFILLER_57_322 VGND VGND VPWR VPWR sky130_fd_sc_hd__fill_2
X_5119_ _5119_/CLK _5119_/D VGND VGND VPWR VPWR _5119_/Q sky130_fd_sc_hd__dfxtp_2
XFILLER_45_517 VGND VGND VPWR VPWR sky130_fd_sc_hd__decap_3
XFILLER_72_303 VGND VGND VPWR VPWR sky130_fd_sc_hd__decap_3
XTAP_TAPCELL_ROW_68_851 VGND VPWR sky130_fd_sc_hd__tapvpwrvgnd_1
XFILLER_57_388 VGND VGND VPWR VPWR sky130_fd_sc_hd__decap_3
XFILLER_57_399 VGND VGND VPWR VPWR sky130_fd_sc_hd__decap_3
XFILLER_53_550 VGND VGND VPWR VPWR sky130_fd_sc_hd__decap_3
XFILLER_60_509 VGND VGND VPWR VPWR sky130_fd_sc_hd__decap_3
XFILLER_13_425 VGND VGND VPWR VPWR sky130_fd_sc_hd__decap_3
XFILLER_25_252 VGND VGND VPWR VPWR sky130_fd_sc_hd__decap_3
XFILLER_40_244 VGND VGND VPWR VPWR sky130_fd_sc_hd__decap_3
XTAP_TAPCELL_ROW_23_420 VGND VPWR sky130_fd_sc_hd__tapvpwrvgnd_1
XFILLER_80_380 VGND VGND VPWR VPWR sky130_fd_sc_hd__decap_3
XFILLER_40_299 VGND VGND VPWR VPWR sky130_fd_sc_hd__decap_3
XFILLER_4_112 VGND VGND VPWR VPWR sky130_fd_sc_hd__decap_3
XFILLER_68_63 VGND VGND VPWR VPWR sky130_fd_sc_hd__fill_2
XFILLER_0_362 VGND VGND VPWR VPWR sky130_fd_sc_hd__fill_2
XFILLER_68_85 VGND VGND VPWR VPWR sky130_fd_sc_hd__fill_2
XFILLER_48_333 VGND VGND VPWR VPWR sky130_fd_sc_hd__decap_3
XFILLER_88_480 VGND VGND VPWR VPWR sky130_fd_sc_hd__decap_3
XFILLER_36_517 VGND VGND VPWR VPWR sky130_fd_sc_hd__decap_3
XFILLER_63_303 VGND VGND VPWR VPWR sky130_fd_sc_hd__decap_3
XFILLER_63_314 VGND VGND VPWR VPWR sky130_fd_sc_hd__decap_3
XFILLER_90_144 VGND VGND VPWR VPWR sky130_fd_sc_hd__fill_1
XFILLER_71_391 VGND VGND VPWR VPWR sky130_fd_sc_hd__fill_1
X_2820_ _5133_/Q _2820_/B VGND VGND VPWR VPWR _2820_/X sky130_fd_sc_hd__or2_2
X_2751_ _5134_/Q _2746_/X _2748_/X _2750_/X VGND VGND VPWR VPWR _3280_/B sky130_fd_sc_hd__a22o_2
X_2682_ _2665_/A _2678_/A _2681_/X _2663_/Y VGND VGND VPWR VPWR _2881_/C sky130_fd_sc_hd__a31o_2
XFILLER_8_462 VGND VGND VPWR VPWR sky130_fd_sc_hd__decap_3
X_4421_ _4624_/A _4421_/B _4421_/C VGND VGND VPWR VPWR _4421_/X sky130_fd_sc_hd__and3b_2
X_4352_ _4335_/Y _4336_/X _4351_/X VGND VGND VPWR VPWR _4352_/Y sky130_fd_sc_hd__o21ai_2
X_4283_ _5217_/Q _4700_/S _4281_/Y _4282_/Y _3442_/B VGND VGND VPWR VPWR _5217_/D
+ sky130_fd_sc_hd__o221a_2
X_3303_ _3283_/A _3283_/B _3293_/B _3294_/A VGND VGND VPWR VPWR _3303_/X sky130_fd_sc_hd__a211o_2
XFILLER_58_108 VGND VGND VPWR VPWR sky130_fd_sc_hd__decap_3
X_3234_ _5170_/Q _3252_/C _3228_/Y _3233_/X VGND VGND VPWR VPWR _5125_/D sky130_fd_sc_hd__o22a_2
XFILLER_86_439 VGND VGND VPWR VPWR sky130_fd_sc_hd__decap_3
XFILLER_39_322 VGND VGND VPWR VPWR sky130_fd_sc_hd__decap_3
XFILLER_66_141 VGND VGND VPWR VPWR sky130_fd_sc_hd__decap_3
X_3165_ _2929_/X _3170_/A2 _3170_/B1 _5069_/Q VGND VGND VPWR VPWR _5069_/D sky130_fd_sc_hd__a22o_2
XFILLER_39_388 VGND VGND VPWR VPWR sky130_fd_sc_hd__decap_3
XFILLER_39_399 VGND VGND VPWR VPWR sky130_fd_sc_hd__decap_3
X_3096_ _2944_/X _3080_/B _3096_/B1 _5010_/Q VGND VGND VPWR VPWR _5010_/D sky130_fd_sc_hd__a22o_2
XTAP_TAPCELL_ROW_65_821 VGND VPWR sky130_fd_sc_hd__tapvpwrvgnd_1
XFILLER_81_111 VGND VGND VPWR VPWR sky130_fd_sc_hd__fill_1
XTAP_TAPCELL_ROW_37_556 VGND VPWR sky130_fd_sc_hd__tapvpwrvgnd_1
XFILLER_81_144 VGND VGND VPWR VPWR sky130_fd_sc_hd__decap_3
XFILLER_81_133 VGND VGND VPWR VPWR sky130_fd_sc_hd__decap_3
XFILLER_50_520 VGND VGND VPWR VPWR sky130_fd_sc_hd__fill_2
X_3998_ _3999_/A _3999_/B VGND VGND VPWR VPWR _3998_/Y sky130_fd_sc_hd__nor2_2
X_2949_ _2891_/X _2961_/A2 _2961_/B1 _4883_/Q VGND VGND VPWR VPWR _4883_/D sky130_fd_sc_hd__a22o_2
X_4619_ _4619_/A _4624_/A VGND VGND VPWR VPWR _4619_/Y sky130_fd_sc_hd__nor2_2
XFILLER_89_255 VGND VGND VPWR VPWR sky130_fd_sc_hd__decap_3
XFILLER_49_108 VGND VGND VPWR VPWR sky130_fd_sc_hd__decap_3
XFILLER_49_119 VGND VGND VPWR VPWR sky130_fd_sc_hd__decap_3
XFILLER_77_417 VGND VGND VPWR VPWR sky130_fd_sc_hd__decap_3
XFILLER_45_325 VGND VGND VPWR VPWR sky130_fd_sc_hd__decap_3
XFILLER_85_472 VGND VGND VPWR VPWR sky130_fd_sc_hd__decap_3
XFILLER_45_347 VGND VGND VPWR VPWR sky130_fd_sc_hd__decap_3
XFILLER_54_32 VGND VGND VPWR VPWR sky130_fd_sc_hd__fill_2
XFILLER_72_144 VGND VGND VPWR VPWR sky130_fd_sc_hd__decap_3
XFILLER_54_54 VGND VGND VPWR VPWR sky130_fd_sc_hd__decap_3
XFILLER_13_222 VGND VGND VPWR VPWR sky130_fd_sc_hd__fill_2
XFILLER_41_531 VGND VGND VPWR VPWR sky130_fd_sc_hd__decap_3
XTAP_TAPCELL_ROW_0_192 VGND VPWR sky130_fd_sc_hd__tapvpwrvgnd_1
XFILLER_13_266 VGND VGND VPWR VPWR sky130_fd_sc_hd__decap_3
XTAP_TAPCELL_ROW_71_879 VGND VPWR sky130_fd_sc_hd__tapvpwrvgnd_1
XFILLER_9_237 VGND VGND VPWR VPWR sky130_fd_sc_hd__decap_3
XFILLER_70_64 VGND VGND VPWR VPWR sky130_fd_sc_hd__decap_3
Xclkload29 _5078_/CLK VGND VGND VPWR VPWR clkload29/Y sky130_fd_sc_hd__clkinv_2
Xclkload18 _5200_/CLK VGND VGND VPWR VPWR clkload18/X sky130_fd_sc_hd__clkbuf_8
XFILLER_5_487 VGND VGND VPWR VPWR sky130_fd_sc_hd__decap_3
XFILLER_79_51 VGND VGND VPWR VPWR sky130_fd_sc_hd__decap_3
XTAP_TAPCELL_ROW_8_281 VGND VPWR sky130_fd_sc_hd__tapvpwrvgnd_1
XFILLER_0_181 VGND VGND VPWR VPWR sky130_fd_sc_hd__decap_3
XFILLER_48_141 VGND VGND VPWR VPWR sky130_fd_sc_hd__decap_3
XFILLER_83_409 VGND VGND VPWR VPWR sky130_fd_sc_hd__decap_3
XFILLER_36_303 VGND VGND VPWR VPWR sky130_fd_sc_hd__decap_3
XFILLER_48_185 VGND VGND VPWR VPWR sky130_fd_sc_hd__decap_3
XFILLER_63_100 VGND VGND VPWR VPWR sky130_fd_sc_hd__fill_2
XFILLER_63_111 VGND VGND VPWR VPWR sky130_fd_sc_hd__fill_1
XFILLER_76_483 VGND VGND VPWR VPWR sky130_fd_sc_hd__decap_3
XFILLER_91_442 VGND VGND VPWR VPWR sky130_fd_sc_hd__decap_3
XFILLER_17_550 VGND VGND VPWR VPWR sky130_fd_sc_hd__decap_3
X_4970_ _5119_/CLK _4970_/D VGND VGND VPWR VPWR _4970_/Q sky130_fd_sc_hd__dfxtp_2
XFILLER_32_542 VGND VGND VPWR VPWR sky130_fd_sc_hd__decap_3
XFILLER_44_380 VGND VGND VPWR VPWR sky130_fd_sc_hd__decap_3
X_3921_ _3682_/D _3920_/X _3917_/X VGND VGND VPWR VPWR _3922_/B sky130_fd_sc_hd__o21a_2
XTAP_TAPCELL_ROW_34_526 VGND VPWR sky130_fd_sc_hd__tapvpwrvgnd_1
X_3852_ _3867_/A _4642_/A VGND VGND VPWR VPWR _4408_/S sky130_fd_sc_hd__nor2_2
X_2803_ _5117_/Q _5005_/Q _4989_/Q _4973_/Q _5131_/Q _2848_/S1 VGND VGND VPWR VPWR
+ _2803_/X sky130_fd_sc_hd__mux4_2
X_3783_ _5065_/Q _5049_/Q _5033_/Q _5017_/Q _5127_/Q _3834_/S1 VGND VGND VPWR VPWR
+ _3784_/B sky130_fd_sc_hd__mux4_2
X_2734_ _2851_/A _3256_/B VGND VGND VPWR VPWR _2734_/X sky130_fd_sc_hd__and2_2
X_2665_ _2665_/A _2665_/B VGND VGND VPWR VPWR _3922_/A sky130_fd_sc_hd__and2_2
X_4404_ _4402_/X _4403_/Y _4404_/S VGND VGND VPWR VPWR _4686_/S sky130_fd_sc_hd__mux2_1
X_2596_ _5125_/Q _2596_/B VGND VGND VPWR VPWR _2596_/X sky130_fd_sc_hd__or2_2
X_4335_ _4335_/A _4335_/B VGND VGND VPWR VPWR _4335_/Y sky130_fd_sc_hd__nor2_2
XFILLER_59_417 VGND VGND VPWR VPWR sky130_fd_sc_hd__decap_3
XFILLER_86_203 VGND VGND VPWR VPWR sky130_fd_sc_hd__fill_1
X_4266_ _4315_/B _4226_/X _4340_/A VGND VGND VPWR VPWR _4267_/B sky130_fd_sc_hd__mux2_1
XFILLER_86_247 VGND VGND VPWR VPWR sky130_fd_sc_hd__decap_3
X_4197_ _3682_/B _4198_/C VGND VGND VPWR VPWR _4223_/C sky130_fd_sc_hd__and2b_2
X_3217_ _2922_/X _3208_/B _3208_/Y _5115_/Q VGND VGND VPWR VPWR _5115_/D sky130_fd_sc_hd__a22o_2
XFILLER_67_494 VGND VGND VPWR VPWR sky130_fd_sc_hd__decap_3
X_3148_ _2932_/X _3152_/A2 _3136_/Y _5054_/Q VGND VGND VPWR VPWR _5054_/D sky130_fd_sc_hd__a22o_2
XFILLER_54_122 VGND VGND VPWR VPWR sky130_fd_sc_hd__decap_3
XFILLER_54_144 VGND VGND VPWR VPWR sky130_fd_sc_hd__decap_3
XFILLER_82_431 VGND VGND VPWR VPWR sky130_fd_sc_hd__decap_3
XFILLER_42_306 VGND VGND VPWR VPWR sky130_fd_sc_hd__fill_2
X_3079_ _3135_/A _3207_/B VGND VGND VPWR VPWR _3080_/B sky130_fd_sc_hd__nor2_2
XFILLER_82_475 VGND VGND VPWR VPWR sky130_fd_sc_hd__fill_1
XFILLER_23_520 VGND VGND VPWR VPWR sky130_fd_sc_hd__decap_3
XFILLER_24_35 VGND VGND VPWR VPWR sky130_fd_sc_hd__decap_3
XFILLER_50_361 VGND VGND VPWR VPWR sky130_fd_sc_hd__decap_3
XFILLER_10_203 VGND VGND VPWR VPWR sky130_fd_sc_hd__decap_3
XFILLER_40_67 VGND VGND VPWR VPWR sky130_fd_sc_hd__decap_3
XFILLER_77_203 VGND VGND VPWR VPWR sky130_fd_sc_hd__decap_3
XFILLER_49_65 VGND VGND VPWR VPWR sky130_fd_sc_hd__fill_1
XFILLER_77_225 VGND VGND VPWR VPWR sky130_fd_sc_hd__decap_3
XTAP_TAPCELL_ROW_5_251 VGND VPWR sky130_fd_sc_hd__tapvpwrvgnd_1
XFILLER_58_483 VGND VGND VPWR VPWR sky130_fd_sc_hd__decap_3
XTAP_TAPCELL_ROW_76_927 VGND VPWR sky130_fd_sc_hd__tapvpwrvgnd_1
XFILLER_18_347 VGND VGND VPWR VPWR sky130_fd_sc_hd__decap_3
XFILLER_65_53 VGND VGND VPWR VPWR sky130_fd_sc_hd__decap_3
XTAP_TAPCELL_ROW_86_1023 VGND VPWR sky130_fd_sc_hd__tapvpwrvgnd_1
XFILLER_33_306 VGND VGND VPWR VPWR sky130_fd_sc_hd__decap_3
XFILLER_45_155 VGND VGND VPWR VPWR sky130_fd_sc_hd__decap_3
XFILLER_81_63 VGND VGND VPWR VPWR sky130_fd_sc_hd__decap_3
XFILLER_81_30 VGND VGND VPWR VPWR sky130_fd_sc_hd__decap_3
XFILLER_5_273 VGND VGND VPWR VPWR sky130_fd_sc_hd__decap_3
X_2450_ _5179_/Q _4171_/A VGND VGND VPWR VPWR _3457_/A sky130_fd_sc_hd__or2_2
XFILLER_5_284 VGND VGND VPWR VPWR sky130_fd_sc_hd__decap_3
X_4120_ _4095_/A _4095_/B _3839_/B VGND VGND VPWR VPWR _4121_/B sky130_fd_sc_hd__a21oi_2
X_4051_ _3930_/A _4313_/B _4048_/Y _4041_/X VGND VGND VPWR VPWR _4051_/X sky130_fd_sc_hd__a31o_2
XFILLER_83_206 VGND VGND VPWR VPWR sky130_fd_sc_hd__decap_3
Xinput5 INSTR_STREAM[13] VGND VGND VPWR VPWR input5/X sky130_fd_sc_hd__clkdlybuf4s25_1
X_3002_ _2941_/X _2987_/B _2987_/Y _4929_/Q VGND VGND VPWR VPWR _4929_/D sky130_fd_sc_hd__a22o_2
XFILLER_83_228 VGND VGND VPWR VPWR sky130_fd_sc_hd__decap_3
XFILLER_64_431 VGND VGND VPWR VPWR sky130_fd_sc_hd__fill_1
XFILLER_76_291 VGND VGND VPWR VPWR sky130_fd_sc_hd__decap_3
XFILLER_64_464 VGND VGND VPWR VPWR sky130_fd_sc_hd__decap_3
XTAP_TAPCELL_ROW_47_651 VGND VPWR sky130_fd_sc_hd__tapvpwrvgnd_1
XFILLER_91_272 VGND VGND VPWR VPWR sky130_fd_sc_hd__decap_3
X_4953_ _5007_/CLK _4953_/D VGND VGND VPWR VPWR _4953_/Q sky130_fd_sc_hd__dfxtp_2
XTAP_TAPCELL_ROW_19_386 VGND VPWR sky130_fd_sc_hd__tapvpwrvgnd_1
XFILLER_91_294 VGND VGND VPWR VPWR sky130_fd_sc_hd__decap_3
XFILLER_51_147 VGND VGND VPWR VPWR sky130_fd_sc_hd__decap_3
XFILLER_51_169 VGND VGND VPWR VPWR sky130_fd_sc_hd__decap_3
X_3904_ _3692_/B _4477_/A VGND VGND VPWR VPWR _3905_/B sky130_fd_sc_hd__nand2b_2
X_4884_ _5210_/CLK _4884_/D VGND VGND VPWR VPWR _4884_/Q sky130_fd_sc_hd__dfxtp_2
X_3835_ _3833_/X _3834_/X _5129_/Q VGND VGND VPWR VPWR _3835_/X sky130_fd_sc_hd__mux2_1
X_3766_ _4551_/A _3767_/B VGND VGND VPWR VPWR _4794_/S sky130_fd_sc_hd__nor2_2
X_2717_ _4884_/Q _4868_/Q _5092_/Q _5076_/Q _2812_/S0 _2848_/S1 VGND VGND VPWR VPWR
+ _2717_/X sky130_fd_sc_hd__mux4_2
X_3697_ _3831_/A _3696_/X _5130_/Q VGND VGND VPWR VPWR _3697_/X sky130_fd_sc_hd__o21a_2
X_2648_ _5160_/Q _4477_/A VGND VGND VPWR VPWR _4198_/A sky130_fd_sc_hd__and2_2
X_2579_ _5109_/Q _4997_/Q _4981_/Q _4965_/Q _2658_/S0 _2671_/S1 VGND VGND VPWR VPWR
+ _2579_/X sky130_fd_sc_hd__mux4_2
XFILLER_59_225 VGND VGND VPWR VPWR sky130_fd_sc_hd__decap_3
X_4318_ _4155_/A _4314_/Y _4317_/X _4128_/B _4200_/Y VGND VGND VPWR VPWR _4318_/X
+ sky130_fd_sc_hd__o32a_2
XFILLER_87_523 VGND VGND VPWR VPWR sky130_fd_sc_hd__decap_3
X_4249_ _4249_/A _4523_/S VGND VGND VPWR VPWR _4249_/Y sky130_fd_sc_hd__nand2_2
XFILLER_19_57 VGND VGND VPWR VPWR sky130_fd_sc_hd__decap_3
XTAP_TAPCELL_ROW_2_221 VGND VPWR sky130_fd_sc_hd__tapvpwrvgnd_1
XFILLER_55_420 VGND VGND VPWR VPWR sky130_fd_sc_hd__decap_3
XFILLER_15_317 VGND VGND VPWR VPWR sky130_fd_sc_hd__fill_1
XFILLER_27_166 VGND VGND VPWR VPWR sky130_fd_sc_hd__fill_2
XFILLER_42_103 VGND VGND VPWR VPWR sky130_fd_sc_hd__decap_3
XFILLER_70_401 VGND VGND VPWR VPWR sky130_fd_sc_hd__decap_3
XFILLER_70_445 VGND VGND VPWR VPWR sky130_fd_sc_hd__decap_3
XFILLER_82_283 VGND VGND VPWR VPWR sky130_fd_sc_hd__decap_3
XFILLER_30_309 VGND VGND VPWR VPWR sky130_fd_sc_hd__decap_3
XFILLER_42_158 VGND VGND VPWR VPWR sky130_fd_sc_hd__fill_2
XTAP_TAPCELL_ROW_81_974 VGND VPWR sky130_fd_sc_hd__tapvpwrvgnd_1
XFILLER_51_44 VGND VGND VPWR VPWR sky130_fd_sc_hd__decap_3
XFILLER_7_505 VGND VGND VPWR VPWR sky130_fd_sc_hd__decap_3
XFILLER_51_66 VGND VGND VPWR VPWR sky130_fd_sc_hd__decap_3
XTAP_TAPCELL_ROW_92_1071 VGND VPWR sky130_fd_sc_hd__tapvpwrvgnd_1
XFILLER_78_545 VGND VGND VPWR VPWR sky130_fd_sc_hd__decap_3
XFILLER_78_523 VGND VGND VPWR VPWR sky130_fd_sc_hd__decap_3
XFILLER_18_100 VGND VGND VPWR VPWR sky130_fd_sc_hd__fill_2
XFILLER_65_228 VGND VGND VPWR VPWR sky130_fd_sc_hd__fill_1
XFILLER_93_526 VGND VGND VPWR VPWR sky130_fd_sc_hd__decap_3
XFILLER_58_280 VGND VGND VPWR VPWR sky130_fd_sc_hd__decap_3
XFILLER_93_548 VGND VGND VPWR VPWR sky130_fd_sc_hd__decap_3
XFILLER_18_166 VGND VGND VPWR VPWR sky130_fd_sc_hd__decap_3
XFILLER_46_453 VGND VGND VPWR VPWR sky130_fd_sc_hd__decap_3
XFILLER_46_486 VGND VGND VPWR VPWR sky130_fd_sc_hd__decap_3
XFILLER_73_250 VGND VGND VPWR VPWR sky130_fd_sc_hd__decap_3
XFILLER_61_423 VGND VGND VPWR VPWR sky130_fd_sc_hd__fill_2
XFILLER_61_434 VGND VGND VPWR VPWR sky130_fd_sc_hd__decap_3
XTAP_TAPCELL_ROW_44_621 VGND VPWR sky130_fd_sc_hd__tapvpwrvgnd_1
XFILLER_33_169 VGND VGND VPWR VPWR sky130_fd_sc_hd__decap_3
XFILLER_61_467 VGND VGND VPWR VPWR sky130_fd_sc_hd__decap_3
XTAP_TAPCELL_ROW_16_356 VGND VPWR sky130_fd_sc_hd__tapvpwrvgnd_1
XFILLER_14_361 VGND VGND VPWR VPWR sky130_fd_sc_hd__decap_3
XFILLER_14_383 VGND VGND VPWR VPWR sky130_fd_sc_hd__fill_1
X_3620_ _3831_/A _3620_/B VGND VGND VPWR VPWR _3620_/X sky130_fd_sc_hd__or2_2
X_3551_ _4714_/A _3551_/B VGND VGND VPWR VPWR _5200_/D sky130_fd_sc_hd__nor2_2
X_2502_ _2685_/A VGND VGND VPWR VPWR _2502_/Y sky130_fd_sc_hd__inv_2
X_3482_ _4866_/A _3482_/B VGND VGND VPWR VPWR _5191_/D sky130_fd_sc_hd__nor2_2
X_5221_ _5221_/CLK _5221_/D VGND VGND VPWR VPWR _5221_/Q sky130_fd_sc_hd__dfxtp_2
X_2433_ _4714_/A VGND VGND VPWR VPWR _3442_/B sky130_fd_sc_hd__clkinv_2
XFILLER_69_545 VGND VGND VPWR VPWR sky130_fd_sc_hd__decap_3
X_5152_ clkload4/A _5152_/D VGND VGND VPWR VPWR _5152_/Q sky130_fd_sc_hd__dfxtp_2
X_4103_ _4173_/A _4103_/B VGND VGND VPWR VPWR _4103_/Y sky130_fd_sc_hd__nand2_2
XFILLER_84_504 VGND VGND VPWR VPWR sky130_fd_sc_hd__decap_3
XFILLER_56_217 VGND VGND VPWR VPWR sky130_fd_sc_hd__decap_3
X_5083_ _5121_/CLK _5083_/D VGND VGND VPWR VPWR _5083_/Q sky130_fd_sc_hd__dfxtp_2
XFILLER_84_515 VGND VGND VPWR VPWR sky130_fd_sc_hd__decap_3
XFILLER_56_239 VGND VGND VPWR VPWR sky130_fd_sc_hd__decap_3
X_4034_ _3657_/Y _3664_/X _4077_/S VGND VGND VPWR VPWR _4034_/X sky130_fd_sc_hd__mux2_1
XFILLER_84_548 VGND VGND VPWR VPWR sky130_fd_sc_hd__decap_3
XFILLER_71_209 VGND VGND VPWR VPWR sky130_fd_sc_hd__decap_3
XFILLER_24_114 VGND VGND VPWR VPWR sky130_fd_sc_hd__decap_3
XFILLER_37_486 VGND VGND VPWR VPWR sky130_fd_sc_hd__decap_3
XFILLER_52_412 VGND VGND VPWR VPWR sky130_fd_sc_hd__decap_3
XFILLER_64_272 VGND VGND VPWR VPWR sky130_fd_sc_hd__decap_3
XFILLER_52_489 VGND VGND VPWR VPWR sky130_fd_sc_hd__decap_3
X_4936_ _4982_/CLK _4936_/D VGND VGND VPWR VPWR _4936_/Q sky130_fd_sc_hd__dfxtp_2
X_4867_ _5109_/CLK _4867_/D VGND VGND VPWR VPWR _4867_/Q sky130_fd_sc_hd__dfxtp_2
X_3818_ _4466_/A _3820_/B VGND VGND VPWR VPWR _4664_/S sky130_fd_sc_hd__nor2_2
XTAP_TAPCELL_ROW_50_679 VGND VPWR sky130_fd_sc_hd__tapvpwrvgnd_1
XFILLER_20_386 VGND VGND VPWR VPWR sky130_fd_sc_hd__decap_3
X_4798_ _5236_/Q _4800_/B _4136_/Y _4797_/X VGND VGND VPWR VPWR _4799_/B sky130_fd_sc_hd__o2bb2a_2
XFILLER_21_69 VGND VGND VPWR VPWR sky130_fd_sc_hd__decap_3
X_3749_ _4959_/Q _4943_/Q _4927_/Q _4911_/Q _5127_/Q _3834_/S1 VGND VGND VPWR VPWR
+ _3749_/X sky130_fd_sc_hd__mux4_2
XFILLER_87_320 VGND VGND VPWR VPWR sky130_fd_sc_hd__decap_3
XFILLER_87_364 VGND VGND VPWR VPWR sky130_fd_sc_hd__decap_3
XFILLER_75_515 VGND VGND VPWR VPWR sky130_fd_sc_hd__decap_3
XTAP_TAPCELL_ROW_58_757 VGND VPWR sky130_fd_sc_hd__tapvpwrvgnd_1
XFILLER_46_77 VGND VGND VPWR VPWR sky130_fd_sc_hd__decap_3
XFILLER_55_250 VGND VGND VPWR VPWR sky130_fd_sc_hd__decap_3
XFILLER_90_529 VGND VGND VPWR VPWR sky130_fd_sc_hd__decap_3
XFILLER_46_88 VGND VGND VPWR VPWR sky130_fd_sc_hd__decap_3
XFILLER_55_272 VGND VGND VPWR VPWR sky130_fd_sc_hd__decap_3
XFILLER_15_169 VGND VGND VPWR VPWR sky130_fd_sc_hd__decap_3
XFILLER_43_445 VGND VGND VPWR VPWR sky130_fd_sc_hd__decap_3
XFILLER_43_467 VGND VGND VPWR VPWR sky130_fd_sc_hd__decap_3
XFILLER_62_65 VGND VGND VPWR VPWR sky130_fd_sc_hd__decap_3
XTAP_TAPCELL_ROW_13_326 VGND VPWR sky130_fd_sc_hd__tapvpwrvgnd_1
XFILLER_7_27 VGND VGND VPWR VPWR sky130_fd_sc_hd__decap_3
XFILLER_7_368 VGND VGND VPWR VPWR sky130_fd_sc_hd__fill_2
XFILLER_11_80 VGND VGND VPWR VPWR sky130_fd_sc_hd__decap_3
XFILLER_3_552 VGND VGND VPWR VPWR sky130_fd_sc_hd__fill_1
XFILLER_78_342 VGND VGND VPWR VPWR sky130_fd_sc_hd__decap_3
XFILLER_38_206 VGND VGND VPWR VPWR sky130_fd_sc_hd__fill_1
XFILLER_38_217 VGND VGND VPWR VPWR sky130_fd_sc_hd__fill_2
XFILLER_66_504 VGND VGND VPWR VPWR sky130_fd_sc_hd__decap_3
XFILLER_78_375 VGND VGND VPWR VPWR sky130_fd_sc_hd__decap_3
XFILLER_38_239 VGND VGND VPWR VPWR sky130_fd_sc_hd__decap_3
XFILLER_66_548 VGND VGND VPWR VPWR sky130_fd_sc_hd__decap_3
XFILLER_93_389 VGND VGND VPWR VPWR sky130_fd_sc_hd__decap_3
XFILLER_46_294 VGND VGND VPWR VPWR sky130_fd_sc_hd__decap_3
XTAP_TAPCELL_ROW_29_481 VGND VPWR sky130_fd_sc_hd__tapvpwrvgnd_1
XFILLER_34_445 VGND VGND VPWR VPWR sky130_fd_sc_hd__decap_3
XFILLER_61_231 VGND VGND VPWR VPWR sky130_fd_sc_hd__decap_3
XFILLER_21_106 VGND VGND VPWR VPWR sky130_fd_sc_hd__decap_3
XFILLER_61_264 VGND VGND VPWR VPWR sky130_fd_sc_hd__decap_3
X_2982_ _2938_/X _2984_/A2 _2968_/Y _4912_/Q VGND VGND VPWR VPWR _4912_/D sky130_fd_sc_hd__a22o_2
XFILLER_21_139 VGND VGND VPWR VPWR sky130_fd_sc_hd__decap_3
X_4721_ _4255_/A _3959_/X _4715_/Y _4720_/X VGND VGND VPWR VPWR _4721_/X sky130_fd_sc_hd__o211a_2
X_4652_ _4631_/Y _4651_/X _4866_/A VGND VGND VPWR VPWR _5226_/D sky130_fd_sc_hd__a21oi_2
Xinput30 INSTR_STREAM[7] VGND VGND VPWR VPWR _3425_/C sky130_fd_sc_hd__clkdlybuf4s25_1
X_3603_ _3831_/A _3600_/X _5130_/Q VGND VGND VPWR VPWR _3603_/X sky130_fd_sc_hd__o21a_2
X_4583_ _4582_/X _4672_/B _4686_/S VGND VGND VPWR VPWR _4583_/X sky130_fd_sc_hd__mux2_1
Xinput41 MEM_LD_DATA[2] VGND VGND VPWR VPWR input41/X sky130_fd_sc_hd__clkdlybuf4s25_1
X_3534_ _3534_/A _3534_/B _3534_/C VGND VGND VPWR VPWR _3537_/B sky130_fd_sc_hd__and3_2
X_3465_ _5185_/Q _4168_/A _3464_/X _3448_/B VGND VGND VPWR VPWR _5185_/D sky130_fd_sc_hd__o211a_2
X_5204_ _5251_/CLK _5204_/D VGND VGND VPWR VPWR _5204_/Q sky130_fd_sc_hd__dfxtp_2
XFILLER_88_139 VGND VGND VPWR VPWR sky130_fd_sc_hd__fill_1
XFILLER_88_117 VGND VGND VPWR VPWR sky130_fd_sc_hd__fill_2
X_3396_ _5256_/Q _5151_/Q _5148_/Q VGND VGND VPWR VPWR _3396_/Y sky130_fd_sc_hd__o21ai_2
XFILLER_69_364 VGND VGND VPWR VPWR sky130_fd_sc_hd__decap_3
X_5135_ _5254_/CLK _5135_/D VGND VGND VPWR VPWR _5135_/Q sky130_fd_sc_hd__dfxtp_2
X_5066_ _5114_/CLK _5066_/D VGND VGND VPWR VPWR _5066_/Q sky130_fd_sc_hd__dfxtp_2
XFILLER_72_507 VGND VGND VPWR VPWR sky130_fd_sc_hd__decap_3
X_4017_ _4716_/B _3914_/X _3916_/X _4850_/B VGND VGND VPWR VPWR _4017_/X sky130_fd_sc_hd__a31o_2
XFILLER_37_261 VGND VGND VPWR VPWR sky130_fd_sc_hd__decap_3
XTAP_TAPCELL_ROW_55_727 VGND VPWR sky130_fd_sc_hd__tapvpwrvgnd_1
XFILLER_52_231 VGND VGND VPWR VPWR sky130_fd_sc_hd__decap_3
XFILLER_52_253 VGND VGND VPWR VPWR sky130_fd_sc_hd__decap_3
XFILLER_40_404 VGND VGND VPWR VPWR sky130_fd_sc_hd__decap_3
XFILLER_52_286 VGND VGND VPWR VPWR sky130_fd_sc_hd__fill_1
XFILLER_40_448 VGND VGND VPWR VPWR sky130_fd_sc_hd__decap_3
X_4919_ _5116_/CLK _4919_/D VGND VGND VPWR VPWR _4919_/Q sky130_fd_sc_hd__dfxtp_2
XFILLER_32_24 VGND VGND VPWR VPWR sky130_fd_sc_hd__decap_3
XFILLER_20_183 VGND VGND VPWR VPWR sky130_fd_sc_hd__decap_3
XFILLER_4_327 VGND VGND VPWR VPWR sky130_fd_sc_hd__fill_2
XFILLER_0_522 VGND VGND VPWR VPWR sky130_fd_sc_hd__decap_3
XFILLER_0_533 VGND VGND VPWR VPWR sky130_fd_sc_hd__decap_3
XFILLER_87_172 VGND VGND VPWR VPWR sky130_fd_sc_hd__decap_3
XFILLER_87_150 VGND VGND VPWR VPWR sky130_fd_sc_hd__decap_3
XFILLER_75_323 VGND VGND VPWR VPWR sky130_fd_sc_hd__decap_3
XFILLER_63_529 VGND VGND VPWR VPWR sky130_fd_sc_hd__decap_3
XFILLER_75_367 VGND VGND VPWR VPWR sky130_fd_sc_hd__decap_3
XFILLER_28_283 VGND VGND VPWR VPWR sky130_fd_sc_hd__fill_2
XFILLER_90_326 VGND VGND VPWR VPWR sky130_fd_sc_hd__decap_3
XFILLER_16_445 VGND VGND VPWR VPWR sky130_fd_sc_hd__decap_3
XFILLER_31_404 VGND VGND VPWR VPWR sky130_fd_sc_hd__decap_3
XFILLER_73_86 VGND VGND VPWR VPWR sky130_fd_sc_hd__decap_3
XTAP_TAPCELL_ROW_26_451 VGND VPWR sky130_fd_sc_hd__tapvpwrvgnd_1
XFILLER_85_9 VGND VGND VPWR VPWR sky130_fd_sc_hd__decap_3
XFILLER_11_183 VGND VGND VPWR VPWR sky130_fd_sc_hd__decap_3
XFILLER_7_143 VGND VGND VPWR VPWR sky130_fd_sc_hd__decap_3
XFILLER_3_393 VGND VGND VPWR VPWR sky130_fd_sc_hd__decap_3
X_3250_ _5260_/Q input15/X _3227_/X VGND VGND VPWR VPWR _3250_/X sky130_fd_sc_hd__a21o_2
XFILLER_66_301 VGND VGND VPWR VPWR sky130_fd_sc_hd__decap_3
XFILLER_66_312 VGND VGND VPWR VPWR sky130_fd_sc_hd__decap_3
X_3181_ _2922_/X _3172_/B _3172_/Y _5083_/Q VGND VGND VPWR VPWR _5083_/D sky130_fd_sc_hd__a22o_2
XFILLER_78_150 VGND VGND VPWR VPWR sky130_fd_sc_hd__decap_3
XFILLER_14_3 VGND VGND VPWR VPWR sky130_fd_sc_hd__decap_3
XFILLER_26_209 VGND VGND VPWR VPWR sky130_fd_sc_hd__decap_3
XFILLER_66_356 VGND VGND VPWR VPWR sky130_fd_sc_hd__decap_3
XFILLER_19_261 VGND VGND VPWR VPWR sky130_fd_sc_hd__decap_3
XFILLER_93_197 VGND VGND VPWR VPWR sky130_fd_sc_hd__decap_3
XFILLER_81_337 VGND VGND VPWR VPWR sky130_fd_sc_hd__decap_3
XFILLER_81_326 VGND VGND VPWR VPWR sky130_fd_sc_hd__decap_3
XFILLER_19_294 VGND VGND VPWR VPWR sky130_fd_sc_hd__fill_2
XFILLER_62_551 VGND VGND VPWR VPWR sky130_fd_sc_hd__fill_2
XFILLER_22_415 VGND VGND VPWR VPWR sky130_fd_sc_hd__decap_3
XFILLER_34_264 VGND VGND VPWR VPWR sky130_fd_sc_hd__decap_3
XFILLER_34_286 VGND VGND VPWR VPWR sky130_fd_sc_hd__decap_3
X_4704_ _3457_/A _4546_/A _4704_/S VGND VGND VPWR VPWR _4704_/X sky130_fd_sc_hd__mux2_1
X_2965_ _5187_/Q _5186_/Q _5184_/Q _5258_/D VGND VGND VPWR VPWR _3171_/B sky130_fd_sc_hd__nand4_2
XTAP_TAPCELL_ROW_60_774 VGND VPWR sky130_fd_sc_hd__tapvpwrvgnd_1
XFILLER_30_492 VGND VGND VPWR VPWR sky130_fd_sc_hd__decap_3
X_2896_ _3135_/A _2947_/A VGND VGND VPWR VPWR _2897_/B sky130_fd_sc_hd__nor2_2
X_4635_ _4806_/A _4635_/B VGND VGND VPWR VPWR _4635_/Y sky130_fd_sc_hd__nand2_2
X_4566_ _4567_/A _4567_/B _4567_/C VGND VGND VPWR VPWR _4568_/A sky130_fd_sc_hd__o21a_2
X_3517_ _3503_/A _3503_/B _3510_/B _3499_/X VGND VGND VPWR VPWR _3518_/B sky130_fd_sc_hd__a211o_2
X_4497_ _4435_/Y _4497_/B VGND VGND VPWR VPWR _4497_/X sky130_fd_sc_hd__and2b_2
X_3448_ _5260_/Q _3448_/B _3448_/C VGND VGND VPWR VPWR _3448_/X sky130_fd_sc_hd__and3_2
XFILLER_57_301 VGND VGND VPWR VPWR sky130_fd_sc_hd__decap_3
XFILLER_69_150 VGND VGND VPWR VPWR sky130_fd_sc_hd__decap_3
X_3379_ _3378_/A _3378_/B _3378_/C VGND VGND VPWR VPWR _3379_/Y sky130_fd_sc_hd__o21ai_2
XFILLER_69_172 VGND VGND VPWR VPWR sky130_fd_sc_hd__decap_3
X_5118_ _5118_/CLK _5118_/D VGND VGND VPWR VPWR _5118_/Q sky130_fd_sc_hd__dfxtp_2
XFILLER_27_35 VGND VGND VPWR VPWR sky130_fd_sc_hd__decap_3
XFILLER_57_367 VGND VGND VPWR VPWR sky130_fd_sc_hd__decap_3
XTAP_TAPCELL_ROW_68_852 VGND VPWR sky130_fd_sc_hd__tapvpwrvgnd_1
XFILLER_45_529 VGND VGND VPWR VPWR sky130_fd_sc_hd__fill_1
XFILLER_72_315 VGND VGND VPWR VPWR sky130_fd_sc_hd__decap_3
X_5049_ clkload8/A _5049_/D VGND VGND VPWR VPWR _5049_/Q sky130_fd_sc_hd__dfxtp_2
XFILLER_84_197 VGND VGND VPWR VPWR sky130_fd_sc_hd__decap_3
XFILLER_25_220 VGND VGND VPWR VPWR sky130_fd_sc_hd__decap_3
XFILLER_25_231 VGND VGND VPWR VPWR sky130_fd_sc_hd__decap_3
XFILLER_25_275 VGND VGND VPWR VPWR sky130_fd_sc_hd__decap_3
XFILLER_43_45 VGND VGND VPWR VPWR sky130_fd_sc_hd__decap_3
XTAP_TAPCELL_ROW_23_421 VGND VPWR sky130_fd_sc_hd__tapvpwrvgnd_1
XFILLER_40_278 VGND VGND VPWR VPWR sky130_fd_sc_hd__decap_3
XFILLER_88_470 VGND VGND VPWR VPWR sky130_fd_sc_hd__fill_1
XFILLER_0_374 VGND VGND VPWR VPWR sky130_fd_sc_hd__decap_3
XFILLER_48_312 VGND VGND VPWR VPWR sky130_fd_sc_hd__decap_3
XFILLER_88_492 VGND VGND VPWR VPWR sky130_fd_sc_hd__decap_3
XFILLER_48_378 VGND VGND VPWR VPWR sky130_fd_sc_hd__decap_3
XFILLER_75_131 VGND VGND VPWR VPWR sky130_fd_sc_hd__fill_2
XFILLER_75_153 VGND VGND VPWR VPWR sky130_fd_sc_hd__decap_3
XTAP_TAPCELL_ROW_89_1043 VGND VPWR sky130_fd_sc_hd__tapvpwrvgnd_1
XFILLER_63_337 VGND VGND VPWR VPWR sky130_fd_sc_hd__decap_3
XFILLER_75_175 VGND VGND VPWR VPWR sky130_fd_sc_hd__decap_3
XFILLER_44_540 VGND VGND VPWR VPWR sky130_fd_sc_hd__fill_1
XFILLER_63_359 VGND VGND VPWR VPWR sky130_fd_sc_hd__decap_3
XFILLER_84_85 VGND VGND VPWR VPWR sky130_fd_sc_hd__fill_2
XFILLER_31_201 VGND VGND VPWR VPWR sky130_fd_sc_hd__decap_3
XFILLER_71_370 VGND VGND VPWR VPWR sky130_fd_sc_hd__decap_3
XFILLER_90_178 VGND VGND VPWR VPWR sky130_fd_sc_hd__decap_3
XFILLER_31_234 VGND VGND VPWR VPWR sky130_fd_sc_hd__decap_3
X_2750_ _5133_/Q _2749_/X _2437_/Y VGND VGND VPWR VPWR _2750_/X sky130_fd_sc_hd__o21a_2
XFILLER_8_430 VGND VGND VPWR VPWR sky130_fd_sc_hd__decap_3
X_2681_ _4242_/A _2681_/B VGND VGND VPWR VPWR _2681_/X sky130_fd_sc_hd__or2_2
XFILLER_8_441 VGND VGND VPWR VPWR sky130_fd_sc_hd__decap_3
X_4420_ _4067_/A _4493_/A _4523_/S VGND VGND VPWR VPWR _4420_/X sky130_fd_sc_hd__mux2_1
X_4351_ _4337_/Y _4338_/X _4345_/X _4350_/X VGND VGND VPWR VPWR _4351_/X sky130_fd_sc_hd__o211a_2
X_4282_ _4115_/A _2880_/B _4277_/X VGND VGND VPWR VPWR _4282_/Y sky130_fd_sc_hd__o21ai_2
X_3302_ _5158_/Q _3302_/B VGND VGND VPWR VPWR _3302_/X sky130_fd_sc_hd__xor2_2
X_3233_ _5260_/Q _3448_/B _3233_/C VGND VGND VPWR VPWR _3233_/X sky130_fd_sc_hd__and3_2
XFILLER_86_418 VGND VGND VPWR VPWR sky130_fd_sc_hd__fill_2
XFILLER_39_334 VGND VGND VPWR VPWR sky130_fd_sc_hd__fill_2
XFILLER_39_356 VGND VGND VPWR VPWR sky130_fd_sc_hd__decap_3
XFILLER_39_367 VGND VGND VPWR VPWR sky130_fd_sc_hd__decap_3
X_3164_ _2926_/X _3170_/A2 _3170_/B1 _5068_/Q VGND VGND VPWR VPWR _5068_/D sky130_fd_sc_hd__a22o_2
XFILLER_54_315 VGND VGND VPWR VPWR sky130_fd_sc_hd__decap_3
XFILLER_66_175 VGND VGND VPWR VPWR sky130_fd_sc_hd__fill_2
X_3095_ _2941_/X _3080_/B _3080_/Y _5009_/Q VGND VGND VPWR VPWR _5009_/D sky130_fd_sc_hd__a22o_2
XTAP_TAPCELL_ROW_65_822 VGND VPWR sky130_fd_sc_hd__tapvpwrvgnd_1
XFILLER_66_197 VGND VGND VPWR VPWR sky130_fd_sc_hd__fill_1
XTAP_TAPCELL_ROW_37_557 VGND VPWR sky130_fd_sc_hd__tapvpwrvgnd_1
XFILLER_81_156 VGND VGND VPWR VPWR sky130_fd_sc_hd__decap_3
XFILLER_35_551 VGND VGND VPWR VPWR sky130_fd_sc_hd__fill_2
XFILLER_22_256 VGND VGND VPWR VPWR sky130_fd_sc_hd__fill_2
X_3997_ _4042_/A _3996_/Y _3993_/X _3991_/Y VGND VGND VPWR VPWR _4015_/B sky130_fd_sc_hd__o211ai_2
XFILLER_10_418 VGND VGND VPWR VPWR sky130_fd_sc_hd__fill_2
X_2948_ _4866_/A _2948_/B VGND VGND VPWR VPWR _2948_/Y sky130_fd_sc_hd__nor2_2
X_4618_ _4515_/X _4517_/X _4624_/A VGND VGND VPWR VPWR _4618_/X sky130_fd_sc_hd__mux2_1
X_2879_ _3922_/A _2879_/B VGND VGND VPWR VPWR _2880_/B sky130_fd_sc_hd__xnor2_2
X_4549_ _3729_/X _4662_/A _4360_/B _3992_/A _4548_/X VGND VGND VPWR VPWR _4549_/X
+ sky130_fd_sc_hd__a221o_2
XFILLER_1_138 VGND VGND VPWR VPWR sky130_fd_sc_hd__decap_3
XFILLER_89_234 VGND VGND VPWR VPWR sky130_fd_sc_hd__decap_3
XFILLER_89_267 VGND VGND VPWR VPWR sky130_fd_sc_hd__decap_3
XFILLER_45_337 VGND VGND VPWR VPWR sky130_fd_sc_hd__decap_3
XFILLER_45_359 VGND VGND VPWR VPWR sky130_fd_sc_hd__decap_3
XFILLER_72_123 VGND VGND VPWR VPWR sky130_fd_sc_hd__decap_3
XFILLER_54_66 VGND VGND VPWR VPWR sky130_fd_sc_hd__fill_1
XFILLER_60_307 VGND VGND VPWR VPWR sky130_fd_sc_hd__fill_1
XFILLER_60_318 VGND VGND VPWR VPWR sky130_fd_sc_hd__fill_2
XFILLER_72_156 VGND VGND VPWR VPWR sky130_fd_sc_hd__fill_2
XFILLER_72_189 VGND VGND VPWR VPWR sky130_fd_sc_hd__decap_3
XFILLER_13_234 VGND VGND VPWR VPWR sky130_fd_sc_hd__decap_3
XFILLER_53_370 VGND VGND VPWR VPWR sky130_fd_sc_hd__decap_3
XTAP_TAPCELL_ROW_0_193 VGND VPWR sky130_fd_sc_hd__tapvpwrvgnd_1
XFILLER_70_32 VGND VGND VPWR VPWR sky130_fd_sc_hd__decap_3
XFILLER_5_422 VGND VGND VPWR VPWR sky130_fd_sc_hd__decap_3
Xclkload19 _5251_/CLK VGND VGND VPWR VPWR clkload19/X sky130_fd_sc_hd__clkbuf_4
XFILLER_5_499 VGND VGND VPWR VPWR sky130_fd_sc_hd__decap_3
XFILLER_68_407 VGND VGND VPWR VPWR sky130_fd_sc_hd__decap_3
XFILLER_68_418 VGND VGND VPWR VPWR sky130_fd_sc_hd__fill_2
XTAP_TAPCELL_ROW_8_282 VGND VPWR sky130_fd_sc_hd__tapvpwrvgnd_1
XFILLER_0_193 VGND VGND VPWR VPWR sky130_fd_sc_hd__decap_3
XFILLER_76_440 VGND VGND VPWR VPWR sky130_fd_sc_hd__decap_3
XFILLER_91_410 VGND VGND VPWR VPWR sky130_fd_sc_hd__decap_3
XFILLER_48_197 VGND VGND VPWR VPWR sky130_fd_sc_hd__decap_3
XFILLER_51_329 VGND VGND VPWR VPWR sky130_fd_sc_hd__decap_3
XFILLER_63_178 VGND VGND VPWR VPWR sky130_fd_sc_hd__decap_3
X_3920_ _5161_/Q _4249_/A _3919_/Y VGND VGND VPWR VPWR _3920_/X sky130_fd_sc_hd__o21a_2
XFILLER_44_392 VGND VGND VPWR VPWR sky130_fd_sc_hd__decap_3
XTAP_TAPCELL_ROW_34_527 VGND VPWR sky130_fd_sc_hd__tapvpwrvgnd_1
X_3851_ _5177_/Q _5176_/Q _5178_/Q VGND VGND VPWR VPWR _4642_/A sky130_fd_sc_hd__or3b_2
X_3782_ _4889_/Q _4873_/Q _5097_/Q _5081_/Q _5127_/Q _3834_/S1 VGND VGND VPWR VPWR
+ _3782_/X sky130_fd_sc_hd__mux4_2
X_2802_ _2831_/S _2802_/B VGND VGND VPWR VPWR _2802_/X sky130_fd_sc_hd__or2_2
XFILLER_81_3 VGND VGND VPWR VPWR sky130_fd_sc_hd__decap_3
X_2733_ _5134_/Q _2728_/X _2730_/X _2732_/X VGND VGND VPWR VPWR _3256_/B sky130_fd_sc_hd__a22o_2
X_2664_ _5163_/Q _4429_/B VGND VGND VPWR VPWR _2665_/B sky130_fd_sc_hd__or2_2
X_4403_ _4403_/A _4406_/A VGND VGND VPWR VPWR _4403_/Y sky130_fd_sc_hd__xnor2_2
X_2595_ _4883_/Q _4867_/Q _5091_/Q _5075_/Q _2658_/S0 _2671_/S1 VGND VGND VPWR VPWR
+ _2596_/B sky130_fd_sc_hd__mux4_2
X_4334_ _3781_/A _3908_/Y _3912_/Y VGND VGND VPWR VPWR _4335_/B sky130_fd_sc_hd__a21oi_2
XFILLER_5_93 VGND VGND VPWR VPWR sky130_fd_sc_hd__decap_3
X_4265_ _4429_/B _4432_/B _4523_/S VGND VGND VPWR VPWR _4315_/B sky130_fd_sc_hd__mux2_1
XFILLER_39_142 VGND VGND VPWR VPWR sky130_fd_sc_hd__decap_3
X_4196_ _4196_/A _4196_/B VGND VGND VPWR VPWR _4196_/Y sky130_fd_sc_hd__xnor2_2
X_3216_ _2919_/X _3221_/A2 _3208_/Y _5114_/Q VGND VGND VPWR VPWR _5114_/D sky130_fd_sc_hd__a22o_2
XFILLER_39_175 VGND VGND VPWR VPWR sky130_fd_sc_hd__decap_3
XFILLER_67_473 VGND VGND VPWR VPWR sky130_fd_sc_hd__decap_3
X_3147_ _2929_/X _3152_/A2 _3136_/Y _5053_/Q VGND VGND VPWR VPWR _5053_/D sky130_fd_sc_hd__a22o_2
XFILLER_54_134 VGND VGND VPWR VPWR sky130_fd_sc_hd__decap_3
XFILLER_82_454 VGND VGND VPWR VPWR sky130_fd_sc_hd__decap_3
XFILLER_82_443 VGND VGND VPWR VPWR sky130_fd_sc_hd__decap_3
XFILLER_54_156 VGND VGND VPWR VPWR sky130_fd_sc_hd__decap_3
X_3078_ _3134_/A _3078_/B VGND VGND VPWR VPWR _3207_/B sky130_fd_sc_hd__or2_2
XFILLER_54_189 VGND VGND VPWR VPWR sky130_fd_sc_hd__decap_3
XPHY_EDGE_ROW_59_Left_153 VGND VGND VPWR VPWR sky130_fd_sc_hd__decap_3
XFILLER_24_25 VGND VGND VPWR VPWR sky130_fd_sc_hd__decap_3
XFILLER_24_47 VGND VGND VPWR VPWR sky130_fd_sc_hd__decap_3
XFILLER_10_215 VGND VGND VPWR VPWR sky130_fd_sc_hd__decap_3
XFILLER_50_384 VGND VGND VPWR VPWR sky130_fd_sc_hd__decap_3
XFILLER_10_248 VGND VGND VPWR VPWR sky130_fd_sc_hd__decap_3
XFILLER_10_259 VGND VGND VPWR VPWR sky130_fd_sc_hd__decap_3
XPHY_EDGE_ROW_68_Left_162 VGND VGND VPWR VPWR sky130_fd_sc_hd__decap_3
XFILLER_49_22 VGND VGND VPWR VPWR sky130_fd_sc_hd__decap_3
XFILLER_49_44 VGND VGND VPWR VPWR sky130_fd_sc_hd__decap_3
XFILLER_77_237 VGND VGND VPWR VPWR sky130_fd_sc_hd__decap_3
XTAP_TAPCELL_ROW_5_252 VGND VPWR sky130_fd_sc_hd__tapvpwrvgnd_1
XFILLER_77_259 VGND VGND VPWR VPWR sky130_fd_sc_hd__decap_3
XFILLER_18_304 VGND VGND VPWR VPWR sky130_fd_sc_hd__decap_3
XFILLER_18_315 VGND VGND VPWR VPWR sky130_fd_sc_hd__decap_3
XFILLER_73_410 VGND VGND VPWR VPWR sky130_fd_sc_hd__decap_3
XTAP_TAPCELL_ROW_76_928 VGND VPWR sky130_fd_sc_hd__tapvpwrvgnd_1
XFILLER_18_359 VGND VGND VPWR VPWR sky130_fd_sc_hd__decap_3
XFILLER_45_134 VGND VGND VPWR VPWR sky130_fd_sc_hd__decap_3
XFILLER_65_65 VGND VGND VPWR VPWR sky130_fd_sc_hd__decap_3
XFILLER_73_454 VGND VGND VPWR VPWR sky130_fd_sc_hd__decap_3
XFILLER_85_281 VGND VGND VPWR VPWR sky130_fd_sc_hd__decap_3
XFILLER_33_318 VGND VGND VPWR VPWR sky130_fd_sc_hd__decap_3
XFILLER_45_167 VGND VGND VPWR VPWR sky130_fd_sc_hd__fill_1
XFILLER_45_178 VGND VGND VPWR VPWR sky130_fd_sc_hd__decap_3
XFILLER_65_98 VGND VGND VPWR VPWR sky130_fd_sc_hd__fill_1
XPHY_EDGE_ROW_77_Left_171 VGND VGND VPWR VPWR sky130_fd_sc_hd__decap_3
XFILLER_73_498 VGND VGND VPWR VPWR sky130_fd_sc_hd__decap_3
XFILLER_81_42 VGND VGND VPWR VPWR sky130_fd_sc_hd__fill_1
XFILLER_41_373 VGND VGND VPWR VPWR sky130_fd_sc_hd__decap_3
XPHY_EDGE_ROW_86_Left_180 VGND VGND VPWR VPWR sky130_fd_sc_hd__decap_3
XFILLER_1_491 VGND VGND VPWR VPWR sky130_fd_sc_hd__decap_3
X_4050_ _4040_/A _3998_/Y _4000_/X _4048_/A _4049_/Y VGND VGND VPWR VPWR _4053_/C
+ sky130_fd_sc_hd__a221o_2
Xinput6 INSTR_STREAM[14] VGND VGND VPWR VPWR input6/X sky130_fd_sc_hd__clkdlybuf4s25_1
X_3001_ _2938_/X _2987_/B _2987_/Y _4928_/Q VGND VGND VPWR VPWR _4928_/D sky130_fd_sc_hd__a22o_2
XFILLER_76_270 VGND VGND VPWR VPWR sky130_fd_sc_hd__decap_3
XFILLER_36_112 VGND VGND VPWR VPWR sky130_fd_sc_hd__fill_1
XFILLER_24_318 VGND VGND VPWR VPWR sky130_fd_sc_hd__decap_3
XTAP_TAPCELL_ROW_47_652 VGND VPWR sky130_fd_sc_hd__tapvpwrvgnd_1
XFILLER_17_370 VGND VGND VPWR VPWR sky130_fd_sc_hd__decap_3
X_4952_ _4982_/CLK _4952_/D VGND VGND VPWR VPWR _4952_/Q sky130_fd_sc_hd__dfxtp_2
XFILLER_32_351 VGND VGND VPWR VPWR sky130_fd_sc_hd__decap_3
XFILLER_51_159 VGND VGND VPWR VPWR sky130_fd_sc_hd__decap_3
X_4883_ _5078_/CLK _4883_/D VGND VGND VPWR VPWR _4883_/Q sky130_fd_sc_hd__dfxtp_2
X_3903_ _4218_/A _3903_/B VGND VGND VPWR VPWR _3903_/Y sky130_fd_sc_hd__nor2_2
XFILLER_20_513 VGND VGND VPWR VPWR sky130_fd_sc_hd__fill_1
XFILLER_32_373 VGND VGND VPWR VPWR sky130_fd_sc_hd__decap_3
X_3834_ _4951_/Q _4935_/Q _4919_/Q _4903_/Q _3834_/S0 _3834_/S1 VGND VGND VPWR VPWR
+ _3834_/X sky130_fd_sc_hd__mux4_2
X_3765_ _3759_/X _3761_/X _3764_/X _2432_/Y VGND VGND VPWR VPWR _3767_/B sky130_fd_sc_hd__a22o_2
X_3696_ _5068_/Q _5052_/Q _5036_/Q _5020_/Q _3834_/S0 _3834_/S1 VGND VGND VPWR VPWR
+ _3696_/X sky130_fd_sc_hd__mux4_2
X_2716_ _2851_/A _3403_/B VGND VGND VPWR VPWR _2716_/X sky130_fd_sc_hd__and2_2
XFILLER_10_27 VGND VGND VPWR VPWR sky130_fd_sc_hd__fill_1
X_2647_ _2641_/X _2643_/X _2646_/X _2435_/Y VGND VGND VPWR VPWR _4477_/A sky130_fd_sc_hd__a22o_2
XFILLER_59_204 VGND VGND VPWR VPWR sky130_fd_sc_hd__decap_3
X_2578_ _4949_/Q _4933_/Q _4917_/Q _4901_/Q _2658_/S0 _2671_/S1 VGND VGND VPWR VPWR
+ _2578_/X sky130_fd_sc_hd__mux4_2
XFILLER_87_502 VGND VGND VPWR VPWR sky130_fd_sc_hd__fill_2
X_4317_ _4340_/A _4316_/X _4315_/Y _4339_/A VGND VGND VPWR VPWR _4317_/X sky130_fd_sc_hd__o211a_2
XFILLER_19_36 VGND VGND VPWR VPWR sky130_fd_sc_hd__fill_2
XFILLER_59_248 VGND VGND VPWR VPWR sky130_fd_sc_hd__decap_3
X_4248_ _4339_/A _4248_/B VGND VGND VPWR VPWR _4248_/Y sky130_fd_sc_hd__nor2_2
XTAP_TAPCELL_ROW_2_222 VGND VPWR sky130_fd_sc_hd__tapvpwrvgnd_1
XFILLER_67_281 VGND VGND VPWR VPWR sky130_fd_sc_hd__decap_3
X_4179_ _4369_/B _4179_/B VGND VGND VPWR VPWR _4179_/Y sky130_fd_sc_hd__nand2_2
XFILLER_82_240 VGND VGND VPWR VPWR sky130_fd_sc_hd__fill_1
XFILLER_42_115 VGND VGND VPWR VPWR sky130_fd_sc_hd__decap_3
XFILLER_70_413 VGND VGND VPWR VPWR sky130_fd_sc_hd__fill_2
XFILLER_70_424 VGND VGND VPWR VPWR sky130_fd_sc_hd__decap_3
XFILLER_82_295 VGND VGND VPWR VPWR sky130_fd_sc_hd__decap_3
XFILLER_23_340 VGND VGND VPWR VPWR sky130_fd_sc_hd__decap_3
XFILLER_70_457 VGND VGND VPWR VPWR sky130_fd_sc_hd__decap_3
XTAP_TAPCELL_ROW_81_975 VGND VPWR sky130_fd_sc_hd__tapvpwrvgnd_1
XFILLER_11_546 VGND VGND VPWR VPWR sky130_fd_sc_hd__decap_3
XFILLER_50_181 VGND VGND VPWR VPWR sky130_fd_sc_hd__decap_3
XFILLER_51_23 VGND VGND VPWR VPWR sky130_fd_sc_hd__decap_3
XPHY_EDGE_ROW_14_Right_14 VGND VGND VPWR VPWR sky130_fd_sc_hd__decap_3
XFILLER_51_78 VGND VGND VPWR VPWR sky130_fd_sc_hd__decap_3
XFILLER_2_200 VGND VGND VPWR VPWR sky130_fd_sc_hd__decap_3
XFILLER_2_233 VGND VGND VPWR VPWR sky130_fd_sc_hd__fill_2
XTAP_TAPCELL_ROW_92_1072 VGND VPWR sky130_fd_sc_hd__tapvpwrvgnd_1
XPHY_EDGE_ROW_23_Right_23 VGND VGND VPWR VPWR sky130_fd_sc_hd__decap_3
XFILLER_93_505 VGND VGND VPWR VPWR sky130_fd_sc_hd__decap_3
XFILLER_65_218 VGND VGND VPWR VPWR sky130_fd_sc_hd__decap_3
XFILLER_46_421 VGND VGND VPWR VPWR sky130_fd_sc_hd__decap_3
XFILLER_58_292 VGND VGND VPWR VPWR sky130_fd_sc_hd__decap_3
XFILLER_61_402 VGND VGND VPWR VPWR sky130_fd_sc_hd__decap_3
XFILLER_73_240 VGND VGND VPWR VPWR sky130_fd_sc_hd__decap_3
XFILLER_73_262 VGND VGND VPWR VPWR sky130_fd_sc_hd__fill_2
XFILLER_46_498 VGND VGND VPWR VPWR sky130_fd_sc_hd__decap_3
XFILLER_73_273 VGND VGND VPWR VPWR sky130_fd_sc_hd__decap_3
XFILLER_73_284 VGND VGND VPWR VPWR sky130_fd_sc_hd__decap_3
XTAP_TAPCELL_ROW_44_622 VGND VPWR sky130_fd_sc_hd__tapvpwrvgnd_1
XFILLER_92_41 VGND VGND VPWR VPWR sky130_fd_sc_hd__fill_1
XFILLER_33_137 VGND VGND VPWR VPWR sky130_fd_sc_hd__decap_3
XFILLER_61_446 VGND VGND VPWR VPWR sky130_fd_sc_hd__fill_2
XFILLER_61_479 VGND VGND VPWR VPWR sky130_fd_sc_hd__decap_3
XTAP_TAPCELL_ROW_16_357 VGND VPWR sky130_fd_sc_hd__tapvpwrvgnd_1
XPHY_EDGE_ROW_32_Right_32 VGND VGND VPWR VPWR sky130_fd_sc_hd__decap_3
XFILLER_92_85 VGND VGND VPWR VPWR sky130_fd_sc_hd__fill_1
X_3550_ _3585_/A _3548_/X _3549_/Y _4168_/A _2422_/Y VGND VGND VPWR VPWR _3551_/B
+ sky130_fd_sc_hd__o32a_2
X_2501_ _5165_/Q _4471_/A VGND VGND VPWR VPWR _2685_/A sky130_fd_sc_hd__or2_2
X_5220_ _5221_/CLK _5220_/D VGND VGND VPWR VPWR _5220_/Q sky130_fd_sc_hd__dfxtp_2
X_3481_ _3585_/A _3479_/X _3480_/Y _4168_/A _2424_/Y VGND VGND VPWR VPWR _3482_/B
+ sky130_fd_sc_hd__o32a_2
X_2432_ _5130_/Q VGND VGND VPWR VPWR _2432_/Y sky130_fd_sc_hd__inv_2
XPHY_EDGE_ROW_41_Right_41 VGND VGND VPWR VPWR sky130_fd_sc_hd__decap_3
XFILLER_69_524 VGND VGND VPWR VPWR sky130_fd_sc_hd__fill_1
X_5151_ _5262_/CLK _5151_/D VGND VGND VPWR VPWR _5151_/Q sky130_fd_sc_hd__dfxtp_2
X_4102_ _4095_/A _3998_/Y _4000_/X _3874_/A _4101_/X VGND VGND VPWR VPWR _4110_/C
+ sky130_fd_sc_hd__a221o_2
X_5082_ _5098_/CLK _5082_/D VGND VGND VPWR VPWR _5082_/Q sky130_fd_sc_hd__dfxtp_2
X_4033_ _4032_/X _4031_/X _4173_/A VGND VGND VPWR VPWR _4033_/X sky130_fd_sc_hd__mux2_1
XFILLER_37_410 VGND VGND VPWR VPWR sky130_fd_sc_hd__decap_3
XFILLER_49_270 VGND VGND VPWR VPWR sky130_fd_sc_hd__decap_3
XFILLER_49_281 VGND VGND VPWR VPWR sky130_fd_sc_hd__decap_3
XFILLER_24_104 VGND VGND VPWR VPWR sky130_fd_sc_hd__decap_3
XFILLER_24_126 VGND VGND VPWR VPWR sky130_fd_sc_hd__decap_3
XFILLER_52_424 VGND VGND VPWR VPWR sky130_fd_sc_hd__decap_3
XFILLER_64_284 VGND VGND VPWR VPWR sky130_fd_sc_hd__decap_3
XFILLER_64_295 VGND VGND VPWR VPWR sky130_fd_sc_hd__decap_3
XPHY_EDGE_ROW_50_Right_50 VGND VGND VPWR VPWR sky130_fd_sc_hd__decap_3
XFILLER_52_457 VGND VGND VPWR VPWR sky130_fd_sc_hd__decap_3
X_4935_ _4982_/CLK _4935_/D VGND VGND VPWR VPWR _4935_/Q sky130_fd_sc_hd__dfxtp_2
XFILLER_32_170 VGND VGND VPWR VPWR sky130_fd_sc_hd__decap_3
X_4866_ _4866_/A _4866_/B VGND VGND VPWR VPWR _5175_/D sky130_fd_sc_hd__nor2_2
X_4797_ _4419_/A _4671_/Y _4791_/X _4796_/X _4345_/X VGND VGND VPWR VPWR _4797_/X
+ sky130_fd_sc_hd__o2111a_2
X_3817_ _3811_/X _3813_/X _3816_/X _2432_/Y VGND VGND VPWR VPWR _3820_/B sky130_fd_sc_hd__a22o_2
XFILLER_20_398 VGND VGND VPWR VPWR sky130_fd_sc_hd__decap_3
X_3748_ _3831_/A _3745_/X _5130_/Q VGND VGND VPWR VPWR _3748_/X sky130_fd_sc_hd__o21a_2
X_3679_ _3999_/A _3679_/B VGND VGND VPWR VPWR _3874_/D sky130_fd_sc_hd__nand2_2
XFILLER_87_332 VGND VGND VPWR VPWR sky130_fd_sc_hd__decap_3
XFILLER_47_207 VGND VGND VPWR VPWR sky130_fd_sc_hd__decap_3
XFILLER_87_376 VGND VGND VPWR VPWR sky130_fd_sc_hd__decap_3
XFILLER_28_421 VGND VGND VPWR VPWR sky130_fd_sc_hd__decap_3
XFILLER_75_549 VGND VGND VPWR VPWR sky130_fd_sc_hd__decap_3
XFILLER_15_104 VGND VGND VPWR VPWR sky130_fd_sc_hd__decap_3
XFILLER_43_402 VGND VGND VPWR VPWR sky130_fd_sc_hd__decap_3
XFILLER_55_284 VGND VGND VPWR VPWR sky130_fd_sc_hd__decap_3
XFILLER_70_276 VGND VGND VPWR VPWR sky130_fd_sc_hd__fill_2
XFILLER_70_287 VGND VGND VPWR VPWR sky130_fd_sc_hd__decap_3
XFILLER_11_310 VGND VGND VPWR VPWR sky130_fd_sc_hd__decap_3
XFILLER_23_181 VGND VGND VPWR VPWR sky130_fd_sc_hd__fill_2
XTAP_TAPCELL_ROW_13_327 VGND VPWR sky130_fd_sc_hd__tapvpwrvgnd_1
XFILLER_11_387 VGND VGND VPWR VPWR sky130_fd_sc_hd__decap_3
XFILLER_7_39 VGND VGND VPWR VPWR sky130_fd_sc_hd__decap_3
XFILLER_11_92 VGND VGND VPWR VPWR sky130_fd_sc_hd__decap_3
XFILLER_87_52 VGND VGND VPWR VPWR sky130_fd_sc_hd__decap_3
XFILLER_87_41 VGND VGND VPWR VPWR sky130_fd_sc_hd__fill_2
XFILLER_87_30 VGND VGND VPWR VPWR sky130_fd_sc_hd__decap_3
XFILLER_78_354 VGND VGND VPWR VPWR sky130_fd_sc_hd__fill_2
XFILLER_78_321 VGND VGND VPWR VPWR sky130_fd_sc_hd__decap_3
XFILLER_66_516 VGND VGND VPWR VPWR sky130_fd_sc_hd__decap_3
XFILLER_93_302 VGND VGND VPWR VPWR sky130_fd_sc_hd__decap_3
XFILLER_87_96 VGND VGND VPWR VPWR sky130_fd_sc_hd__fill_1
XFILLER_19_421 VGND VGND VPWR VPWR sky130_fd_sc_hd__decap_3
XFILLER_93_346 VGND VGND VPWR VPWR sky130_fd_sc_hd__decap_3
XFILLER_46_251 VGND VGND VPWR VPWR sky130_fd_sc_hd__fill_1
XFILLER_93_368 VGND VGND VPWR VPWR sky130_fd_sc_hd__decap_3
XFILLER_19_476 VGND VGND VPWR VPWR sky130_fd_sc_hd__decap_3
XFILLER_19_487 VGND VGND VPWR VPWR sky130_fd_sc_hd__fill_1
XFILLER_34_402 VGND VGND VPWR VPWR sky130_fd_sc_hd__decap_3
XFILLER_34_424 VGND VGND VPWR VPWR sky130_fd_sc_hd__decap_3
XFILLER_46_262 VGND VGND VPWR VPWR sky130_fd_sc_hd__decap_3
XFILLER_61_210 VGND VGND VPWR VPWR sky130_fd_sc_hd__decap_3
XFILLER_61_243 VGND VGND VPWR VPWR sky130_fd_sc_hd__decap_3
X_2981_ _2935_/X _2984_/A2 _2968_/Y _4911_/Q VGND VGND VPWR VPWR _4911_/D sky130_fd_sc_hd__a22o_2
XFILLER_21_129 VGND VGND VPWR VPWR sky130_fd_sc_hd__decap_3
XFILLER_42_490 VGND VGND VPWR VPWR sky130_fd_sc_hd__decap_3
X_4720_ _3682_/A _4224_/A _4718_/X _4719_/X VGND VGND VPWR VPWR _4720_/X sky130_fd_sc_hd__o211a_2
X_4651_ _4632_/X _4640_/X _4650_/X _4136_/Y VGND VGND VPWR VPWR _4651_/X sky130_fd_sc_hd__a31o_2
Xinput31 INSTR_STREAM[8] VGND VGND VPWR VPWR _3427_/C sky130_fd_sc_hd__clkdlybuf4s25_1
Xinput20 INSTR_STREAM[27] VGND VGND VPWR VPWR _3442_/C sky130_fd_sc_hd__clkdlybuf4s25_1
X_3602_ _5129_/Q _3602_/B VGND VGND VPWR VPWR _3602_/X sky130_fd_sc_hd__or2_2
X_4582_ _4420_/X _4422_/X _4624_/A VGND VGND VPWR VPWR _4582_/X sky130_fd_sc_hd__mux2_1
Xinput42 MEM_LD_DATA[3] VGND VGND VPWR VPWR input42/X sky130_fd_sc_hd__clkdlybuf4s25_1
X_3533_ _3534_/A _3534_/B _3534_/C VGND VGND VPWR VPWR _3533_/Y sky130_fd_sc_hd__a21oi_2
X_3464_ _5181_/Q _5180_/Q _2889_/C _3463_/Y _4850_/B VGND VGND VPWR VPWR _3464_/X
+ sky130_fd_sc_hd__a41o_2
X_5203_ _5251_/CLK _5203_/D VGND VGND VPWR VPWR _5203_/Q sky130_fd_sc_hd__dfxtp_2
XFILLER_69_343 VGND VGND VPWR VPWR sky130_fd_sc_hd__decap_3
X_5134_ _5134_/CLK _5134_/D VGND VGND VPWR VPWR _5134_/Q sky130_fd_sc_hd__dfxtp_2
X_3395_ _5147_/Q _3337_/A _3394_/X _3442_/B VGND VGND VPWR VPWR _5147_/D sky130_fd_sc_hd__o211a_2
XFILLER_69_376 VGND VGND VPWR VPWR sky130_fd_sc_hd__decap_3
XFILLER_57_549 VGND VGND VPWR VPWR sky130_fd_sc_hd__decap_3
X_5065_ clkload7/A _5065_/D VGND VGND VPWR VPWR _5065_/Q sky130_fd_sc_hd__dfxtp_2
XFILLER_84_324 VGND VGND VPWR VPWR sky130_fd_sc_hd__decap_3
XFILLER_37_240 VGND VGND VPWR VPWR sky130_fd_sc_hd__decap_3
XFILLER_72_519 VGND VGND VPWR VPWR sky130_fd_sc_hd__decap_3
X_4016_ _3874_/D _3950_/Y _4558_/A _4015_/Y VGND VGND VPWR VPWR _4016_/X sky130_fd_sc_hd__o211a_2
XFILLER_84_368 VGND VGND VPWR VPWR sky130_fd_sc_hd__decap_3
XFILLER_37_284 VGND VGND VPWR VPWR sky130_fd_sc_hd__decap_3
XTAP_TAPCELL_ROW_55_728 VGND VPWR sky130_fd_sc_hd__tapvpwrvgnd_1
XFILLER_52_243 VGND VGND VPWR VPWR sky130_fd_sc_hd__decap_3
XFILLER_40_416 VGND VGND VPWR VPWR sky130_fd_sc_hd__decap_3
XFILLER_40_427 VGND VGND VPWR VPWR sky130_fd_sc_hd__decap_3
XFILLER_52_265 VGND VGND VPWR VPWR sky130_fd_sc_hd__decap_3
X_4918_ _5111_/CLK _4918_/D VGND VGND VPWR VPWR _4918_/Q sky130_fd_sc_hd__dfxtp_2
X_4849_ _5254_/Q _4168_/A _3456_/X _3448_/B VGND VGND VPWR VPWR _5254_/D sky130_fd_sc_hd__o211a_2
XFILLER_20_195 VGND VGND VPWR VPWR sky130_fd_sc_hd__fill_1
XFILLER_0_501 VGND VGND VPWR VPWR sky130_fd_sc_hd__decap_3
XFILLER_0_545 VGND VGND VPWR VPWR sky130_fd_sc_hd__decap_3
XFILLER_48_516 VGND VGND VPWR VPWR sky130_fd_sc_hd__decap_3
XFILLER_57_11 VGND VGND VPWR VPWR sky130_fd_sc_hd__decap_3
XFILLER_57_33 VGND VGND VPWR VPWR sky130_fd_sc_hd__decap_3
XFILLER_87_162 VGND VGND VPWR VPWR sky130_fd_sc_hd__decap_3
XFILLER_57_66 VGND VGND VPWR VPWR sky130_fd_sc_hd__decap_3
XFILLER_75_335 VGND VGND VPWR VPWR sky130_fd_sc_hd__fill_1
XFILLER_75_346 VGND VGND VPWR VPWR sky130_fd_sc_hd__decap_3
XFILLER_87_184 VGND VGND VPWR VPWR sky130_fd_sc_hd__decap_3
XFILLER_63_508 VGND VGND VPWR VPWR sky130_fd_sc_hd__decap_3
XFILLER_75_379 VGND VGND VPWR VPWR sky130_fd_sc_hd__decap_3
XFILLER_90_305 VGND VGND VPWR VPWR sky130_fd_sc_hd__decap_3
XFILLER_28_251 VGND VGND VPWR VPWR sky130_fd_sc_hd__fill_1
XFILLER_28_262 VGND VGND VPWR VPWR sky130_fd_sc_hd__decap_3
XFILLER_90_316 VGND VGND VPWR VPWR sky130_fd_sc_hd__fill_2
XFILLER_43_221 VGND VGND VPWR VPWR sky130_fd_sc_hd__decap_3
XFILLER_71_552 VGND VGND VPWR VPWR sky130_fd_sc_hd__fill_1
XFILLER_73_43 VGND VGND VPWR VPWR sky130_fd_sc_hd__decap_3
XFILLER_73_98 VGND VGND VPWR VPWR sky130_fd_sc_hd__fill_1
XTAP_TAPCELL_ROW_26_452 VGND VPWR sky130_fd_sc_hd__tapvpwrvgnd_1
XFILLER_31_427 VGND VGND VPWR VPWR sky130_fd_sc_hd__decap_3
XFILLER_43_287 VGND VGND VPWR VPWR sky130_fd_sc_hd__decap_3
XFILLER_11_162 VGND VGND VPWR VPWR sky130_fd_sc_hd__decap_3
XFILLER_7_111 VGND VGND VPWR VPWR sky130_fd_sc_hd__fill_1
XFILLER_7_100 VGND VGND VPWR VPWR sky130_fd_sc_hd__decap_3
XFILLER_11_195 VGND VGND VPWR VPWR sky130_fd_sc_hd__decap_3
XFILLER_7_166 VGND VGND VPWR VPWR sky130_fd_sc_hd__fill_2
XFILLER_7_155 VGND VGND VPWR VPWR sky130_fd_sc_hd__decap_3
XFILLER_22_80 VGND VGND VPWR VPWR sky130_fd_sc_hd__decap_3
XPHY_EDGE_ROW_13_Left_107 VGND VGND VPWR VPWR sky130_fd_sc_hd__decap_3
XFILLER_39_505 VGND VGND VPWR VPWR sky130_fd_sc_hd__decap_3
X_3180_ _2919_/X _3185_/A2 _3185_/B1 _5082_/Q VGND VGND VPWR VPWR _5082_/D sky130_fd_sc_hd__a22o_2
XFILLER_66_335 VGND VGND VPWR VPWR sky130_fd_sc_hd__decap_3
XFILLER_78_173 VGND VGND VPWR VPWR sky130_fd_sc_hd__decap_3
XFILLER_19_240 VGND VGND VPWR VPWR sky130_fd_sc_hd__decap_3
XFILLER_66_368 VGND VGND VPWR VPWR sky130_fd_sc_hd__fill_1
XFILLER_19_273 VGND VGND VPWR VPWR sky130_fd_sc_hd__fill_2
XFILLER_62_530 VGND VGND VPWR VPWR sky130_fd_sc_hd__fill_2
XFILLER_81_349 VGND VGND VPWR VPWR sky130_fd_sc_hd__decap_3
XPHY_EDGE_ROW_22_Left_116 VGND VGND VPWR VPWR sky130_fd_sc_hd__decap_3
XFILLER_15_490 VGND VGND VPWR VPWR sky130_fd_sc_hd__decap_3
XFILLER_22_427 VGND VGND VPWR VPWR sky130_fd_sc_hd__fill_1
XFILLER_34_298 VGND VGND VPWR VPWR sky130_fd_sc_hd__decap_3
X_2964_ _2944_/X _2948_/B _2948_/Y _4898_/Q VGND VGND VPWR VPWR _4898_/D sky130_fd_sc_hd__a22o_2
X_4703_ _4198_/A _3678_/X _4284_/B _4716_/B _4702_/X VGND VGND VPWR VPWR _4703_/Y
+ sky130_fd_sc_hd__a221oi_2
XTAP_TAPCELL_ROW_60_775 VGND VPWR sky130_fd_sc_hd__tapvpwrvgnd_1
X_2895_ _3134_/A _3189_/A VGND VGND VPWR VPWR _2947_/A sky130_fd_sc_hd__or2_2
X_4634_ _4786_/A _4634_/B VGND VGND VPWR VPWR _4634_/Y sky130_fd_sc_hd__nand2_2
X_4565_ _4565_/A _4565_/B VGND VGND VPWR VPWR _4567_/C sky130_fd_sc_hd__xnor2_2
X_3516_ _3514_/X _3516_/B VGND VGND VPWR VPWR _3519_/A sky130_fd_sc_hd__nand2b_2
XFILLER_89_405 VGND VGND VPWR VPWR sky130_fd_sc_hd__decap_3
X_4496_ _4498_/A _4498_/B VGND VGND VPWR VPWR _4563_/A sky130_fd_sc_hd__or2_2
XPHY_EDGE_ROW_4_Right_4 VGND VGND VPWR VPWR sky130_fd_sc_hd__decap_3
XPHY_EDGE_ROW_31_Left_125 VGND VGND VPWR VPWR sky130_fd_sc_hd__decap_3
X_3447_ _5181_/Q _3226_/Y _3228_/Y _3446_/X VGND VGND VPWR VPWR _5181_/D sky130_fd_sc_hd__o22a_2
XFILLER_89_449 VGND VGND VPWR VPWR sky130_fd_sc_hd__decap_3
XFILLER_69_162 VGND VGND VPWR VPWR sky130_fd_sc_hd__decap_3
X_3378_ _3378_/A _3378_/B _3378_/C VGND VGND VPWR VPWR _3378_/X sky130_fd_sc_hd__or3_2
XFILLER_57_313 VGND VGND VPWR VPWR sky130_fd_sc_hd__decap_3
XFILLER_57_335 VGND VGND VPWR VPWR sky130_fd_sc_hd__fill_1
XFILLER_69_184 VGND VGND VPWR VPWR sky130_fd_sc_hd__decap_3
X_5117_ _5117_/CLK _5117_/D VGND VGND VPWR VPWR _5117_/Q sky130_fd_sc_hd__dfxtp_2
XFILLER_45_508 VGND VGND VPWR VPWR sky130_fd_sc_hd__decap_3
XFILLER_57_346 VGND VGND VPWR VPWR sky130_fd_sc_hd__decap_3
X_5048_ _5111_/CLK _5048_/D VGND VGND VPWR VPWR _5048_/Q sky130_fd_sc_hd__dfxtp_2
XFILLER_57_379 VGND VGND VPWR VPWR sky130_fd_sc_hd__decap_3
XFILLER_53_541 VGND VGND VPWR VPWR sky130_fd_sc_hd__decap_3
XPHY_EDGE_ROW_40_Left_134 VGND VGND VPWR VPWR sky130_fd_sc_hd__decap_3
XFILLER_25_243 VGND VGND VPWR VPWR sky130_fd_sc_hd__decap_3
XFILLER_80_360 VGND VGND VPWR VPWR sky130_fd_sc_hd__decap_3
XFILLER_25_287 VGND VGND VPWR VPWR sky130_fd_sc_hd__decap_3
XFILLER_25_298 VGND VGND VPWR VPWR sky130_fd_sc_hd__decap_3
XTAP_TAPCELL_ROW_23_422 VGND VPWR sky130_fd_sc_hd__tapvpwrvgnd_1
XFILLER_80_371 VGND VGND VPWR VPWR sky130_fd_sc_hd__decap_3
XFILLER_43_57 VGND VGND VPWR VPWR sky130_fd_sc_hd__decap_3
XFILLER_43_79 VGND VGND VPWR VPWR sky130_fd_sc_hd__decap_3
XFILLER_4_136 VGND VGND VPWR VPWR sky130_fd_sc_hd__decap_3
XFILLER_4_147 VGND VGND VPWR VPWR sky130_fd_sc_hd__decap_3
XFILLER_4_29 VGND VGND VPWR VPWR sky130_fd_sc_hd__decap_3
XFILLER_68_32 VGND VGND VPWR VPWR sky130_fd_sc_hd__decap_3
XFILLER_68_54 VGND VGND VPWR VPWR sky130_fd_sc_hd__decap_3
XFILLER_0_331 VGND VGND VPWR VPWR sky130_fd_sc_hd__decap_3
XFILLER_0_353 VGND VGND VPWR VPWR sky130_fd_sc_hd__decap_3
XFILLER_48_324 VGND VGND VPWR VPWR sky130_fd_sc_hd__decap_3
XFILLER_36_508 VGND VGND VPWR VPWR sky130_fd_sc_hd__decap_3
XFILLER_48_357 VGND VGND VPWR VPWR sky130_fd_sc_hd__decap_3
XFILLER_48_368 VGND VGND VPWR VPWR sky130_fd_sc_hd__decap_3
XTAP_TAPCELL_ROW_89_1044 VGND VPWR sky130_fd_sc_hd__tapvpwrvgnd_1
XFILLER_75_165 VGND VGND VPWR VPWR sky130_fd_sc_hd__decap_3
XFILLER_84_75 VGND VGND VPWR VPWR sky130_fd_sc_hd__decap_3
XFILLER_17_91 VGND VGND VPWR VPWR sky130_fd_sc_hd__decap_3
XFILLER_44_552 VGND VGND VPWR VPWR sky130_fd_sc_hd__fill_1
XFILLER_16_276 VGND VGND VPWR VPWR sky130_fd_sc_hd__decap_3
XFILLER_71_382 VGND VGND VPWR VPWR sky130_fd_sc_hd__decap_3
XFILLER_71_393 VGND VGND VPWR VPWR sky130_fd_sc_hd__decap_3
X_2680_ _2652_/A _2649_/Y _2638_/B VGND VGND VPWR VPWR _2681_/B sky130_fd_sc_hd__a21o_2
XFILLER_8_453 VGND VGND VPWR VPWR sky130_fd_sc_hd__decap_3
XFILLER_76_6 VGND VGND VPWR VPWR sky130_fd_sc_hd__decap_3
XFILLER_8_486 VGND VGND VPWR VPWR sky130_fd_sc_hd__decap_3
X_4350_ _4348_/X _4350_/B _4796_/A _4350_/D VGND VGND VPWR VPWR _4350_/X sky130_fd_sc_hd__and4b_2
X_3301_ _5138_/Q _3265_/B _3300_/Y VGND VGND VPWR VPWR _5138_/D sky130_fd_sc_hd__o21a_2
X_4281_ _4263_/Y _4264_/X _4279_/Y _4280_/X VGND VGND VPWR VPWR _4281_/Y sky130_fd_sc_hd__o211ai_2
X_3232_ _5169_/Q _3252_/C _3228_/Y _3231_/X VGND VGND VPWR VPWR _5124_/D sky130_fd_sc_hd__o22a_2
X_3163_ _2922_/X _3154_/B _3154_/Y _5067_/Q VGND VGND VPWR VPWR _5067_/D sky130_fd_sc_hd__a22o_2
XFILLER_39_379 VGND VGND VPWR VPWR sky130_fd_sc_hd__decap_3
X_3094_ _2938_/X _3080_/B _3096_/B1 _5008_/Q VGND VGND VPWR VPWR _5008_/D sky130_fd_sc_hd__a22o_2
XTAP_TAPCELL_ROW_65_823 VGND VPWR sky130_fd_sc_hd__tapvpwrvgnd_1
XFILLER_47_390 VGND VGND VPWR VPWR sky130_fd_sc_hd__fill_2
XFILLER_50_511 VGND VGND VPWR VPWR sky130_fd_sc_hd__decap_3
XFILLER_62_371 VGND VGND VPWR VPWR sky130_fd_sc_hd__decap_3
XFILLER_50_544 VGND VGND VPWR VPWR sky130_fd_sc_hd__decap_3
X_3996_ _3992_/A _3888_/B _4360_/B VGND VGND VPWR VPWR _3996_/Y sky130_fd_sc_hd__o21ai_2
X_2947_ _2947_/A _3207_/A VGND VGND VPWR VPWR _2948_/B sky130_fd_sc_hd__nor2_2
X_4617_ _4088_/C _4617_/B _4617_/C VGND VGND VPWR VPWR _4617_/X sky130_fd_sc_hd__and3b_2
X_2878_ _3682_/D _2876_/B _2678_/A VGND VGND VPWR VPWR _2879_/B sky130_fd_sc_hd__a21bo_2
X_4548_ _4333_/B _4547_/B _3678_/X _2594_/X _4547_/Y VGND VGND VPWR VPWR _4548_/X
+ sky130_fd_sc_hd__a221o_2
X_4479_ _4479_/A _4479_/B _4469_/B VGND VGND VPWR VPWR _4479_/X sky130_fd_sc_hd__or3b_2
XFILLER_8_9 VGND VGND VPWR VPWR sky130_fd_sc_hd__fill_2
XFILLER_89_246 VGND VGND VPWR VPWR sky130_fd_sc_hd__decap_3
XFILLER_77_408 VGND VGND VPWR VPWR sky130_fd_sc_hd__decap_3
XFILLER_38_57 VGND VGND VPWR VPWR sky130_fd_sc_hd__fill_2
XFILLER_85_452 VGND VGND VPWR VPWR sky130_fd_sc_hd__decap_3
XFILLER_85_441 VGND VGND VPWR VPWR sky130_fd_sc_hd__decap_3
XFILLER_45_316 VGND VGND VPWR VPWR sky130_fd_sc_hd__decap_3
XFILLER_57_165 VGND VGND VPWR VPWR sky130_fd_sc_hd__decap_3
XPHY_EDGE_ROW_79_Right_79 VGND VGND VPWR VPWR sky130_fd_sc_hd__decap_3
XFILLER_57_198 VGND VGND VPWR VPWR sky130_fd_sc_hd__fill_2
XFILLER_26_552 VGND VGND VPWR VPWR sky130_fd_sc_hd__fill_1
XFILLER_41_522 VGND VGND VPWR VPWR sky130_fd_sc_hd__decap_3
XFILLER_53_393 VGND VGND VPWR VPWR sky130_fd_sc_hd__decap_3
XTAP_TAPCELL_ROW_0_194 VGND VPWR sky130_fd_sc_hd__tapvpwrvgnd_1
XFILLER_13_257 VGND VGND VPWR VPWR sky130_fd_sc_hd__decap_3
XFILLER_9_228 VGND VGND VPWR VPWR sky130_fd_sc_hd__decap_3
XFILLER_70_88 VGND VGND VPWR VPWR sky130_fd_sc_hd__decap_3
XPHY_EDGE_ROW_88_Right_88 VGND VGND VPWR VPWR sky130_fd_sc_hd__decap_3
XFILLER_0_150 VGND VGND VPWR VPWR sky130_fd_sc_hd__decap_3
XFILLER_0_172 VGND VGND VPWR VPWR sky130_fd_sc_hd__decap_3
XTAP_TAPCELL_ROW_79_948 VGND VPWR sky130_fd_sc_hd__tapvpwrvgnd_1
XFILLER_48_176 VGND VGND VPWR VPWR sky130_fd_sc_hd__decap_3
XFILLER_76_474 VGND VGND VPWR VPWR sky130_fd_sc_hd__fill_2
XFILLER_63_113 VGND VGND VPWR VPWR sky130_fd_sc_hd__fill_2
XFILLER_63_146 VGND VGND VPWR VPWR sky130_fd_sc_hd__fill_1
XFILLER_91_422 VGND VGND VPWR VPWR sky130_fd_sc_hd__fill_2
XFILLER_76_496 VGND VGND VPWR VPWR sky130_fd_sc_hd__decap_3
XFILLER_17_541 VGND VGND VPWR VPWR sky130_fd_sc_hd__decap_3
XFILLER_51_308 VGND VGND VPWR VPWR sky130_fd_sc_hd__decap_3
XFILLER_91_488 VGND VGND VPWR VPWR sky130_fd_sc_hd__fill_1
XFILLER_32_511 VGND VGND VPWR VPWR sky130_fd_sc_hd__decap_3
XFILLER_32_533 VGND VGND VPWR VPWR sky130_fd_sc_hd__decap_3
XFILLER_44_371 VGND VGND VPWR VPWR sky130_fd_sc_hd__decap_3
XTAP_TAPCELL_ROW_34_528 VGND VPWR sky130_fd_sc_hd__tapvpwrvgnd_1
X_3850_ _5177_/Q _3999_/A _5178_/Q VGND VGND VPWR VPWR _4528_/A sky130_fd_sc_hd__and3b_2
X_3781_ _3781_/A _3781_/B VGND VGND VPWR VPWR _3849_/C sky130_fd_sc_hd__and2_2
X_2801_ _4957_/Q _4941_/Q _4925_/Q _4909_/Q _5131_/Q _2848_/S1 VGND VGND VPWR VPWR
+ _2802_/B sky130_fd_sc_hd__mux4_2
XTAP_TAPCELL_ROW_70_870 VGND VPWR sky130_fd_sc_hd__tapvpwrvgnd_1
XFILLER_74_3 VGND VGND VPWR VPWR sky130_fd_sc_hd__fill_1
X_2732_ _2831_/S _2731_/X _2437_/Y VGND VGND VPWR VPWR _2732_/X sky130_fd_sc_hd__o21a_2
X_2663_ _5163_/Q _4429_/B VGND VGND VPWR VPWR _2663_/Y sky130_fd_sc_hd__nor2_2
X_4402_ _4402_/A _4402_/B VGND VGND VPWR VPWR _4402_/X sky130_fd_sc_hd__and2_2
X_2594_ _5153_/Q _4449_/B VGND VGND VPWR VPWR _2594_/X sky130_fd_sc_hd__and2_2
X_4333_ _2887_/A _4333_/B _4333_/C VGND VGND VPWR VPWR _4333_/X sky130_fd_sc_hd__and3b_2
XFILLER_59_408 VGND VGND VPWR VPWR sky130_fd_sc_hd__decap_3
X_4264_ _3922_/A _3917_/X _4244_/C _4224_/A VGND VGND VPWR VPWR _4264_/X sky130_fd_sc_hd__a31o_2
X_3215_ _2916_/X _3221_/A2 _3208_/Y _5113_/Q VGND VGND VPWR VPWR _5113_/D sky130_fd_sc_hd__a22o_2
XFILLER_39_121 VGND VGND VPWR VPWR sky130_fd_sc_hd__fill_1
XFILLER_67_441 VGND VGND VPWR VPWR sky130_fd_sc_hd__decap_3
X_4195_ _4196_/A _4196_/B VGND VGND VPWR VPWR _4195_/Y sky130_fd_sc_hd__nand2_2
XFILLER_79_290 VGND VGND VPWR VPWR sky130_fd_sc_hd__decap_3
XFILLER_39_154 VGND VGND VPWR VPWR sky130_fd_sc_hd__decap_3
XFILLER_67_485 VGND VGND VPWR VPWR sky130_fd_sc_hd__fill_2
X_3146_ _2926_/X _3152_/A2 _3136_/Y _5052_/Q VGND VGND VPWR VPWR _5052_/D sky130_fd_sc_hd__a22o_2
XFILLER_82_400 VGND VGND VPWR VPWR sky130_fd_sc_hd__decap_3
XFILLER_39_187 VGND VGND VPWR VPWR sky130_fd_sc_hd__fill_2
X_3077_ _2944_/X _3061_/B _3061_/Y _4994_/Q VGND VGND VPWR VPWR _4994_/D sky130_fd_sc_hd__a22o_2
XFILLER_82_477 VGND VGND VPWR VPWR sky130_fd_sc_hd__decap_3
XFILLER_23_511 VGND VGND VPWR VPWR sky130_fd_sc_hd__decap_3
XFILLER_35_393 VGND VGND VPWR VPWR sky130_fd_sc_hd__decap_3
XFILLER_50_330 VGND VGND VPWR VPWR sky130_fd_sc_hd__decap_3
XFILLER_50_352 VGND VGND VPWR VPWR sky130_fd_sc_hd__decap_3
XFILLER_62_190 VGND VGND VPWR VPWR sky130_fd_sc_hd__fill_1
XFILLER_24_59 VGND VGND VPWR VPWR sky130_fd_sc_hd__fill_2
XFILLER_50_396 VGND VGND VPWR VPWR sky130_fd_sc_hd__decap_3
X_3979_ _3978_/X _3977_/A _4077_/S VGND VGND VPWR VPWR _3979_/X sky130_fd_sc_hd__mux2_1
XFILLER_40_25 VGND VGND VPWR VPWR sky130_fd_sc_hd__decap_3
XFILLER_6_209 VGND VGND VPWR VPWR sky130_fd_sc_hd__fill_2
XFILLER_40_58 VGND VGND VPWR VPWR sky130_fd_sc_hd__decap_3
XFILLER_6_6 VGND VGND VPWR VPWR sky130_fd_sc_hd__decap_3
XTAP_TAPCELL_ROW_5_253 VGND VPWR sky130_fd_sc_hd__tapvpwrvgnd_1
XFILLER_45_102 VGND VGND VPWR VPWR sky130_fd_sc_hd__fill_1
XFILLER_18_327 VGND VGND VPWR VPWR sky130_fd_sc_hd__decap_3
XTAP_TAPCELL_ROW_86_1014 VGND VPWR sky130_fd_sc_hd__tapvpwrvgnd_1
XFILLER_85_293 VGND VGND VPWR VPWR sky130_fd_sc_hd__decap_3
XFILLER_45_146 VGND VGND VPWR VPWR sky130_fd_sc_hd__decap_3
XTAP_TAPCELL_ROW_84_995 VGND VPWR sky130_fd_sc_hd__tapvpwrvgnd_1
XFILLER_14_533 VGND VGND VPWR VPWR sky130_fd_sc_hd__fill_2
XFILLER_81_54 VGND VGND VPWR VPWR sky130_fd_sc_hd__fill_2
XFILLER_41_385 VGND VGND VPWR VPWR sky130_fd_sc_hd__fill_1
XFILLER_5_242 VGND VGND VPWR VPWR sky130_fd_sc_hd__decap_3
XFILLER_5_264 VGND VGND VPWR VPWR sky130_fd_sc_hd__decap_3
XFILLER_68_238 VGND VGND VPWR VPWR sky130_fd_sc_hd__decap_3
XFILLER_49_452 VGND VGND VPWR VPWR sky130_fd_sc_hd__decap_3
Xinput7 INSTR_STREAM[15] VGND VGND VPWR VPWR input7/X sky130_fd_sc_hd__clkdlybuf4s25_1
X_3000_ _2935_/X _2987_/B _2987_/Y _4927_/Q VGND VGND VPWR VPWR _4927_/D sky130_fd_sc_hd__a22o_2
XFILLER_76_282 VGND VGND VPWR VPWR sky130_fd_sc_hd__decap_3
XFILLER_64_477 VGND VGND VPWR VPWR sky130_fd_sc_hd__decap_3
XFILLER_17_382 VGND VGND VPWR VPWR sky130_fd_sc_hd__fill_2
X_4951_ _4982_/CLK _4951_/D VGND VGND VPWR VPWR _4951_/Q sky130_fd_sc_hd__dfxtp_2
XFILLER_17_393 VGND VGND VPWR VPWR sky130_fd_sc_hd__decap_3
X_4882_ _5106_/CLK _4882_/D VGND VGND VPWR VPWR _4882_/Q sky130_fd_sc_hd__dfxtp_2
X_3902_ _4196_/A _3902_/B VGND VGND VPWR VPWR _3903_/B sky130_fd_sc_hd__or2_2
XFILLER_32_363 VGND VGND VPWR VPWR sky130_fd_sc_hd__fill_1
X_3833_ _5111_/Q _4999_/Q _4983_/Q _4967_/Q _3834_/S0 _3834_/S1 VGND VGND VPWR VPWR
+ _3833_/X sky130_fd_sc_hd__mux4_2
XFILLER_20_547 VGND VGND VPWR VPWR sky130_fd_sc_hd__decap_3
XFILLER_32_385 VGND VGND VPWR VPWR sky130_fd_sc_hd__decap_3
X_3764_ _3762_/X _3763_/X _3831_/A VGND VGND VPWR VPWR _3764_/X sky130_fd_sc_hd__mux2_1
X_3695_ _5129_/Q _3695_/B VGND VGND VPWR VPWR _3695_/X sky130_fd_sc_hd__or2_2
X_2715_ _5134_/Q _2710_/X _2712_/X _2714_/X VGND VGND VPWR VPWR _3403_/B sky130_fd_sc_hd__a22o_2
X_2646_ _2644_/X _2645_/X _5125_/Q VGND VGND VPWR VPWR _2646_/X sky130_fd_sc_hd__mux2_1
X_2577_ _2667_/A _2576_/X _5126_/Q VGND VGND VPWR VPWR _2577_/X sky130_fd_sc_hd__o21a_2
X_4316_ _4341_/A _4453_/B _4523_/S VGND VGND VPWR VPWR _4316_/X sky130_fd_sc_hd__mux2_1
XFILLER_87_514 VGND VGND VPWR VPWR sky130_fd_sc_hd__decap_3
X_4247_ _4285_/C _3903_/Y _3906_/Y _4246_/Y VGND VGND VPWR VPWR _4247_/X sky130_fd_sc_hd__o31a_2
XFILLER_87_547 VGND VGND VPWR VPWR sky130_fd_sc_hd__decap_3
XFILLER_67_260 VGND VGND VPWR VPWR sky130_fd_sc_hd__decap_3
XFILLER_74_219 VGND VGND VPWR VPWR sky130_fd_sc_hd__decap_3
X_4178_ _4070_/B _4177_/Y _4339_/A VGND VGND VPWR VPWR _4178_/X sky130_fd_sc_hd__mux2_1
XFILLER_27_113 VGND VGND VPWR VPWR sky130_fd_sc_hd__decap_3
XFILLER_55_411 VGND VGND VPWR VPWR sky130_fd_sc_hd__decap_3
XFILLER_67_293 VGND VGND VPWR VPWR sky130_fd_sc_hd__decap_3
XTAP_TAPCELL_ROW_2_223 VGND VPWR sky130_fd_sc_hd__tapvpwrvgnd_1
XFILLER_27_157 VGND VGND VPWR VPWR sky130_fd_sc_hd__decap_3
XFILLER_55_455 VGND VGND VPWR VPWR sky130_fd_sc_hd__decap_3
X_3129_ _2932_/X _3117_/B _3133_/B1 _5038_/Q VGND VGND VPWR VPWR _5038_/D sky130_fd_sc_hd__a22o_2
XFILLER_55_488 VGND VGND VPWR VPWR sky130_fd_sc_hd__decap_3
XFILLER_70_436 VGND VGND VPWR VPWR sky130_fd_sc_hd__decap_3
XFILLER_82_274 VGND VGND VPWR VPWR sky130_fd_sc_hd__decap_3
XFILLER_23_330 VGND VGND VPWR VPWR sky130_fd_sc_hd__decap_3
XFILLER_70_469 VGND VGND VPWR VPWR sky130_fd_sc_hd__decap_3
XFILLER_11_503 VGND VGND VPWR VPWR sky130_fd_sc_hd__fill_1
XFILLER_23_352 VGND VGND VPWR VPWR sky130_fd_sc_hd__decap_3
XFILLER_50_160 VGND VGND VPWR VPWR sky130_fd_sc_hd__decap_3
XFILLER_23_396 VGND VGND VPWR VPWR sky130_fd_sc_hd__fill_2
XFILLER_50_193 VGND VGND VPWR VPWR sky130_fd_sc_hd__decap_3
XFILLER_51_35 VGND VGND VPWR VPWR sky130_fd_sc_hd__decap_3
XFILLER_51_57 VGND VGND VPWR VPWR sky130_fd_sc_hd__fill_1
XFILLER_2_256 VGND VGND VPWR VPWR sky130_fd_sc_hd__decap_3
XFILLER_4_3 VGND VGND VPWR VPWR sky130_fd_sc_hd__decap_3
XTAP_TAPCELL_ROW_92_1073 VGND VPWR sky130_fd_sc_hd__tapvpwrvgnd_1
XFILLER_76_32 VGND VGND VPWR VPWR sky130_fd_sc_hd__fill_2
XFILLER_76_21 VGND VGND VPWR VPWR sky130_fd_sc_hd__decap_3
XFILLER_93_517 VGND VGND VPWR VPWR sky130_fd_sc_hd__decap_3
XFILLER_76_65 VGND VGND VPWR VPWR sky130_fd_sc_hd__fill_1
XFILLER_46_433 VGND VGND VPWR VPWR sky130_fd_sc_hd__decap_3
XFILLER_58_271 VGND VGND VPWR VPWR sky130_fd_sc_hd__decap_3
XFILLER_93_539 VGND VGND VPWR VPWR sky130_fd_sc_hd__decap_3
XFILLER_46_444 VGND VGND VPWR VPWR sky130_fd_sc_hd__decap_3
XFILLER_46_477 VGND VGND VPWR VPWR sky130_fd_sc_hd__decap_3
XFILLER_61_414 VGND VGND VPWR VPWR sky130_fd_sc_hd__decap_3
XFILLER_73_296 VGND VGND VPWR VPWR sky130_fd_sc_hd__decap_3
XTAP_TAPCELL_ROW_44_623 VGND VPWR sky130_fd_sc_hd__tapvpwrvgnd_1
XFILLER_26_190 VGND VGND VPWR VPWR sky130_fd_sc_hd__decap_3
XFILLER_61_458 VGND VGND VPWR VPWR sky130_fd_sc_hd__decap_3
XFILLER_14_352 VGND VGND VPWR VPWR sky130_fd_sc_hd__decap_3
XFILLER_14_374 VGND VGND VPWR VPWR sky130_fd_sc_hd__decap_3
XTAP_TAPCELL_ROW_16_358 VGND VPWR sky130_fd_sc_hd__tapvpwrvgnd_1
X_3480_ _5152_/Q _5149_/Q _3479_/C VGND VGND VPWR VPWR _3480_/Y sky130_fd_sc_hd__a21oi_2
X_2500_ _4471_/A VGND VGND VPWR VPWR _4341_/A sky130_fd_sc_hd__inv_2
X_2431_ _5129_/Q VGND VGND VPWR VPWR _3831_/A sky130_fd_sc_hd__inv_2
XFILLER_69_514 VGND VGND VPWR VPWR sky130_fd_sc_hd__fill_2
X_5150_ _5254_/CLK _5150_/D VGND VGND VPWR VPWR _5150_/Q sky130_fd_sc_hd__dfxtp_2
X_4101_ _3839_/B _4371_/B _4002_/Y _2560_/Y VGND VGND VPWR VPWR _4101_/X sky130_fd_sc_hd__a2bb2o_2
X_5081_ clkload6/A _5081_/D VGND VGND VPWR VPWR _5081_/Q sky130_fd_sc_hd__dfxtp_2
X_4032_ _3672_/X _3670_/X _4077_/S VGND VGND VPWR VPWR _4032_/X sky130_fd_sc_hd__mux2_1
XFILLER_37_444 VGND VGND VPWR VPWR sky130_fd_sc_hd__decap_3
XFILLER_37_455 VGND VGND VPWR VPWR sky130_fd_sc_hd__fill_2
XFILLER_92_550 VGND VGND VPWR VPWR sky130_fd_sc_hd__decap_3
XFILLER_37_477 VGND VGND VPWR VPWR sky130_fd_sc_hd__decap_3
XFILLER_52_403 VGND VGND VPWR VPWR sky130_fd_sc_hd__decap_3
XFILLER_52_436 VGND VGND VPWR VPWR sky130_fd_sc_hd__fill_2
XFILLER_52_469 VGND VGND VPWR VPWR sky130_fd_sc_hd__decap_3
X_4934_ _5111_/CLK _4934_/D VGND VGND VPWR VPWR _4934_/Q sky130_fd_sc_hd__dfxtp_2
XFILLER_60_480 VGND VGND VPWR VPWR sky130_fd_sc_hd__decap_3
X_4865_ _5174_/Q _3252_/C _3250_/X _3448_/B VGND VGND VPWR VPWR _5174_/D sky130_fd_sc_hd__o211a_2
XFILLER_20_344 VGND VGND VPWR VPWR sky130_fd_sc_hd__decap_3
X_4796_ _4796_/A _4796_/B _4796_/C VGND VGND VPWR VPWR _4796_/X sky130_fd_sc_hd__and3_2
X_3816_ _3814_/X _3815_/X _5129_/Q VGND VGND VPWR VPWR _3816_/X sky130_fd_sc_hd__mux2_1
X_3747_ _5129_/Q _3747_/B VGND VGND VPWR VPWR _3747_/X sky130_fd_sc_hd__or2_2
X_3678_ _3999_/A _3679_/B VGND VGND VPWR VPWR _3678_/X sky130_fd_sc_hd__and2_2
X_2629_ _5116_/Q _5004_/Q _4988_/Q _4972_/Q _2658_/S0 _2671_/S1 VGND VGND VPWR VPWR
+ _2629_/X sky130_fd_sc_hd__mux4_2
XFILLER_87_311 VGND VGND VPWR VPWR sky130_fd_sc_hd__decap_3
XFILLER_47_219 VGND VGND VPWR VPWR sky130_fd_sc_hd__decap_3
XFILLER_87_388 VGND VGND VPWR VPWR sky130_fd_sc_hd__decap_3
XFILLER_87_355 VGND VGND VPWR VPWR sky130_fd_sc_hd__decap_3
XFILLER_28_433 VGND VGND VPWR VPWR sky130_fd_sc_hd__decap_3
XTAP_TAPCELL_ROW_58_748 VGND VPWR sky130_fd_sc_hd__tapvpwrvgnd_1
XFILLER_87_399 VGND VGND VPWR VPWR sky130_fd_sc_hd__decap_3
XFILLER_28_466 VGND VGND VPWR VPWR sky130_fd_sc_hd__fill_2
XFILLER_46_57 VGND VGND VPWR VPWR sky130_fd_sc_hd__decap_3
XFILLER_28_477 VGND VGND VPWR VPWR sky130_fd_sc_hd__fill_1
XFILLER_28_499 VGND VGND VPWR VPWR sky130_fd_sc_hd__decap_3
XFILLER_43_414 VGND VGND VPWR VPWR sky130_fd_sc_hd__decap_3
XFILLER_70_211 VGND VGND VPWR VPWR sky130_fd_sc_hd__decap_3
XFILLER_11_322 VGND VGND VPWR VPWR sky130_fd_sc_hd__decap_3
XFILLER_51_491 VGND VGND VPWR VPWR sky130_fd_sc_hd__decap_3
XFILLER_62_56 VGND VGND VPWR VPWR sky130_fd_sc_hd__decap_3
XFILLER_70_299 VGND VGND VPWR VPWR sky130_fd_sc_hd__decap_3
XTAP_TAPCELL_ROW_13_328 VGND VPWR sky130_fd_sc_hd__tapvpwrvgnd_1
XFILLER_11_333 VGND VGND VPWR VPWR sky130_fd_sc_hd__decap_3
XFILLER_7_18 VGND VGND VPWR VPWR sky130_fd_sc_hd__decap_3
XFILLER_7_337 VGND VGND VPWR VPWR sky130_fd_sc_hd__decap_3
XFILLER_7_359 VGND VGND VPWR VPWR sky130_fd_sc_hd__decap_3
XFILLER_11_60 VGND VGND VPWR VPWR sky130_fd_sc_hd__fill_1
XFILLER_11_71 VGND VGND VPWR VPWR sky130_fd_sc_hd__decap_3
XFILLER_3_543 VGND VGND VPWR VPWR sky130_fd_sc_hd__decap_3
XFILLER_78_333 VGND VGND VPWR VPWR sky130_fd_sc_hd__decap_3
XFILLER_66_528 VGND VGND VPWR VPWR sky130_fd_sc_hd__decap_3
XFILLER_66_539 VGND VGND VPWR VPWR sky130_fd_sc_hd__decap_3
XFILLER_78_399 VGND VGND VPWR VPWR sky130_fd_sc_hd__decap_3
XFILLER_46_230 VGND VGND VPWR VPWR sky130_fd_sc_hd__decap_3
XFILLER_34_414 VGND VGND VPWR VPWR sky130_fd_sc_hd__decap_3
XFILLER_34_436 VGND VGND VPWR VPWR sky130_fd_sc_hd__decap_3
XFILLER_61_255 VGND VGND VPWR VPWR sky130_fd_sc_hd__decap_3
X_2980_ _2932_/X _2984_/A2 _2968_/Y _4910_/Q VGND VGND VPWR VPWR _4910_/D sky130_fd_sc_hd__a22o_2
XFILLER_61_299 VGND VGND VPWR VPWR sky130_fd_sc_hd__decap_3
X_4650_ _4110_/B _4647_/X _4650_/C _4650_/D VGND VGND VPWR VPWR _4650_/X sky130_fd_sc_hd__and4bb_2
Xinput21 INSTR_STREAM[28] VGND VGND VPWR VPWR _3444_/C sky130_fd_sc_hd__clkdlybuf4s25_1
Xinput10 INSTR_STREAM[18] VGND VGND VPWR VPWR _3233_/C sky130_fd_sc_hd__clkdlybuf4s25_1
X_3601_ _4885_/Q _4869_/Q _5093_/Q _5077_/Q _3834_/S0 _3834_/S1 VGND VGND VPWR VPWR
+ _3602_/B sky130_fd_sc_hd__mux4_2
X_4581_ _4423_/Y _4409_/Y _4624_/A VGND VGND VPWR VPWR _4672_/B sky130_fd_sc_hd__mux2_1
Xinput43 MEM_LD_DATA[4] VGND VGND VPWR VPWR input43/X sky130_fd_sc_hd__clkdlybuf4s25_1
Xinput32 INSTR_STREAM[9] VGND VGND VPWR VPWR _3429_/B sky130_fd_sc_hd__clkdlybuf4s25_1
X_3532_ _3524_/B _3526_/B _3522_/X VGND VGND VPWR VPWR _3534_/C sky130_fd_sc_hd__a21o_2
XFILLER_6_392 VGND VGND VPWR VPWR sky130_fd_sc_hd__decap_3
X_3463_ _5179_/Q _3463_/B VGND VGND VPWR VPWR _3463_/Y sky130_fd_sc_hd__xnor2_2
Xclkbuf_leaf_30_CLK clkload1/A VGND VGND VPWR VPWR _5114_/CLK sky130_fd_sc_hd__clkbuf_8
X_5202_ _5251_/CLK _5202_/D VGND VGND VPWR VPWR _5202_/Q sky130_fd_sc_hd__dfxtp_2
XFILLER_88_108 VGND VGND VPWR VPWR sky130_fd_sc_hd__decap_3
XFILLER_69_333 VGND VGND VPWR VPWR sky130_fd_sc_hd__decap_3
X_5133_ clkload5/A _5133_/D VGND VGND VPWR VPWR _5133_/Q sky130_fd_sc_hd__dfxtp_2
X_3394_ _3389_/Y _3390_/X _3393_/X _3265_/Y VGND VGND VPWR VPWR _3394_/X sky130_fd_sc_hd__a22o_2
XFILLER_57_517 VGND VGND VPWR VPWR sky130_fd_sc_hd__decap_3
XFILLER_69_355 VGND VGND VPWR VPWR sky130_fd_sc_hd__decap_3
XFILLER_69_388 VGND VGND VPWR VPWR sky130_fd_sc_hd__decap_3
X_5064_ _5094_/CLK _5064_/D VGND VGND VPWR VPWR _5064_/Q sky130_fd_sc_hd__dfxtp_2
X_4015_ _4556_/A _4015_/B _4015_/C _4015_/D VGND VGND VPWR VPWR _4015_/Y sky130_fd_sc_hd__nor4_2
XFILLER_37_252 VGND VGND VPWR VPWR sky130_fd_sc_hd__decap_3
XFILLER_16_27 VGND VGND VPWR VPWR sky130_fd_sc_hd__fill_1
XFILLER_16_38 VGND VGND VPWR VPWR sky130_fd_sc_hd__decap_3
XFILLER_52_222 VGND VGND VPWR VPWR sky130_fd_sc_hd__decap_3
XFILLER_92_380 VGND VGND VPWR VPWR sky130_fd_sc_hd__decap_3
XFILLER_80_520 VGND VGND VPWR VPWR sky130_fd_sc_hd__decap_3
XFILLER_52_277 VGND VGND VPWR VPWR sky130_fd_sc_hd__decap_3
XFILLER_40_439 VGND VGND VPWR VPWR sky130_fd_sc_hd__decap_3
X_4917_ _5111_/CLK _4917_/D VGND VGND VPWR VPWR _4917_/Q sky130_fd_sc_hd__dfxtp_2
XFILLER_20_141 VGND VGND VPWR VPWR sky130_fd_sc_hd__decap_3
X_4848_ input39/X _4816_/Y _4847_/X _3442_/B VGND VGND VPWR VPWR _5253_/D sky130_fd_sc_hd__o211a_2
XFILLER_20_174 VGND VGND VPWR VPWR sky130_fd_sc_hd__fill_1
X_4779_ _3457_/A _4546_/A _4779_/S VGND VGND VPWR VPWR _4779_/X sky130_fd_sc_hd__mux2_1
XFILLER_4_318 VGND VGND VPWR VPWR sky130_fd_sc_hd__decap_3
Xclkbuf_leaf_21_CLK clkload2/A VGND VGND VPWR VPWR _5078_/CLK sky130_fd_sc_hd__clkbuf_8
XFILLER_57_78 VGND VGND VPWR VPWR sky130_fd_sc_hd__decap_3
XFILLER_75_358 VGND VGND VPWR VPWR sky130_fd_sc_hd__decap_3
XFILLER_71_520 VGND VGND VPWR VPWR sky130_fd_sc_hd__fill_2
XFILLER_83_380 VGND VGND VPWR VPWR sky130_fd_sc_hd__decap_3
XFILLER_43_255 VGND VGND VPWR VPWR sky130_fd_sc_hd__decap_3
XFILLER_73_77 VGND VGND VPWR VPWR sky130_fd_sc_hd__decap_3
XTAP_TAPCELL_ROW_26_453 VGND VPWR sky130_fd_sc_hd__tapvpwrvgnd_1
XFILLER_43_299 VGND VGND VPWR VPWR sky130_fd_sc_hd__decap_3
Xclkbuf_leaf_12_CLK clkload0/A VGND VGND VPWR VPWR _5177_/CLK sky130_fd_sc_hd__clkbuf_8
XFILLER_21_6 VGND VGND VPWR VPWR sky130_fd_sc_hd__decap_3
XFILLER_39_517 VGND VGND VPWR VPWR sky130_fd_sc_hd__fill_2
XFILLER_78_141 VGND VGND VPWR VPWR sky130_fd_sc_hd__decap_3
XFILLER_66_347 VGND VGND VPWR VPWR sky130_fd_sc_hd__decap_3
XFILLER_19_252 VGND VGND VPWR VPWR sky130_fd_sc_hd__decap_3
XFILLER_34_200 VGND VGND VPWR VPWR sky130_fd_sc_hd__decap_3
XFILLER_93_177 VGND VGND VPWR VPWR sky130_fd_sc_hd__decap_3
XFILLER_81_317 VGND VGND VPWR VPWR sky130_fd_sc_hd__decap_3
XFILLER_74_380 VGND VGND VPWR VPWR sky130_fd_sc_hd__decap_3
XFILLER_34_244 VGND VGND VPWR VPWR sky130_fd_sc_hd__decap_3
X_2963_ _2941_/X _2948_/B _2948_/Y _4897_/Q VGND VGND VPWR VPWR _4897_/D sky130_fd_sc_hd__a22o_2
X_4702_ _2443_/Y _4333_/B _4702_/S VGND VGND VPWR VPWR _4702_/X sky130_fd_sc_hd__mux2_1
XFILLER_30_461 VGND VGND VPWR VPWR sky130_fd_sc_hd__decap_3
XFILLER_30_483 VGND VGND VPWR VPWR sky130_fd_sc_hd__decap_3
X_2894_ _5188_/Q _5189_/Q VGND VGND VPWR VPWR _3189_/A sky130_fd_sc_hd__nand2b_2
XTAP_TAPCELL_ROW_60_776 VGND VPWR sky130_fd_sc_hd__tapvpwrvgnd_1
X_4633_ _4786_/A _4634_/B VGND VGND VPWR VPWR _4635_/B sky130_fd_sc_hd__and2_2
X_4564_ _4565_/A _4565_/B VGND VGND VPWR VPWR _4564_/Y sky130_fd_sc_hd__nand2b_2
X_3515_ _5158_/Q _5139_/Q VGND VGND VPWR VPWR _3516_/B sky130_fd_sc_hd__or2_2
X_4495_ _4447_/B _4494_/Y _4565_/A VGND VGND VPWR VPWR _4506_/A sky130_fd_sc_hd__o21a_2
XFILLER_89_417 VGND VGND VPWR VPWR sky130_fd_sc_hd__decap_3
X_3446_ _5260_/Q _3448_/B _3446_/C VGND VGND VPWR VPWR _3446_/X sky130_fd_sc_hd__and3_2
X_3377_ _3375_/X _3377_/B VGND VGND VPWR VPWR _3378_/C sky130_fd_sc_hd__and2b_2
X_5116_ _5116_/CLK _5116_/D VGND VGND VPWR VPWR _5116_/Q sky130_fd_sc_hd__dfxtp_2
XFILLER_27_26 VGND VGND VPWR VPWR sky130_fd_sc_hd__decap_3
X_5047_ _5063_/CLK _5047_/D VGND VGND VPWR VPWR _5047_/Q sky130_fd_sc_hd__dfxtp_2
XTAP_TAPCELL_ROW_68_843 VGND VPWR sky130_fd_sc_hd__tapvpwrvgnd_1
XFILLER_38_550 VGND VGND VPWR VPWR sky130_fd_sc_hd__decap_3
XFILLER_72_306 VGND VGND VPWR VPWR sky130_fd_sc_hd__fill_2
XFILLER_25_211 VGND VGND VPWR VPWR sky130_fd_sc_hd__decap_3
XFILLER_53_520 VGND VGND VPWR VPWR sky130_fd_sc_hd__decap_3
XFILLER_25_255 VGND VGND VPWR VPWR sky130_fd_sc_hd__fill_1
XFILLER_13_428 VGND VGND VPWR VPWR sky130_fd_sc_hd__fill_1
XFILLER_80_394 VGND VGND VPWR VPWR sky130_fd_sc_hd__decap_3
XFILLER_80_383 VGND VGND VPWR VPWR sky130_fd_sc_hd__decap_3
XFILLER_40_247 VGND VGND VPWR VPWR sky130_fd_sc_hd__decap_3
XTAP_TAPCELL_ROW_23_423 VGND VPWR sky130_fd_sc_hd__tapvpwrvgnd_1
XFILLER_4_115 VGND VGND VPWR VPWR sky130_fd_sc_hd__decap_3
XFILLER_0_365 VGND VGND VPWR VPWR sky130_fd_sc_hd__decap_3
XFILLER_88_483 VGND VGND VPWR VPWR sky130_fd_sc_hd__decap_3
XFILLER_48_336 VGND VGND VPWR VPWR sky130_fd_sc_hd__decap_3
XFILLER_75_122 VGND VGND VPWR VPWR sky130_fd_sc_hd__decap_3
XTAP_TAPCELL_ROW_89_1045 VGND VPWR sky130_fd_sc_hd__tapvpwrvgnd_1
XFILLER_84_32 VGND VGND VPWR VPWR sky130_fd_sc_hd__decap_3
XFILLER_63_306 VGND VGND VPWR VPWR sky130_fd_sc_hd__fill_1
XFILLER_63_317 VGND VGND VPWR VPWR sky130_fd_sc_hd__decap_3
XFILLER_56_380 VGND VGND VPWR VPWR sky130_fd_sc_hd__decap_3
XFILLER_71_361 VGND VGND VPWR VPWR sky130_fd_sc_hd__decap_3
XFILLER_31_225 VGND VGND VPWR VPWR sky130_fd_sc_hd__decap_3
Xclkbuf_leaf_1_CLK clkbuf_leaf_8_CLK/A VGND VGND VPWR VPWR _5106_/CLK sky130_fd_sc_hd__clkbuf_8
XFILLER_31_247 VGND VGND VPWR VPWR sky130_fd_sc_hd__decap_3
XFILLER_12_472 VGND VGND VPWR VPWR sky130_fd_sc_hd__decap_3
XFILLER_8_465 VGND VGND VPWR VPWR sky130_fd_sc_hd__fill_2
X_3300_ _4714_/A _3300_/B VGND VGND VPWR VPWR _3300_/Y sky130_fd_sc_hd__nor2_2
X_4280_ _4285_/B _4246_/A _4279_/C _4274_/X _4270_/X VGND VGND VPWR VPWR _4280_/X
+ sky130_fd_sc_hd__o311a_2
X_3231_ _5260_/Q _3448_/B input9/X VGND VGND VPWR VPWR _3231_/X sky130_fd_sc_hd__and3_2
XFILLER_86_409 VGND VGND VPWR VPWR sky130_fd_sc_hd__decap_3
XFILLER_39_325 VGND VGND VPWR VPWR sky130_fd_sc_hd__decap_3
X_3162_ _2919_/X _3170_/A2 _3170_/B1 _5066_/Q VGND VGND VPWR VPWR _5066_/D sky130_fd_sc_hd__a22o_2
XFILLER_66_144 VGND VGND VPWR VPWR sky130_fd_sc_hd__decap_3
X_3093_ _2935_/X _3093_/A2 _3096_/B1 _5007_/Q VGND VGND VPWR VPWR _5007_/D sky130_fd_sc_hd__a22o_2
XFILLER_35_520 VGND VGND VPWR VPWR sky130_fd_sc_hd__fill_1
XFILLER_81_147 VGND VGND VPWR VPWR sky130_fd_sc_hd__decap_3
XFILLER_35_542 VGND VGND VPWR VPWR sky130_fd_sc_hd__decap_3
XFILLER_81_169 VGND VGND VPWR VPWR sky130_fd_sc_hd__decap_3
XFILLER_62_361 VGND VGND VPWR VPWR sky130_fd_sc_hd__decap_3
X_3995_ _3999_/A _3995_/B VGND VGND VPWR VPWR _4246_/A sky130_fd_sc_hd__or2_2
X_2946_ _5187_/Q _5186_/Q VGND VGND VPWR VPWR _3207_/A sky130_fd_sc_hd__or2_2
X_2877_ _2887_/B _2877_/B VGND VGND VPWR VPWR _2877_/Y sky130_fd_sc_hd__nor2_2
X_4616_ _4614_/X _4615_/X _4088_/A _4088_/B VGND VGND VPWR VPWR _4617_/C sky130_fd_sc_hd__a211oi_2
X_4547_ _4547_/A _4547_/B VGND VGND VPWR VPWR _4547_/Y sky130_fd_sc_hd__nor2_2
Xmax_cap140 _4662_/A VGND VGND VPWR VPWR _4716_/B sky130_fd_sc_hd__buf_6
XFILLER_89_203 VGND VGND VPWR VPWR sky130_fd_sc_hd__fill_1
X_4478_ _4445_/A _4067_/A _4449_/B VGND VGND VPWR VPWR _4478_/Y sky130_fd_sc_hd__a21oi_2
XFILLER_89_225 VGND VGND VPWR VPWR sky130_fd_sc_hd__fill_1
X_3429_ _5260_/Q _3429_/B _3429_/C VGND VGND VPWR VPWR _3429_/X sky130_fd_sc_hd__and3_2
XFILLER_89_258 VGND VGND VPWR VPWR sky130_fd_sc_hd__decap_3
XFILLER_38_25 VGND VGND VPWR VPWR sky130_fd_sc_hd__decap_3
XFILLER_57_111 VGND VGND VPWR VPWR sky130_fd_sc_hd__fill_1
XFILLER_57_122 VGND VGND VPWR VPWR sky130_fd_sc_hd__decap_3
XFILLER_85_486 VGND VGND VPWR VPWR sky130_fd_sc_hd__fill_2
XFILLER_85_475 VGND VGND VPWR VPWR sky130_fd_sc_hd__decap_3
XFILLER_26_531 VGND VGND VPWR VPWR sky130_fd_sc_hd__fill_1
XFILLER_38_380 VGND VGND VPWR VPWR sky130_fd_sc_hd__decap_3
XFILLER_45_328 VGND VGND VPWR VPWR sky130_fd_sc_hd__decap_3
XFILLER_54_24 VGND VGND VPWR VPWR sky130_fd_sc_hd__decap_3
XFILLER_54_57 VGND VGND VPWR VPWR sky130_fd_sc_hd__decap_3
XFILLER_60_309 VGND VGND VPWR VPWR sky130_fd_sc_hd__decap_3
XFILLER_72_147 VGND VGND VPWR VPWR sky130_fd_sc_hd__decap_3
XFILLER_13_225 VGND VGND VPWR VPWR sky130_fd_sc_hd__decap_3
XFILLER_41_534 VGND VGND VPWR VPWR sky130_fd_sc_hd__decap_3
XFILLER_53_361 VGND VGND VPWR VPWR sky130_fd_sc_hd__decap_3
XTAP_TAPCELL_ROW_0_195 VGND VPWR sky130_fd_sc_hd__tapvpwrvgnd_1
XFILLER_13_269 VGND VGND VPWR VPWR sky130_fd_sc_hd__decap_3
XFILLER_70_45 VGND VGND VPWR VPWR sky130_fd_sc_hd__decap_3
XFILLER_70_67 VGND VGND VPWR VPWR sky130_fd_sc_hd__decap_3
XFILLER_79_54 VGND VGND VPWR VPWR sky130_fd_sc_hd__fill_2
XFILLER_0_162 VGND VGND VPWR VPWR sky130_fd_sc_hd__decap_3
XTAP_TAPCELL_ROW_8_273 VGND VPWR sky130_fd_sc_hd__tapvpwrvgnd_1
XTAP_TAPCELL_ROW_79_949 VGND VPWR sky130_fd_sc_hd__tapvpwrvgnd_1
XFILLER_0_184 VGND VGND VPWR VPWR sky130_fd_sc_hd__decap_3
XFILLER_48_144 VGND VGND VPWR VPWR sky130_fd_sc_hd__decap_3
XFILLER_88_291 VGND VGND VPWR VPWR sky130_fd_sc_hd__decap_3
XFILLER_36_306 VGND VGND VPWR VPWR sky130_fd_sc_hd__fill_2
XFILLER_76_486 VGND VGND VPWR VPWR sky130_fd_sc_hd__fill_2
XFILLER_28_80 VGND VGND VPWR VPWR sky130_fd_sc_hd__decap_3
XFILLER_29_380 VGND VGND VPWR VPWR sky130_fd_sc_hd__decap_3
XFILLER_48_188 VGND VGND VPWR VPWR sky130_fd_sc_hd__fill_2
XFILLER_91_445 VGND VGND VPWR VPWR sky130_fd_sc_hd__decap_3
XFILLER_63_169 VGND VGND VPWR VPWR sky130_fd_sc_hd__decap_3
XFILLER_44_383 VGND VGND VPWR VPWR sky130_fd_sc_hd__decap_3
XTAP_TAPCELL_ROW_34_529 VGND VPWR sky130_fd_sc_hd__tapvpwrvgnd_1
XFILLER_32_545 VGND VGND VPWR VPWR sky130_fd_sc_hd__decap_3
XFILLER_71_180 VGND VGND VPWR VPWR sky130_fd_sc_hd__decap_3
X_3780_ _4335_/A _4360_/A VGND VGND VPWR VPWR _3781_/B sky130_fd_sc_hd__and2b_2
X_2800_ _2798_/X _2799_/X _5133_/Q VGND VGND VPWR VPWR _2800_/X sky130_fd_sc_hd__mux2_1
XTAP_TAPCELL_ROW_70_871 VGND VPWR sky130_fd_sc_hd__tapvpwrvgnd_1
X_2731_ _4949_/Q _4933_/Q _4917_/Q _4901_/Q _2812_/S0 _2848_/S1 VGND VGND VPWR VPWR
+ _2731_/X sky130_fd_sc_hd__mux4_2
XFILLER_67_3 VGND VGND VPWR VPWR sky130_fd_sc_hd__fill_1
X_4401_ _5153_/Q _5152_/Q _5154_/Q VGND VGND VPWR VPWR _4402_/B sky130_fd_sc_hd__o21ai_2
X_2662_ _5163_/Q _4429_/B VGND VGND VPWR VPWR _2665_/A sky130_fd_sc_hd__nand2_2
X_2593_ _2588_/X _2589_/X _2592_/X _2435_/Y VGND VGND VPWR VPWR _4449_/B sky130_fd_sc_hd__a22o_2
XFILLER_5_51 VGND VGND VPWR VPWR sky130_fd_sc_hd__decap_3
X_4332_ _4335_/A _4332_/B VGND VGND VPWR VPWR _4332_/X sky130_fd_sc_hd__xor2_2
XFILLER_5_84 VGND VGND VPWR VPWR sky130_fd_sc_hd__decap_3
X_4263_ _3917_/X _4244_/C _3922_/A VGND VGND VPWR VPWR _4263_/Y sky130_fd_sc_hd__a21oi_2
X_3214_ _2913_/X _3221_/A2 _3208_/Y _5112_/Q VGND VGND VPWR VPWR _5112_/D sky130_fd_sc_hd__a22o_2
XFILLER_39_111 VGND VGND VPWR VPWR sky130_fd_sc_hd__fill_1
X_4194_ _4191_/A _4191_/B _3805_/A VGND VGND VPWR VPWR _4196_/B sky130_fd_sc_hd__a21o_2
XFILLER_27_317 VGND VGND VPWR VPWR sky130_fd_sc_hd__fill_2
X_3145_ _2922_/X _3136_/B _3136_/Y _5051_/Q VGND VGND VPWR VPWR _5051_/D sky130_fd_sc_hd__a22o_2
XFILLER_54_114 VGND VGND VPWR VPWR sky130_fd_sc_hd__fill_1
XFILLER_54_125 VGND VGND VPWR VPWR sky130_fd_sc_hd__decap_3
XFILLER_67_497 VGND VGND VPWR VPWR sky130_fd_sc_hd__decap_3
X_3076_ _2941_/X _3061_/B _3061_/Y _4993_/Q VGND VGND VPWR VPWR _4993_/D sky130_fd_sc_hd__a22o_2
XFILLER_82_434 VGND VGND VPWR VPWR sky130_fd_sc_hd__decap_3
XFILLER_54_147 VGND VGND VPWR VPWR sky130_fd_sc_hd__decap_3
XFILLER_35_383 VGND VGND VPWR VPWR sky130_fd_sc_hd__decap_3
XFILLER_24_38 VGND VGND VPWR VPWR sky130_fd_sc_hd__decap_3
XFILLER_62_180 VGND VGND VPWR VPWR sky130_fd_sc_hd__fill_2
XFILLER_10_206 VGND VGND VPWR VPWR sky130_fd_sc_hd__decap_3
X_3978_ _4466_/A _4464_/B _4010_/S VGND VGND VPWR VPWR _3978_/X sky130_fd_sc_hd__mux2_1
XFILLER_10_239 VGND VGND VPWR VPWR sky130_fd_sc_hd__decap_3
X_2929_ _5200_/Q _2455_/X _2888_/Y _5248_/Q _2928_/X VGND VGND VPWR VPWR _2929_/X
+ sky130_fd_sc_hd__a221o_2
XFILLER_2_416 VGND VGND VPWR VPWR sky130_fd_sc_hd__decap_3
XFILLER_77_217 VGND VGND VPWR VPWR sky130_fd_sc_hd__decap_3
XFILLER_77_206 VGND VGND VPWR VPWR sky130_fd_sc_hd__decap_3
XFILLER_58_431 VGND VGND VPWR VPWR sky130_fd_sc_hd__fill_1
XTAP_TAPCELL_ROW_76_919 VGND VPWR sky130_fd_sc_hd__tapvpwrvgnd_1
XFILLER_58_486 VGND VGND VPWR VPWR sky130_fd_sc_hd__fill_2
XFILLER_73_445 VGND VGND VPWR VPWR sky130_fd_sc_hd__decap_3
XTAP_TAPCELL_ROW_86_1015 VGND VPWR sky130_fd_sc_hd__tapvpwrvgnd_1
XFILLER_33_309 VGND VGND VPWR VPWR sky130_fd_sc_hd__decap_3
XFILLER_45_158 VGND VGND VPWR VPWR sky130_fd_sc_hd__decap_3
XFILLER_45_169 VGND VGND VPWR VPWR sky130_fd_sc_hd__decap_3
XFILLER_65_89 VGND VGND VPWR VPWR sky130_fd_sc_hd__decap_3
XFILLER_73_489 VGND VGND VPWR VPWR sky130_fd_sc_hd__decap_3
XTAP_TAPCELL_ROW_84_996 VGND VPWR sky130_fd_sc_hd__tapvpwrvgnd_1
XFILLER_41_320 VGND VGND VPWR VPWR sky130_fd_sc_hd__decap_3
XFILLER_81_33 VGND VGND VPWR VPWR sky130_fd_sc_hd__decap_3
XFILLER_81_66 VGND VGND VPWR VPWR sky130_fd_sc_hd__fill_1
XFILLER_5_276 VGND VGND VPWR VPWR sky130_fd_sc_hd__decap_3
XFILLER_5_287 VGND VGND VPWR VPWR sky130_fd_sc_hd__decap_3
XFILLER_49_420 VGND VGND VPWR VPWR sky130_fd_sc_hd__decap_3
XFILLER_49_475 VGND VGND VPWR VPWR sky130_fd_sc_hd__decap_3
Xinput8 INSTR_STREAM[16] VGND VGND VPWR VPWR input8/X sky130_fd_sc_hd__clkdlybuf4s25_1
XFILLER_83_209 VGND VGND VPWR VPWR sky130_fd_sc_hd__decap_3
XFILLER_64_412 VGND VGND VPWR VPWR sky130_fd_sc_hd__decap_3
XFILLER_76_294 VGND VGND VPWR VPWR sky130_fd_sc_hd__decap_3
XFILLER_24_309 VGND VGND VPWR VPWR sky130_fd_sc_hd__decap_3
XFILLER_64_467 VGND VGND VPWR VPWR sky130_fd_sc_hd__decap_3
XFILLER_17_361 VGND VGND VPWR VPWR sky130_fd_sc_hd__fill_1
XFILLER_51_106 VGND VGND VPWR VPWR sky130_fd_sc_hd__decap_3
X_4950_ _4982_/CLK _4950_/D VGND VGND VPWR VPWR _4950_/Q sky130_fd_sc_hd__dfxtp_2
XTAP_TAPCELL_ROW_19_378 VGND VPWR sky130_fd_sc_hd__tapvpwrvgnd_1
XFILLER_91_297 VGND VGND VPWR VPWR sky130_fd_sc_hd__decap_3
XFILLER_91_275 VGND VGND VPWR VPWR sky130_fd_sc_hd__decap_3
X_4881_ clkload3/A _4881_/D VGND VGND VPWR VPWR _4881_/Q sky130_fd_sc_hd__dfxtp_2
X_3901_ _3900_/A _3896_/Y _3899_/Y _3900_/X VGND VGND VPWR VPWR _3902_/B sky130_fd_sc_hd__o211a_2
XFILLER_20_504 VGND VGND VPWR VPWR sky130_fd_sc_hd__decap_3
XFILLER_32_342 VGND VGND VPWR VPWR sky130_fd_sc_hd__decap_3
X_3832_ _5129_/Q _3829_/X _5130_/Q VGND VGND VPWR VPWR _3832_/X sky130_fd_sc_hd__o21a_2
X_3763_ _5121_/Q _5009_/Q _4993_/Q _4977_/Q _5127_/Q _5128_/Q VGND VGND VPWR VPWR
+ _3763_/X sky130_fd_sc_hd__mux4_2
X_3694_ _4892_/Q _4876_/Q _5100_/Q _5084_/Q _3834_/S0 _3834_/S1 VGND VGND VPWR VPWR
+ _3695_/B sky130_fd_sc_hd__mux4_2
X_2714_ _2831_/S _2713_/X _2437_/Y VGND VGND VPWR VPWR _2714_/X sky130_fd_sc_hd__o21a_2
X_2645_ _4955_/Q _4939_/Q _4923_/Q _4907_/Q _5123_/Q _2671_/S1 VGND VGND VPWR VPWR
+ _2645_/X sky130_fd_sc_hd__mux4_2
XFILLER_10_29 VGND VGND VPWR VPWR sky130_fd_sc_hd__decap_3
X_4315_ _4340_/A _4315_/B VGND VGND VPWR VPWR _4315_/Y sky130_fd_sc_hd__nand2_2
X_2576_ _5061_/Q _5045_/Q _5029_/Q _5013_/Q _2658_/S0 _2671_/S1 VGND VGND VPWR VPWR
+ _2576_/X sky130_fd_sc_hd__mux4_2
XFILLER_59_228 VGND VGND VPWR VPWR sky130_fd_sc_hd__decap_3
XFILLER_87_526 VGND VGND VPWR VPWR sky130_fd_sc_hd__decap_3
XFILLER_19_27 VGND VGND VPWR VPWR sky130_fd_sc_hd__decap_3
X_4246_ _4246_/A _4278_/B VGND VGND VPWR VPWR _4246_/Y sky130_fd_sc_hd__nor2_2
X_4177_ _4268_/B VGND VGND VPWR VPWR _4177_/Y sky130_fd_sc_hd__inv_2
XFILLER_55_423 VGND VGND VPWR VPWR sky130_fd_sc_hd__decap_3
XFILLER_67_272 VGND VGND VPWR VPWR sky130_fd_sc_hd__decap_3
X_3128_ _2929_/X _3117_/B _3133_/B1 _5037_/Q VGND VGND VPWR VPWR _5037_/D sky130_fd_sc_hd__a22o_2
XTAP_TAPCELL_ROW_2_224 VGND VPWR sky130_fd_sc_hd__tapvpwrvgnd_1
XFILLER_82_253 VGND VGND VPWR VPWR sky130_fd_sc_hd__decap_3
XFILLER_82_231 VGND VGND VPWR VPWR sky130_fd_sc_hd__decap_3
XFILLER_27_169 VGND VGND VPWR VPWR sky130_fd_sc_hd__decap_3
XFILLER_42_106 VGND VGND VPWR VPWR sky130_fd_sc_hd__decap_3
XFILLER_70_404 VGND VGND VPWR VPWR sky130_fd_sc_hd__decap_3
X_3059_ _2944_/X _3043_/B _3043_/Y _4978_/Q VGND VGND VPWR VPWR _4978_/D sky130_fd_sc_hd__a22o_2
XFILLER_82_286 VGND VGND VPWR VPWR sky130_fd_sc_hd__decap_3
XFILLER_35_191 VGND VGND VPWR VPWR sky130_fd_sc_hd__decap_3
XFILLER_70_448 VGND VGND VPWR VPWR sky130_fd_sc_hd__decap_3
XFILLER_11_526 VGND VGND VPWR VPWR sky130_fd_sc_hd__decap_3
XFILLER_50_172 VGND VGND VPWR VPWR sky130_fd_sc_hd__decap_3
XFILLER_51_47 VGND VGND VPWR VPWR sky130_fd_sc_hd__decap_3
XFILLER_51_69 VGND VGND VPWR VPWR sky130_fd_sc_hd__fill_2
XFILLER_2_268 VGND VGND VPWR VPWR sky130_fd_sc_hd__fill_1
XTAP_TAPCELL_ROW_92_1074 VGND VPWR sky130_fd_sc_hd__tapvpwrvgnd_1
XFILLER_78_526 VGND VGND VPWR VPWR sky130_fd_sc_hd__decap_3
XFILLER_78_548 VGND VGND VPWR VPWR sky130_fd_sc_hd__decap_3
XFILLER_93_529 VGND VGND VPWR VPWR sky130_fd_sc_hd__decap_3
XFILLER_58_283 VGND VGND VPWR VPWR sky130_fd_sc_hd__fill_1
XFILLER_46_456 VGND VGND VPWR VPWR sky130_fd_sc_hd__decap_3
XFILLER_46_467 VGND VGND VPWR VPWR sky130_fd_sc_hd__decap_3
XFILLER_73_231 VGND VGND VPWR VPWR sky130_fd_sc_hd__decap_3
XFILLER_73_253 VGND VGND VPWR VPWR sky130_fd_sc_hd__decap_3
XFILLER_18_169 VGND VGND VPWR VPWR sky130_fd_sc_hd__decap_3
XFILLER_46_489 VGND VGND VPWR VPWR sky130_fd_sc_hd__decap_3
XFILLER_92_54 VGND VGND VPWR VPWR sky130_fd_sc_hd__fill_2
XFILLER_92_32 VGND VGND VPWR VPWR sky130_fd_sc_hd__decap_3
XFILLER_61_437 VGND VGND VPWR VPWR sky130_fd_sc_hd__decap_3
XTAP_TAPCELL_ROW_44_624 VGND VPWR sky130_fd_sc_hd__tapvpwrvgnd_1
XFILLER_92_76 VGND VGND VPWR VPWR sky130_fd_sc_hd__fill_2
XFILLER_41_150 VGND VGND VPWR VPWR sky130_fd_sc_hd__decap_3
X_2430_ _5163_/Q VGND VGND VPWR VPWR _3352_/A sky130_fd_sc_hd__inv_2
XFILLER_69_548 VGND VGND VPWR VPWR sky130_fd_sc_hd__decap_3
X_4100_ _4155_/A _4100_/B VGND VGND VPWR VPWR _4110_/B sky130_fd_sc_hd__nor2_2
X_5080_ _5109_/CLK _5080_/D VGND VGND VPWR VPWR _5080_/Q sky130_fd_sc_hd__dfxtp_2
X_4031_ _3669_/X _4614_/A _4077_/S VGND VGND VPWR VPWR _4031_/X sky130_fd_sc_hd__mux2_1
XFILLER_84_518 VGND VGND VPWR VPWR sky130_fd_sc_hd__decap_3
XFILLER_2_63 VGND VGND VPWR VPWR sky130_fd_sc_hd__decap_3
XFILLER_37_401 VGND VGND VPWR VPWR sky130_fd_sc_hd__decap_3
XFILLER_24_117 VGND VGND VPWR VPWR sky130_fd_sc_hd__decap_3
XFILLER_52_415 VGND VGND VPWR VPWR sky130_fd_sc_hd__decap_3
XFILLER_64_253 VGND VGND VPWR VPWR sky130_fd_sc_hd__decap_3
XFILLER_64_275 VGND VGND VPWR VPWR sky130_fd_sc_hd__decap_3
X_4933_ _5111_/CLK _4933_/D VGND VGND VPWR VPWR _4933_/Q sky130_fd_sc_hd__dfxtp_2
XFILLER_32_161 VGND VGND VPWR VPWR sky130_fd_sc_hd__decap_3
X_4864_ _4866_/A _4864_/B VGND VGND VPWR VPWR _5173_/D sky130_fd_sc_hd__nor2_2
X_4795_ _3681_/B _4224_/A _4246_/A _4335_/A _4794_/X VGND VGND VPWR VPWR _4796_/C
+ sky130_fd_sc_hd__o221a_2
X_3815_ _4952_/Q _4936_/Q _4920_/Q _4904_/Q _3834_/S0 _3834_/S1 VGND VGND VPWR VPWR
+ _3815_/X sky130_fd_sc_hd__mux4_2
XFILLER_20_389 VGND VGND VPWR VPWR sky130_fd_sc_hd__decap_3
X_3746_ _4895_/Q _4879_/Q _5103_/Q _5087_/Q _3834_/S0 _3834_/S1 VGND VGND VPWR VPWR
+ _3747_/B sky130_fd_sc_hd__mux4_2
X_3677_ _3676_/Y _3671_/X _4173_/A VGND VGND VPWR VPWR _3677_/X sky130_fd_sc_hd__mux2_1
X_2628_ _5125_/Q _2625_/X _5126_/Q VGND VGND VPWR VPWR _2628_/X sky130_fd_sc_hd__o21a_2
X_2559_ _5156_/Q _4466_/B VGND VGND VPWR VPWR _2562_/A sky130_fd_sc_hd__and2_2
XFILLER_87_323 VGND VGND VPWR VPWR sky130_fd_sc_hd__decap_3
X_4229_ _4339_/A _4229_/B VGND VGND VPWR VPWR _4229_/Y sky130_fd_sc_hd__nor2_2
XFILLER_87_367 VGND VGND VPWR VPWR sky130_fd_sc_hd__decap_3
XFILLER_75_518 VGND VGND VPWR VPWR sky130_fd_sc_hd__decap_3
XFILLER_28_412 VGND VGND VPWR VPWR sky130_fd_sc_hd__decap_3
XTAP_TAPCELL_ROW_58_749 VGND VPWR sky130_fd_sc_hd__tapvpwrvgnd_1
XFILLER_83_540 VGND VGND VPWR VPWR sky130_fd_sc_hd__decap_3
XFILLER_55_253 VGND VGND VPWR VPWR sky130_fd_sc_hd__decap_3
XFILLER_55_275 VGND VGND VPWR VPWR sky130_fd_sc_hd__decap_3
XFILLER_15_139 VGND VGND VPWR VPWR sky130_fd_sc_hd__fill_1
XFILLER_70_267 VGND VGND VPWR VPWR sky130_fd_sc_hd__decap_3
XFILLER_11_301 VGND VGND VPWR VPWR sky130_fd_sc_hd__decap_3
XFILLER_23_172 VGND VGND VPWR VPWR sky130_fd_sc_hd__decap_3
XFILLER_51_470 VGND VGND VPWR VPWR sky130_fd_sc_hd__decap_3
XFILLER_62_68 VGND VGND VPWR VPWR sky130_fd_sc_hd__decap_3
XTAP_TAPCELL_ROW_13_329 VGND VPWR sky130_fd_sc_hd__tapvpwrvgnd_1
XFILLER_11_83 VGND VGND VPWR VPWR sky130_fd_sc_hd__decap_3
XFILLER_87_65 VGND VGND VPWR VPWR sky130_fd_sc_hd__decap_3
XFILLER_78_345 VGND VGND VPWR VPWR sky130_fd_sc_hd__decap_3
XFILLER_78_312 VGND VGND VPWR VPWR sky130_fd_sc_hd__decap_3
XFILLER_66_507 VGND VGND VPWR VPWR sky130_fd_sc_hd__decap_3
XFILLER_78_378 VGND VGND VPWR VPWR sky130_fd_sc_hd__decap_3
XFILLER_93_337 VGND VGND VPWR VPWR sky130_fd_sc_hd__decap_3
XFILLER_46_242 VGND VGND VPWR VPWR sky130_fd_sc_hd__decap_3
XFILLER_74_540 VGND VGND VPWR VPWR sky130_fd_sc_hd__decap_3
XFILLER_46_253 VGND VGND VPWR VPWR sky130_fd_sc_hd__decap_3
XFILLER_34_448 VGND VGND VPWR VPWR sky130_fd_sc_hd__decap_3
XFILLER_36_91 VGND VGND VPWR VPWR sky130_fd_sc_hd__decap_3
XFILLER_46_297 VGND VGND VPWR VPWR sky130_fd_sc_hd__decap_3
XFILLER_61_234 VGND VGND VPWR VPWR sky130_fd_sc_hd__decap_3
XTAP_TAPCELL_ROW_29_473 VGND VPWR sky130_fd_sc_hd__tapvpwrvgnd_1
XFILLER_21_109 VGND VGND VPWR VPWR sky130_fd_sc_hd__decap_3
XFILLER_61_267 VGND VGND VPWR VPWR sky130_fd_sc_hd__fill_1
XFILLER_14_194 VGND VGND VPWR VPWR sky130_fd_sc_hd__fill_2
X_4580_ _4580_/A VGND VGND VPWR VPWR _4580_/Y sky130_fd_sc_hd__inv_2
Xinput22 INSTR_STREAM[29] VGND VGND VPWR VPWR _3446_/C sky130_fd_sc_hd__clkdlybuf4s25_1
Xinput11 INSTR_STREAM[19] VGND VGND VPWR VPWR _3235_/C sky130_fd_sc_hd__clkdlybuf4s25_1
X_3600_ _5061_/Q _5045_/Q _5029_/Q _5013_/Q _3834_/S0 _3834_/S1 VGND VGND VPWR VPWR
+ _3600_/X sky130_fd_sc_hd__mux4_2
Xinput44 MEM_LD_DATA[5] VGND VGND VPWR VPWR input44/X sky130_fd_sc_hd__clkdlybuf4s25_1
Xinput33 MEM_LD_DATA[0] VGND VGND VPWR VPWR input33/X sky130_fd_sc_hd__clkdlybuf4s25_1
X_3531_ _5160_/Q _5141_/Q VGND VGND VPWR VPWR _3534_/B sky130_fd_sc_hd__or2_2
X_3462_ _5178_/Q _5012_/Q _3461_/X VGND VGND VPWR VPWR _3463_/B sky130_fd_sc_hd__a21oi_2
X_5201_ _5251_/CLK _5201_/D VGND VGND VPWR VPWR _5201_/Q sky130_fd_sc_hd__dfxtp_2
X_3393_ _3391_/X _3400_/B _3337_/A VGND VGND VPWR VPWR _3393_/X sky130_fd_sc_hd__a21bo_2
XFILLER_69_312 VGND VGND VPWR VPWR sky130_fd_sc_hd__fill_1
X_5132_ clkload3/A _5132_/D VGND VGND VPWR VPWR _5132_/Q sky130_fd_sc_hd__dfxtp_4
XFILLER_69_367 VGND VGND VPWR VPWR sky130_fd_sc_hd__decap_3
X_5063_ _5063_/CLK _5063_/D VGND VGND VPWR VPWR _5063_/Q sky130_fd_sc_hd__dfxtp_2
XFILLER_37_220 VGND VGND VPWR VPWR sky130_fd_sc_hd__decap_3
XFILLER_37_231 VGND VGND VPWR VPWR sky130_fd_sc_hd__decap_3
XFILLER_65_551 VGND VGND VPWR VPWR sky130_fd_sc_hd__fill_2
X_4014_ _4172_/A _3975_/X _3980_/Y _4013_/X _4132_/A VGND VGND VPWR VPWR _4015_/D
+ sky130_fd_sc_hd__a32o_2
XFILLER_52_234 VGND VGND VPWR VPWR sky130_fd_sc_hd__decap_3
XFILLER_92_392 VGND VGND VPWR VPWR sky130_fd_sc_hd__decap_3
XFILLER_40_407 VGND VGND VPWR VPWR sky130_fd_sc_hd__decap_3
XFILLER_52_256 VGND VGND VPWR VPWR sky130_fd_sc_hd__decap_3
X_4916_ _5098_/CLK _4916_/D VGND VGND VPWR VPWR _4916_/Q sky130_fd_sc_hd__dfxtp_2
XTAP_TAPCELL_ROW_63_796 VGND VPWR sky130_fd_sc_hd__tapvpwrvgnd_1
XFILLER_20_131 VGND VGND VPWR VPWR sky130_fd_sc_hd__decap_3
XFILLER_32_27 VGND VGND VPWR VPWR sky130_fd_sc_hd__fill_1
X_4847_ _5253_/Q _4847_/B VGND VGND VPWR VPWR _4847_/X sky130_fd_sc_hd__or2_2
XFILLER_20_186 VGND VGND VPWR VPWR sky130_fd_sc_hd__decap_3
X_4778_ _4806_/A _4778_/B VGND VGND VPWR VPWR _4778_/Y sky130_fd_sc_hd__nand2_2
X_3729_ _4449_/B _4405_/A VGND VGND VPWR VPWR _3729_/X sky130_fd_sc_hd__and2_2
XFILLER_0_525 VGND VGND VPWR VPWR sky130_fd_sc_hd__decap_3
XFILLER_0_536 VGND VGND VPWR VPWR sky130_fd_sc_hd__decap_3
XFILLER_87_153 VGND VGND VPWR VPWR sky130_fd_sc_hd__decap_3
XFILLER_57_57 VGND VGND VPWR VPWR sky130_fd_sc_hd__decap_3
XFILLER_75_326 VGND VGND VPWR VPWR sky130_fd_sc_hd__decap_3
XFILLER_75_337 VGND VGND VPWR VPWR sky130_fd_sc_hd__fill_1
XFILLER_87_175 VGND VGND VPWR VPWR sky130_fd_sc_hd__decap_3
XFILLER_16_415 VGND VGND VPWR VPWR sky130_fd_sc_hd__decap_3
XFILLER_28_253 VGND VGND VPWR VPWR sky130_fd_sc_hd__decap_3
XFILLER_90_329 VGND VGND VPWR VPWR sky130_fd_sc_hd__fill_1
XFILLER_16_448 VGND VGND VPWR VPWR sky130_fd_sc_hd__fill_2
XFILLER_43_212 VGND VGND VPWR VPWR sky130_fd_sc_hd__decap_3
XFILLER_71_543 VGND VGND VPWR VPWR sky130_fd_sc_hd__decap_3
XFILLER_73_34 VGND VGND VPWR VPWR sky130_fd_sc_hd__decap_3
XFILLER_73_89 VGND VGND VPWR VPWR sky130_fd_sc_hd__decap_3
XFILLER_7_113 VGND VGND VPWR VPWR sky130_fd_sc_hd__decap_3
XFILLER_11_186 VGND VGND VPWR VPWR sky130_fd_sc_hd__decap_3
XFILLER_7_146 VGND VGND VPWR VPWR sky130_fd_sc_hd__fill_1
XFILLER_3_396 VGND VGND VPWR VPWR sky130_fd_sc_hd__decap_3
XFILLER_78_153 VGND VGND VPWR VPWR sky130_fd_sc_hd__decap_3
XFILLER_66_304 VGND VGND VPWR VPWR sky130_fd_sc_hd__decap_3
XFILLER_66_315 VGND VGND VPWR VPWR sky130_fd_sc_hd__decap_3
XFILLER_14_6 VGND VGND VPWR VPWR sky130_fd_sc_hd__decap_3
XFILLER_19_231 VGND VGND VPWR VPWR sky130_fd_sc_hd__decap_3
XFILLER_66_359 VGND VGND VPWR VPWR sky130_fd_sc_hd__decap_3
XFILLER_78_197 VGND VGND VPWR VPWR sky130_fd_sc_hd__decap_3
XFILLER_19_264 VGND VGND VPWR VPWR sky130_fd_sc_hd__decap_3
XFILLER_47_551 VGND VGND VPWR VPWR sky130_fd_sc_hd__fill_2
XFILLER_93_189 VGND VGND VPWR VPWR sky130_fd_sc_hd__decap_3
XFILLER_81_329 VGND VGND VPWR VPWR sky130_fd_sc_hd__decap_3
XFILLER_62_521 VGND VGND VPWR VPWR sky130_fd_sc_hd__decap_3
XFILLER_34_267 VGND VGND VPWR VPWR sky130_fd_sc_hd__fill_1
XFILLER_22_418 VGND VGND VPWR VPWR sky130_fd_sc_hd__fill_2
XFILLER_34_289 VGND VGND VPWR VPWR sky130_fd_sc_hd__decap_3
X_2962_ _2938_/X _2948_/B _2948_/Y _4896_/Q VGND VGND VPWR VPWR _4896_/D sky130_fd_sc_hd__a22o_2
X_4701_ _4866_/A _4701_/B VGND VGND VPWR VPWR _5229_/D sky130_fd_sc_hd__nor2_2
X_4632_ _4632_/A _4632_/B _4632_/C VGND VGND VPWR VPWR _4632_/X sky130_fd_sc_hd__or3_2
X_2893_ _5184_/Q _5258_/D VGND VGND VPWR VPWR _3134_/A sky130_fd_sc_hd__nand2_2
XFILLER_30_495 VGND VGND VPWR VPWR sky130_fd_sc_hd__decap_3
XFILLER_8_62 VGND VGND VPWR VPWR sky130_fd_sc_hd__decap_3
X_4563_ _4563_/A _4563_/B VGND VGND VPWR VPWR _4565_/B sky130_fd_sc_hd__xnor2_2
X_4494_ _4465_/A _4465_/B _4493_/C VGND VGND VPWR VPWR _4494_/Y sky130_fd_sc_hd__o21ai_2
X_3514_ _5158_/Q _5139_/Q VGND VGND VPWR VPWR _3514_/X sky130_fd_sc_hd__and2_2
X_3445_ _5180_/Q _3226_/Y _3228_/Y _3444_/X VGND VGND VPWR VPWR _5180_/D sky130_fd_sc_hd__o22a_2
XFILLER_89_429 VGND VGND VPWR VPWR sky130_fd_sc_hd__decap_3
X_3376_ _5165_/Q _3376_/B VGND VGND VPWR VPWR _3377_/B sky130_fd_sc_hd__or2_2
XFILLER_57_304 VGND VGND VPWR VPWR sky130_fd_sc_hd__decap_3
XFILLER_69_175 VGND VGND VPWR VPWR sky130_fd_sc_hd__decap_3
X_5115_ _5115_/CLK _5115_/D VGND VGND VPWR VPWR _5115_/Q sky130_fd_sc_hd__dfxtp_2
XFILLER_84_101 VGND VGND VPWR VPWR sky130_fd_sc_hd__fill_1
XFILLER_57_337 VGND VGND VPWR VPWR sky130_fd_sc_hd__decap_3
X_5046_ _5094_/CLK _5046_/D VGND VGND VPWR VPWR _5046_/Q sky130_fd_sc_hd__dfxtp_2
XTAP_TAPCELL_ROW_68_844 VGND VPWR sky130_fd_sc_hd__tapvpwrvgnd_1
XFILLER_72_318 VGND VGND VPWR VPWR sky130_fd_sc_hd__fill_1
XFILLER_25_223 VGND VGND VPWR VPWR sky130_fd_sc_hd__fill_1
XFILLER_53_532 VGND VGND VPWR VPWR sky130_fd_sc_hd__decap_3
XFILLER_65_370 VGND VGND VPWR VPWR sky130_fd_sc_hd__decap_3
XFILLER_25_234 VGND VGND VPWR VPWR sky130_fd_sc_hd__decap_3
XFILLER_25_278 VGND VGND VPWR VPWR sky130_fd_sc_hd__fill_2
XFILLER_40_204 VGND VGND VPWR VPWR sky130_fd_sc_hd__decap_3
XFILLER_40_215 VGND VGND VPWR VPWR sky130_fd_sc_hd__decap_3
XTAP_TAPCELL_ROW_23_424 VGND VPWR sky130_fd_sc_hd__tapvpwrvgnd_1
XFILLER_88_440 VGND VGND VPWR VPWR sky130_fd_sc_hd__decap_3
XFILLER_0_377 VGND VGND VPWR VPWR sky130_fd_sc_hd__decap_3
XFILLER_88_495 VGND VGND VPWR VPWR sky130_fd_sc_hd__fill_1
XTAP_TAPCELL_ROW_89_1046 VGND VPWR sky130_fd_sc_hd__tapvpwrvgnd_1
XFILLER_29_551 VGND VGND VPWR VPWR sky130_fd_sc_hd__fill_2
XFILLER_75_156 VGND VGND VPWR VPWR sky130_fd_sc_hd__fill_1
XFILLER_75_178 VGND VGND VPWR VPWR sky130_fd_sc_hd__decap_3
XFILLER_16_212 VGND VGND VPWR VPWR sky130_fd_sc_hd__decap_3
XFILLER_56_392 VGND VGND VPWR VPWR sky130_fd_sc_hd__decap_3
XFILLER_17_82 VGND VGND VPWR VPWR sky130_fd_sc_hd__decap_3
XFILLER_71_340 VGND VGND VPWR VPWR sky130_fd_sc_hd__decap_3
XFILLER_31_204 VGND VGND VPWR VPWR sky130_fd_sc_hd__decap_3
XFILLER_71_373 VGND VGND VPWR VPWR sky130_fd_sc_hd__decap_3
XFILLER_31_237 VGND VGND VPWR VPWR sky130_fd_sc_hd__fill_2
XFILLER_8_444 VGND VGND VPWR VPWR sky130_fd_sc_hd__decap_3
XFILLER_8_433 VGND VGND VPWR VPWR sky130_fd_sc_hd__fill_2
XFILLER_8_477 VGND VGND VPWR VPWR sky130_fd_sc_hd__decap_3
X_3230_ _5168_/Q _3252_/C _3228_/Y _3229_/X VGND VGND VPWR VPWR _5123_/D sky130_fd_sc_hd__o22a_2
X_3161_ _2916_/X _3170_/A2 _3170_/B1 _5065_/Q VGND VGND VPWR VPWR _5065_/D sky130_fd_sc_hd__a22o_2
XFILLER_79_484 VGND VGND VPWR VPWR sky130_fd_sc_hd__decap_3
XFILLER_12_3 VGND VGND VPWR VPWR sky130_fd_sc_hd__fill_1
XFILLER_39_337 VGND VGND VPWR VPWR sky130_fd_sc_hd__decap_3
XFILLER_39_359 VGND VGND VPWR VPWR sky130_fd_sc_hd__fill_1
XFILLER_79_495 VGND VGND VPWR VPWR sky130_fd_sc_hd__decap_3
XFILLER_54_318 VGND VGND VPWR VPWR sky130_fd_sc_hd__fill_1
X_3092_ _2932_/X _3093_/A2 _3096_/B1 _5006_/Q VGND VGND VPWR VPWR _5006_/D sky130_fd_sc_hd__a22o_2
XFILLER_47_381 VGND VGND VPWR VPWR sky130_fd_sc_hd__decap_3
XFILLER_54_329 VGND VGND VPWR VPWR sky130_fd_sc_hd__decap_3
XTAP_TAPCELL_ROW_37_549 VGND VPWR sky130_fd_sc_hd__tapvpwrvgnd_1
XFILLER_62_340 VGND VGND VPWR VPWR sky130_fd_sc_hd__decap_3
XFILLER_81_159 VGND VGND VPWR VPWR sky130_fd_sc_hd__decap_3
X_3994_ _3999_/A _3995_/B VGND VGND VPWR VPWR _4279_/B sky130_fd_sc_hd__nor2_2
XTAP_TAPCELL_ROW_73_891 VGND VPWR sky130_fd_sc_hd__tapvpwrvgnd_1
X_2945_ _4882_/Q _2897_/Y _2944_/X _2897_/B VGND VGND VPWR VPWR _4882_/D sky130_fd_sc_hd__a22o_2
XFILLER_30_270 VGND VGND VPWR VPWR sky130_fd_sc_hd__decap_3
X_2876_ _3682_/D _2876_/B VGND VGND VPWR VPWR _2877_/B sky130_fd_sc_hd__xnor2_2
X_4615_ _3869_/Y _4470_/A _4470_/B _4588_/Y VGND VGND VPWR VPWR _4615_/X sky130_fd_sc_hd__a22o_2
X_4546_ _4546_/A _4546_/B VGND VGND VPWR VPWR _4556_/B sky130_fd_sc_hd__nor2_2
Xmax_cap130 _2986_/Y VGND VGND VPWR VPWR _2987_/B sky130_fd_sc_hd__clkbuf_8
Xmax_cap141 _3265_/B VGND VGND VPWR VPWR _3337_/A sky130_fd_sc_hd__buf_6
X_4477_ _4477_/A _4589_/A _4477_/C _4589_/B VGND VGND VPWR VPWR _4479_/A sky130_fd_sc_hd__or4_2
XFILLER_89_237 VGND VGND VPWR VPWR sky130_fd_sc_hd__decap_3
X_3428_ _5160_/Q _3450_/C _3228_/Y _3427_/X VGND VGND VPWR VPWR _5160_/D sky130_fd_sc_hd__o22a_2
X_3359_ _5144_/Q _3337_/A _3355_/X _3358_/Y _3442_/B VGND VGND VPWR VPWR _5144_/D
+ sky130_fd_sc_hd__o221a_2
XFILLER_85_432 VGND VGND VPWR VPWR sky130_fd_sc_hd__decap_3
XFILLER_72_126 VGND VGND VPWR VPWR sky130_fd_sc_hd__decap_3
X_5029_ _5063_/CLK _5029_/D VGND VGND VPWR VPWR _5029_/Q sky130_fd_sc_hd__dfxtp_2
XFILLER_53_340 VGND VGND VPWR VPWR sky130_fd_sc_hd__decap_3
XFILLER_53_373 VGND VGND VPWR VPWR sky130_fd_sc_hd__fill_2
XTAP_TAPCELL_ROW_0_196 VGND VPWR sky130_fd_sc_hd__tapvpwrvgnd_1
XFILLER_13_237 VGND VGND VPWR VPWR sky130_fd_sc_hd__fill_1
XFILLER_70_24 VGND VGND VPWR VPWR sky130_fd_sc_hd__decap_3
XFILLER_70_35 VGND VGND VPWR VPWR sky130_fd_sc_hd__fill_1
XFILLER_5_425 VGND VGND VPWR VPWR sky130_fd_sc_hd__decap_3
XFILLER_0_130 VGND VGND VPWR VPWR sky130_fd_sc_hd__decap_3
XFILLER_0_141 VGND VGND VPWR VPWR sky130_fd_sc_hd__decap_3
XTAP_TAPCELL_ROW_8_274 VGND VPWR sky130_fd_sc_hd__tapvpwrvgnd_1
XFILLER_48_112 VGND VGND VPWR VPWR sky130_fd_sc_hd__decap_3
XFILLER_76_443 VGND VGND VPWR VPWR sky130_fd_sc_hd__decap_3
XFILLER_76_421 VGND VGND VPWR VPWR sky130_fd_sc_hd__decap_3
XFILLER_76_465 VGND VGND VPWR VPWR sky130_fd_sc_hd__decap_3
XFILLER_91_413 VGND VGND VPWR VPWR sky130_fd_sc_hd__decap_3
XFILLER_32_502 VGND VGND VPWR VPWR sky130_fd_sc_hd__decap_3
XFILLER_44_362 VGND VGND VPWR VPWR sky130_fd_sc_hd__fill_2
XFILLER_44_395 VGND VGND VPWR VPWR sky130_fd_sc_hd__decap_3
XFILLER_12_270 VGND VGND VPWR VPWR sky130_fd_sc_hd__fill_2
X_2730_ _5133_/Q _2730_/B VGND VGND VPWR VPWR _2730_/X sky130_fd_sc_hd__or2_2
XTAP_TAPCELL_ROW_42_596 VGND VPWR sky130_fd_sc_hd__tapvpwrvgnd_1
XFILLER_81_6 VGND VGND VPWR VPWR sky130_fd_sc_hd__decap_3
X_2661_ _4429_/B VGND VGND VPWR VPWR _4479_/B sky130_fd_sc_hd__inv_2
XFILLER_60_90 VGND VGND VPWR VPWR sky130_fd_sc_hd__decap_3
X_4400_ _4391_/Y _4393_/Y _4396_/Y _4398_/Y VGND VGND VPWR VPWR _4419_/A sky130_fd_sc_hd__a2bb2o_2
X_2592_ _2590_/X _2591_/X _2667_/A VGND VGND VPWR VPWR _2592_/X sky130_fd_sc_hd__mux2_1
X_4331_ _4326_/A _4291_/A _4289_/B _4330_/Y _3744_/B VGND VGND VPWR VPWR _4332_/B
+ sky130_fd_sc_hd__a311o_2
XFILLER_4_480 VGND VGND VPWR VPWR sky130_fd_sc_hd__decap_3
X_4262_ _4800_/B _4260_/X _4261_/X _3442_/B VGND VGND VPWR VPWR _5216_/D sky130_fd_sc_hd__o211a_2
X_3213_ _2910_/X _3221_/A2 _3208_/Y _5111_/Q VGND VGND VPWR VPWR _5111_/D sky130_fd_sc_hd__a22o_2
X_4193_ _4170_/Y _4192_/X _4866_/A VGND VGND VPWR VPWR _5213_/D sky130_fd_sc_hd__a21oi_2
XFILLER_79_281 VGND VGND VPWR VPWR sky130_fd_sc_hd__decap_3
XFILLER_39_145 VGND VGND VPWR VPWR sky130_fd_sc_hd__decap_3
XFILLER_67_476 VGND VGND VPWR VPWR sky130_fd_sc_hd__decap_3
X_3144_ _2919_/X _3152_/A2 _3136_/Y _5050_/Q VGND VGND VPWR VPWR _5050_/D sky130_fd_sc_hd__a22o_2
XPHY_EDGE_ROW_19_Left_113 VGND VGND VPWR VPWR sky130_fd_sc_hd__decap_3
XFILLER_39_178 VGND VGND VPWR VPWR sky130_fd_sc_hd__decap_3
X_3075_ _2938_/X _3061_/B _3061_/Y _4992_/Q VGND VGND VPWR VPWR _4992_/D sky130_fd_sc_hd__a22o_2
XFILLER_54_137 VGND VGND VPWR VPWR sky130_fd_sc_hd__decap_3
XFILLER_54_159 VGND VGND VPWR VPWR sky130_fd_sc_hd__fill_1
XFILLER_82_457 VGND VGND VPWR VPWR sky130_fd_sc_hd__fill_2
XFILLER_35_373 VGND VGND VPWR VPWR sky130_fd_sc_hd__decap_3
XFILLER_50_321 VGND VGND VPWR VPWR sky130_fd_sc_hd__decap_3
XFILLER_50_365 VGND VGND VPWR VPWR sky130_fd_sc_hd__decap_3
X_3977_ _3977_/A VGND VGND VPWR VPWR _3977_/Y sky130_fd_sc_hd__inv_2
XFILLER_10_218 VGND VGND VPWR VPWR sky130_fd_sc_hd__decap_3
XFILLER_50_387 VGND VGND VPWR VPWR sky130_fd_sc_hd__decap_3
X_2928_ _5232_/Q _4850_/A _3458_/B _5216_/Q VGND VGND VPWR VPWR _2928_/X sky130_fd_sc_hd__a22o_2
XPHY_EDGE_ROW_28_Left_122 VGND VGND VPWR VPWR sky130_fd_sc_hd__decap_3
X_2859_ _2859_/A _3876_/A VGND VGND VPWR VPWR _2860_/B sky130_fd_sc_hd__xnor2_2
X_4529_ _4432_/B _4468_/Y _4589_/A VGND VGND VPWR VPWR _4529_/Y sky130_fd_sc_hd__a21oi_2
XFILLER_49_25 VGND VGND VPWR VPWR sky130_fd_sc_hd__decap_3
XFILLER_49_47 VGND VGND VPWR VPWR sky130_fd_sc_hd__fill_2
XFILLER_58_421 VGND VGND VPWR VPWR sky130_fd_sc_hd__fill_1
XPHY_EDGE_ROW_37_Left_131 VGND VGND VPWR VPWR sky130_fd_sc_hd__decap_3
XFILLER_18_307 VGND VGND VPWR VPWR sky130_fd_sc_hd__fill_1
XFILLER_18_318 VGND VGND VPWR VPWR sky130_fd_sc_hd__decap_3
XFILLER_73_413 VGND VGND VPWR VPWR sky130_fd_sc_hd__decap_3
XTAP_TAPCELL_ROW_86_1016 VGND VPWR sky130_fd_sc_hd__tapvpwrvgnd_1
XFILLER_85_284 VGND VGND VPWR VPWR sky130_fd_sc_hd__decap_3
XFILLER_45_137 VGND VGND VPWR VPWR sky130_fd_sc_hd__decap_3
XFILLER_65_68 VGND VGND VPWR VPWR sky130_fd_sc_hd__decap_3
XFILLER_73_457 VGND VGND VPWR VPWR sky130_fd_sc_hd__decap_3
XTAP_TAPCELL_ROW_84_997 VGND VPWR sky130_fd_sc_hd__tapvpwrvgnd_1
XFILLER_53_192 VGND VGND VPWR VPWR sky130_fd_sc_hd__decap_3
XFILLER_81_12 VGND VGND VPWR VPWR sky130_fd_sc_hd__decap_3
XFILLER_41_376 VGND VGND VPWR VPWR sky130_fd_sc_hd__decap_3
XPHY_EDGE_ROW_46_Left_140 VGND VGND VPWR VPWR sky130_fd_sc_hd__decap_3
XFILLER_5_200 VGND VGND VPWR VPWR sky130_fd_sc_hd__decap_3
XFILLER_68_207 VGND VGND VPWR VPWR sky130_fd_sc_hd__decap_3
XFILLER_1_494 VGND VGND VPWR VPWR sky130_fd_sc_hd__fill_2
XFILLER_49_432 VGND VGND VPWR VPWR sky130_fd_sc_hd__decap_3
Xinput9 INSTR_STREAM[17] VGND VGND VPWR VPWR input9/X sky130_fd_sc_hd__clkdlybuf4s25_1
XFILLER_76_273 VGND VGND VPWR VPWR sky130_fd_sc_hd__decap_3
XTAP_TAPCELL_ROW_47_644 VGND VPWR sky130_fd_sc_hd__tapvpwrvgnd_1
XFILLER_17_373 VGND VGND VPWR VPWR sky130_fd_sc_hd__decap_3
XFILLER_55_90 VGND VGND VPWR VPWR sky130_fd_sc_hd__decap_3
XTAP_TAPCELL_ROW_19_379 VGND VPWR sky130_fd_sc_hd__tapvpwrvgnd_1
XFILLER_32_321 VGND VGND VPWR VPWR sky130_fd_sc_hd__decap_3
X_4880_ _5134_/CLK _4880_/D VGND VGND VPWR VPWR _4880_/Q sky130_fd_sc_hd__dfxtp_2
X_3900_ _3900_/A _3900_/B VGND VGND VPWR VPWR _3900_/X sky130_fd_sc_hd__or2_2
XFILLER_32_354 VGND VGND VPWR VPWR sky130_fd_sc_hd__decap_3
X_3831_ _3831_/A _3831_/B VGND VGND VPWR VPWR _3831_/X sky130_fd_sc_hd__or2_2
XFILLER_32_376 VGND VGND VPWR VPWR sky130_fd_sc_hd__decap_3
X_3762_ _4961_/Q _4945_/Q _4929_/Q _4913_/Q _5127_/Q _5128_/Q VGND VGND VPWR VPWR
+ _3762_/X sky130_fd_sc_hd__mux4_2
X_3693_ _4704_/S _4284_/B VGND VGND VPWR VPWR _4196_/A sky130_fd_sc_hd__nor2_2
X_2713_ _4947_/Q _4931_/Q _4915_/Q _4899_/Q _2812_/S0 _2848_/S1 VGND VGND VPWR VPWR
+ _2713_/X sky130_fd_sc_hd__mux4_2
X_2644_ _5115_/Q _5003_/Q _4987_/Q _4971_/Q _5123_/Q _5124_/Q VGND VGND VPWR VPWR
+ _2644_/X sky130_fd_sc_hd__mux4_2
X_2575_ _5125_/Q _2575_/B VGND VGND VPWR VPWR _2575_/X sky130_fd_sc_hd__or2_2
X_4314_ _4339_/A _4314_/B VGND VGND VPWR VPWR _4314_/Y sky130_fd_sc_hd__nor2_2
XFILLER_59_207 VGND VGND VPWR VPWR sky130_fd_sc_hd__decap_3
X_4245_ _3903_/Y _3906_/Y _4285_/C VGND VGND VPWR VPWR _4278_/B sky130_fd_sc_hd__o21a_2
XFILLER_87_538 VGND VGND VPWR VPWR sky130_fd_sc_hd__decap_3
XFILLER_67_240 VGND VGND VPWR VPWR sky130_fd_sc_hd__decap_3
X_4176_ _4175_/X _4124_/B _4340_/A VGND VGND VPWR VPWR _4268_/B sky130_fd_sc_hd__mux2_1
XFILLER_55_402 VGND VGND VPWR VPWR sky130_fd_sc_hd__fill_1
XFILLER_55_435 VGND VGND VPWR VPWR sky130_fd_sc_hd__decap_3
XFILLER_67_284 VGND VGND VPWR VPWR sky130_fd_sc_hd__decap_3
X_3127_ _2926_/X _3117_/B _3133_/B1 _5036_/Q VGND VGND VPWR VPWR _5036_/D sky130_fd_sc_hd__a22o_2
XTAP_TAPCELL_ROW_2_225 VGND VPWR sky130_fd_sc_hd__tapvpwrvgnd_1
XFILLER_42_118 VGND VGND VPWR VPWR sky130_fd_sc_hd__fill_2
XFILLER_55_479 VGND VGND VPWR VPWR sky130_fd_sc_hd__decap_3
XFILLER_70_427 VGND VGND VPWR VPWR sky130_fd_sc_hd__decap_3
X_3058_ _2941_/X _3043_/B _3043_/Y _4977_/Q VGND VGND VPWR VPWR _4977_/D sky130_fd_sc_hd__a22o_2
XFILLER_23_321 VGND VGND VPWR VPWR sky130_fd_sc_hd__decap_3
XFILLER_82_298 VGND VGND VPWR VPWR sky130_fd_sc_hd__decap_3
XFILLER_11_505 VGND VGND VPWR VPWR sky130_fd_sc_hd__decap_3
XFILLER_23_343 VGND VGND VPWR VPWR sky130_fd_sc_hd__decap_3
XTAP_TAPCELL_ROW_81_967 VGND VPWR sky130_fd_sc_hd__tapvpwrvgnd_1
XFILLER_11_549 VGND VGND VPWR VPWR sky130_fd_sc_hd__decap_3
XFILLER_50_184 VGND VGND VPWR VPWR sky130_fd_sc_hd__fill_1
XFILLER_51_26 VGND VGND VPWR VPWR sky130_fd_sc_hd__decap_3
XFILLER_2_203 VGND VGND VPWR VPWR sky130_fd_sc_hd__fill_1
XTAP_TAPCELL_ROW_92_1075 VGND VPWR sky130_fd_sc_hd__tapvpwrvgnd_1
XFILLER_76_12 VGND VGND VPWR VPWR sky130_fd_sc_hd__decap_3
XFILLER_58_240 VGND VGND VPWR VPWR sky130_fd_sc_hd__decap_3
XFILLER_93_508 VGND VGND VPWR VPWR sky130_fd_sc_hd__decap_3
XFILLER_18_115 VGND VGND VPWR VPWR sky130_fd_sc_hd__decap_3
XFILLER_46_424 VGND VGND VPWR VPWR sky130_fd_sc_hd__decap_3
XFILLER_18_126 VGND VGND VPWR VPWR sky130_fd_sc_hd__decap_3
XFILLER_58_295 VGND VGND VPWR VPWR sky130_fd_sc_hd__decap_3
XFILLER_73_221 VGND VGND VPWR VPWR sky130_fd_sc_hd__decap_3
XFILLER_73_243 VGND VGND VPWR VPWR sky130_fd_sc_hd__fill_2
XFILLER_61_405 VGND VGND VPWR VPWR sky130_fd_sc_hd__decap_3
XFILLER_73_276 VGND VGND VPWR VPWR sky130_fd_sc_hd__decap_3
XFILLER_73_287 VGND VGND VPWR VPWR sky130_fd_sc_hd__decap_3
XFILLER_26_170 VGND VGND VPWR VPWR sky130_fd_sc_hd__decap_3
XFILLER_61_449 VGND VGND VPWR VPWR sky130_fd_sc_hd__decap_3
XFILLER_14_365 VGND VGND VPWR VPWR sky130_fd_sc_hd__decap_3
XTAP_TAPCELL_ROW_16_349 VGND VPWR sky130_fd_sc_hd__tapvpwrvgnd_1
XTAP_TAPCELL_ROW_52_691 VGND VPWR sky130_fd_sc_hd__tapvpwrvgnd_1
XFILLER_41_81 VGND VGND VPWR VPWR sky130_fd_sc_hd__fill_1
XFILLER_41_92 VGND VGND VPWR VPWR sky130_fd_sc_hd__decap_3
XFILLER_69_505 VGND VGND VPWR VPWR sky130_fd_sc_hd__decap_3
X_4030_ _4107_/A _4255_/B _4027_/X _3651_/Y _4029_/X VGND VGND VPWR VPWR _4030_/X
+ sky130_fd_sc_hd__o221a_2
XPHY_EDGE_ROW_10_Right_10 VGND VGND VPWR VPWR sky130_fd_sc_hd__decap_3
XFILLER_37_413 VGND VGND VPWR VPWR sky130_fd_sc_hd__decap_3
XFILLER_49_273 VGND VGND VPWR VPWR sky130_fd_sc_hd__decap_3
XFILLER_49_284 VGND VGND VPWR VPWR sky130_fd_sc_hd__decap_3
XFILLER_37_435 VGND VGND VPWR VPWR sky130_fd_sc_hd__decap_3
XFILLER_64_232 VGND VGND VPWR VPWR sky130_fd_sc_hd__decap_3
XFILLER_92_541 VGND VGND VPWR VPWR sky130_fd_sc_hd__decap_3
XFILLER_92_530 VGND VGND VPWR VPWR sky130_fd_sc_hd__fill_2
XFILLER_24_129 VGND VGND VPWR VPWR sky130_fd_sc_hd__decap_3
XFILLER_45_490 VGND VGND VPWR VPWR sky130_fd_sc_hd__decap_3
XFILLER_52_427 VGND VGND VPWR VPWR sky130_fd_sc_hd__decap_3
XFILLER_64_287 VGND VGND VPWR VPWR sky130_fd_sc_hd__fill_1
XFILLER_64_298 VGND VGND VPWR VPWR sky130_fd_sc_hd__decap_3
X_4932_ _5119_/CLK _4932_/D VGND VGND VPWR VPWR _4932_/Q sky130_fd_sc_hd__dfxtp_2
XFILLER_32_173 VGND VGND VPWR VPWR sky130_fd_sc_hd__decap_3
XFILLER_60_460 VGND VGND VPWR VPWR sky130_fd_sc_hd__decap_3
X_4863_ _5172_/Q _3252_/C _3245_/X _3448_/B VGND VGND VPWR VPWR _5172_/D sky130_fd_sc_hd__o211a_2
X_4794_ _3457_/A _4546_/A _4794_/S VGND VGND VPWR VPWR _4794_/X sky130_fd_sc_hd__mux2_1
X_3814_ _5112_/Q _5000_/Q _4984_/Q _4968_/Q _3834_/S0 _3834_/S1 VGND VGND VPWR VPWR
+ _3814_/X sky130_fd_sc_hd__mux4_2
X_3745_ _5071_/Q _5055_/Q _5039_/Q _5023_/Q _3834_/S0 _3834_/S1 VGND VGND VPWR VPWR
+ _3745_/X sky130_fd_sc_hd__mux4_2
X_3676_ _4103_/B VGND VGND VPWR VPWR _3676_/Y sky130_fd_sc_hd__inv_2
X_2627_ _2667_/A _2627_/B VGND VGND VPWR VPWR _2627_/X sky130_fd_sc_hd__or2_2
X_2558_ _4466_/B VGND VGND VPWR VPWR _3934_/B sky130_fd_sc_hd__inv_2
X_2489_ _5166_/Q _4551_/A VGND VGND VPWR VPWR _2490_/B sky130_fd_sc_hd__or2_2
XFILLER_87_335 VGND VGND VPWR VPWR sky130_fd_sc_hd__fill_1
X_4228_ _4297_/A _4314_/B VGND VGND VPWR VPWR _4228_/Y sky130_fd_sc_hd__nor2_2
XFILLER_87_379 VGND VGND VPWR VPWR sky130_fd_sc_hd__decap_3
XFILLER_28_424 VGND VGND VPWR VPWR sky130_fd_sc_hd__decap_3
XFILLER_28_457 VGND VGND VPWR VPWR sky130_fd_sc_hd__decap_3
XFILLER_55_210 VGND VGND VPWR VPWR sky130_fd_sc_hd__decap_3
XFILLER_55_232 VGND VGND VPWR VPWR sky130_fd_sc_hd__fill_1
X_4159_ _4149_/A _3998_/Y _4000_/X _4164_/A _4158_/X VGND VGND VPWR VPWR _4159_/X
+ sky130_fd_sc_hd__a221o_2
XFILLER_83_552 VGND VGND VPWR VPWR sky130_fd_sc_hd__fill_1
XFILLER_15_107 VGND VGND VPWR VPWR sky130_fd_sc_hd__decap_3
XFILLER_43_405 VGND VGND VPWR VPWR sky130_fd_sc_hd__decap_3
XFILLER_43_449 VGND VGND VPWR VPWR sky130_fd_sc_hd__decap_3
XFILLER_55_287 VGND VGND VPWR VPWR sky130_fd_sc_hd__decap_3
XFILLER_11_313 VGND VGND VPWR VPWR sky130_fd_sc_hd__decap_3
XFILLER_51_482 VGND VGND VPWR VPWR sky130_fd_sc_hd__decap_3
XFILLER_11_51 VGND VGND VPWR VPWR sky130_fd_sc_hd__decap_3
XFILLER_3_501 VGND VGND VPWR VPWR sky130_fd_sc_hd__decap_3
XFILLER_3_523 VGND VGND VPWR VPWR sky130_fd_sc_hd__decap_3
XFILLER_11_95 VGND VGND VPWR VPWR sky130_fd_sc_hd__decap_3
XFILLER_87_33 VGND VGND VPWR VPWR sky130_fd_sc_hd__fill_1
XFILLER_87_55 VGND VGND VPWR VPWR sky130_fd_sc_hd__fill_1
XFILLER_78_324 VGND VGND VPWR VPWR sky130_fd_sc_hd__decap_3
XFILLER_66_519 VGND VGND VPWR VPWR sky130_fd_sc_hd__decap_3
XFILLER_19_402 VGND VGND VPWR VPWR sky130_fd_sc_hd__decap_3
XFILLER_93_327 VGND VGND VPWR VPWR sky130_fd_sc_hd__fill_1
XFILLER_93_305 VGND VGND VPWR VPWR sky130_fd_sc_hd__decap_3
XFILLER_19_424 VGND VGND VPWR VPWR sky130_fd_sc_hd__decap_3
XFILLER_19_457 VGND VGND VPWR VPWR sky130_fd_sc_hd__decap_3
XFILLER_46_221 VGND VGND VPWR VPWR sky130_fd_sc_hd__decap_3
XFILLER_93_349 VGND VGND VPWR VPWR sky130_fd_sc_hd__decap_3
XFILLER_34_405 VGND VGND VPWR VPWR sky130_fd_sc_hd__decap_3
XFILLER_46_265 VGND VGND VPWR VPWR sky130_fd_sc_hd__decap_3
XFILLER_74_552 VGND VGND VPWR VPWR sky130_fd_sc_hd__fill_1
XFILLER_27_490 VGND VGND VPWR VPWR sky130_fd_sc_hd__decap_3
XFILLER_34_427 VGND VGND VPWR VPWR sky130_fd_sc_hd__decap_3
XFILLER_36_70 VGND VGND VPWR VPWR sky130_fd_sc_hd__decap_3
XFILLER_61_213 VGND VGND VPWR VPWR sky130_fd_sc_hd__fill_1
XTAP_TAPCELL_ROW_29_474 VGND VPWR sky130_fd_sc_hd__tapvpwrvgnd_1
XFILLER_61_246 VGND VGND VPWR VPWR sky130_fd_sc_hd__decap_3
XFILLER_61_279 VGND VGND VPWR VPWR sky130_fd_sc_hd__fill_1
XFILLER_42_493 VGND VGND VPWR VPWR sky130_fd_sc_hd__fill_1
XFILLER_52_91 VGND VGND VPWR VPWR sky130_fd_sc_hd__decap_3
Xinput12 INSTR_STREAM[1] VGND VGND VPWR VPWR _3412_/C sky130_fd_sc_hd__clkdlybuf4s25_1
Xinput45 MEM_LD_DATA[6] VGND VGND VPWR VPWR input45/X sky130_fd_sc_hd__clkdlybuf4s25_1
Xinput34 MEM_LD_DATA[10] VGND VGND VPWR VPWR input34/X sky130_fd_sc_hd__clkdlybuf4s25_1
Xinput23 INSTR_STREAM[2] VGND VGND VPWR VPWR _3414_/C sky130_fd_sc_hd__clkdlybuf4s25_1
X_3530_ _3534_/A VGND VGND VPWR VPWR _3537_/A sky130_fd_sc_hd__inv_2
XFILLER_6_350 VGND VGND VPWR VPWR sky130_fd_sc_hd__decap_3
XFILLER_6_383 VGND VGND VPWR VPWR sky130_fd_sc_hd__decap_3
X_3461_ _5176_/Q _5011_/Q _5013_/Q _5177_/Q VGND VGND VPWR VPWR _3461_/X sky130_fd_sc_hd__a22o_2
X_5200_ _5200_/CLK _5200_/D VGND VGND VPWR VPWR _5200_/Q sky130_fd_sc_hd__dfxtp_2
X_3392_ _5147_/Q _3392_/B VGND VGND VPWR VPWR _3400_/B sky130_fd_sc_hd__nand2_2
X_5131_ clkload5/A _5131_/D VGND VGND VPWR VPWR _5131_/Q sky130_fd_sc_hd__dfxtp_4
XFILLER_69_346 VGND VGND VPWR VPWR sky130_fd_sc_hd__decap_3
X_5062_ _5094_/CLK _5062_/D VGND VGND VPWR VPWR _5062_/Q sky130_fd_sc_hd__dfxtp_2
X_4013_ _4012_/X _4008_/X _4173_/A VGND VGND VPWR VPWR _4013_/X sky130_fd_sc_hd__mux2_1
XFILLER_84_327 VGND VGND VPWR VPWR sky130_fd_sc_hd__fill_2
XFILLER_77_390 VGND VGND VPWR VPWR sky130_fd_sc_hd__fill_2
XFILLER_37_243 VGND VGND VPWR VPWR sky130_fd_sc_hd__decap_3
XFILLER_16_29 VGND VGND VPWR VPWR sky130_fd_sc_hd__decap_3
XFILLER_37_287 VGND VGND VPWR VPWR sky130_fd_sc_hd__decap_3
XFILLER_52_202 VGND VGND VPWR VPWR sky130_fd_sc_hd__decap_3
XFILLER_52_213 VGND VGND VPWR VPWR sky130_fd_sc_hd__decap_3
XFILLER_92_371 VGND VGND VPWR VPWR sky130_fd_sc_hd__decap_3
XFILLER_52_246 VGND VGND VPWR VPWR sky130_fd_sc_hd__decap_3
XFILLER_52_268 VGND VGND VPWR VPWR sky130_fd_sc_hd__decap_3
XFILLER_33_482 VGND VGND VPWR VPWR sky130_fd_sc_hd__fill_1
XFILLER_40_419 VGND VGND VPWR VPWR sky130_fd_sc_hd__fill_1
X_4915_ _4982_/CLK _4915_/D VGND VGND VPWR VPWR _4915_/Q sky130_fd_sc_hd__dfxtp_2
XTAP_TAPCELL_ROW_63_797 VGND VPWR sky130_fd_sc_hd__tapvpwrvgnd_1
X_4846_ input38/X _4816_/Y _4845_/X _3442_/B VGND VGND VPWR VPWR _5252_/D sky130_fd_sc_hd__o211a_2
X_4777_ _4635_/B _4773_/Y _4776_/X _4661_/A _4537_/X VGND VGND VPWR VPWR _4778_/B
+ sky130_fd_sc_hd__a32o_2
XFILLER_4_309 VGND VGND VPWR VPWR sky130_fd_sc_hd__decap_3
X_3728_ _4449_/B _4405_/A VGND VGND VPWR VPWR _4546_/B sky130_fd_sc_hd__or2_2
X_3659_ _4445_/B _4449_/B _4010_/S VGND VGND VPWR VPWR _3659_/X sky130_fd_sc_hd__mux2_1
XFILLER_0_548 VGND VGND VPWR VPWR sky130_fd_sc_hd__decap_3
XFILLER_57_36 VGND VGND VPWR VPWR sky130_fd_sc_hd__decap_3
XFILLER_57_69 VGND VGND VPWR VPWR sky130_fd_sc_hd__decap_3
XFILLER_87_187 VGND VGND VPWR VPWR sky130_fd_sc_hd__fill_1
XFILLER_87_165 VGND VGND VPWR VPWR sky130_fd_sc_hd__decap_3
XFILLER_75_349 VGND VGND VPWR VPWR sky130_fd_sc_hd__decap_3
XFILLER_28_265 VGND VGND VPWR VPWR sky130_fd_sc_hd__fill_1
XFILLER_56_552 VGND VGND VPWR VPWR sky130_fd_sc_hd__fill_1
XFILLER_71_511 VGND VGND VPWR VPWR sky130_fd_sc_hd__decap_3
XFILLER_73_46 VGND VGND VPWR VPWR sky130_fd_sc_hd__fill_2
XFILLER_83_393 VGND VGND VPWR VPWR sky130_fd_sc_hd__decap_3
XFILLER_83_371 VGND VGND VPWR VPWR sky130_fd_sc_hd__decap_3
XFILLER_73_57 VGND VGND VPWR VPWR sky130_fd_sc_hd__fill_1
XTAP_TAPCELL_ROW_26_444 VGND VPWR sky130_fd_sc_hd__tapvpwrvgnd_1
XFILLER_51_290 VGND VGND VPWR VPWR sky130_fd_sc_hd__decap_3
XFILLER_11_165 VGND VGND VPWR VPWR sky130_fd_sc_hd__decap_3
XFILLER_11_198 VGND VGND VPWR VPWR sky130_fd_sc_hd__decap_3
XFILLER_22_83 VGND VGND VPWR VPWR sky130_fd_sc_hd__fill_1
XFILLER_7_169 VGND VGND VPWR VPWR sky130_fd_sc_hd__decap_3
XFILLER_3_331 VGND VGND VPWR VPWR sky130_fd_sc_hd__decap_3
XFILLER_39_508 VGND VGND VPWR VPWR sky130_fd_sc_hd__decap_3
XFILLER_93_113 VGND VGND VPWR VPWR sky130_fd_sc_hd__decap_3
XFILLER_78_176 VGND VGND VPWR VPWR sky130_fd_sc_hd__decap_3
XFILLER_66_338 VGND VGND VPWR VPWR sky130_fd_sc_hd__decap_3
XFILLER_19_243 VGND VGND VPWR VPWR sky130_fd_sc_hd__decap_3
XFILLER_62_500 VGND VGND VPWR VPWR sky130_fd_sc_hd__decap_3
XFILLER_81_308 VGND VGND VPWR VPWR sky130_fd_sc_hd__decap_3
XFILLER_74_371 VGND VGND VPWR VPWR sky130_fd_sc_hd__decap_3
X_2961_ _2935_/X _2961_/A2 _2961_/B1 _4895_/Q VGND VGND VPWR VPWR _4895_/D sky130_fd_sc_hd__a22o_2
XFILLER_15_493 VGND VGND VPWR VPWR sky130_fd_sc_hd__decap_3
XFILLER_42_290 VGND VGND VPWR VPWR sky130_fd_sc_hd__decap_3
X_4700_ _2419_/Y _4699_/X _4700_/S VGND VGND VPWR VPWR _4701_/B sky130_fd_sc_hd__mux2_1
X_4631_ _5226_/Q _4850_/B VGND VGND VPWR VPWR _4631_/Y sky130_fd_sc_hd__nand2_2
X_2892_ _5187_/Q _5186_/Q VGND VGND VPWR VPWR _3135_/A sky130_fd_sc_hd__nand2b_2
XTAP_TAPCELL_ROW_60_767 VGND VPWR sky130_fd_sc_hd__tapvpwrvgnd_1
XFILLER_8_85 VGND VGND VPWR VPWR sky130_fd_sc_hd__fill_2
X_4562_ _5224_/Q _4850_/B VGND VGND VPWR VPWR _4562_/Y sky130_fd_sc_hd__nand2_2
XFILLER_6_180 VGND VGND VPWR VPWR sky130_fd_sc_hd__decap_3
X_4493_ _4493_/A _4493_/B _4493_/C VGND VGND VPWR VPWR _4565_/A sky130_fd_sc_hd__or3_2
X_3513_ _4866_/A _3513_/B VGND VGND VPWR VPWR _5195_/D sky130_fd_sc_hd__nor2_2
X_3444_ _5260_/Q _3448_/B _3444_/C VGND VGND VPWR VPWR _3444_/X sky130_fd_sc_hd__and3_2
XFILLER_89_408 VGND VGND VPWR VPWR sky130_fd_sc_hd__decap_3
XFILLER_69_132 VGND VGND VPWR VPWR sky130_fd_sc_hd__fill_1
X_3375_ _5165_/Q _3376_/B VGND VGND VPWR VPWR _3375_/X sky130_fd_sc_hd__and2_2
XFILLER_57_316 VGND VGND VPWR VPWR sky130_fd_sc_hd__decap_3
XFILLER_69_165 VGND VGND VPWR VPWR sky130_fd_sc_hd__decap_3
X_5114_ _5114_/CLK _5114_/D VGND VGND VPWR VPWR _5114_/Q sky130_fd_sc_hd__dfxtp_2
XFILLER_38_530 VGND VGND VPWR VPWR sky130_fd_sc_hd__fill_2
XFILLER_57_349 VGND VGND VPWR VPWR sky130_fd_sc_hd__fill_2
XFILLER_69_187 VGND VGND VPWR VPWR sky130_fd_sc_hd__fill_1
X_5045_ _5078_/CLK _5045_/D VGND VGND VPWR VPWR _5045_/Q sky130_fd_sc_hd__dfxtp_2
XTAP_TAPCELL_ROW_68_845 VGND VPWR sky130_fd_sc_hd__tapvpwrvgnd_1
XFILLER_25_202 VGND VGND VPWR VPWR sky130_fd_sc_hd__decap_3
XFILLER_53_511 VGND VGND VPWR VPWR sky130_fd_sc_hd__decap_3
XFILLER_65_393 VGND VGND VPWR VPWR sky130_fd_sc_hd__decap_3
XFILLER_25_246 VGND VGND VPWR VPWR sky130_fd_sc_hd__decap_3
XFILLER_53_544 VGND VGND VPWR VPWR sky130_fd_sc_hd__decap_3
XFILLER_80_374 VGND VGND VPWR VPWR sky130_fd_sc_hd__decap_3
XFILLER_80_363 VGND VGND VPWR VPWR sky130_fd_sc_hd__fill_1
XFILLER_21_452 VGND VGND VPWR VPWR sky130_fd_sc_hd__decap_3
X_4829_ _5244_/Q _4847_/B VGND VGND VPWR VPWR _4829_/X sky130_fd_sc_hd__or2_2
XFILLER_4_139 VGND VGND VPWR VPWR sky130_fd_sc_hd__fill_1
XFILLER_0_312 VGND VGND VPWR VPWR sky130_fd_sc_hd__decap_3
XFILLER_68_35 VGND VGND VPWR VPWR sky130_fd_sc_hd__fill_2
XFILLER_0_334 VGND VGND VPWR VPWR sky130_fd_sc_hd__fill_2
XFILLER_68_46 VGND VGND VPWR VPWR sky130_fd_sc_hd__decap_3
XFILLER_68_57 VGND VGND VPWR VPWR sky130_fd_sc_hd__decap_3
XFILLER_88_452 VGND VGND VPWR VPWR sky130_fd_sc_hd__decap_3
XFILLER_0_356 VGND VGND VPWR VPWR sky130_fd_sc_hd__decap_3
XFILLER_48_327 VGND VGND VPWR VPWR sky130_fd_sc_hd__decap_3
XFILLER_75_113 VGND VGND VPWR VPWR sky130_fd_sc_hd__decap_3
XTAP_TAPCELL_ROW_89_1047 VGND VPWR sky130_fd_sc_hd__tapvpwrvgnd_1
XFILLER_44_500 VGND VGND VPWR VPWR sky130_fd_sc_hd__decap_3
XFILLER_56_371 VGND VGND VPWR VPWR sky130_fd_sc_hd__decap_3
XFILLER_84_78 VGND VGND VPWR VPWR sky130_fd_sc_hd__decap_3
XFILLER_71_352 VGND VGND VPWR VPWR sky130_fd_sc_hd__decap_3
XFILLER_16_279 VGND VGND VPWR VPWR sky130_fd_sc_hd__decap_3
XFILLER_17_94 VGND VGND VPWR VPWR sky130_fd_sc_hd__decap_3
XFILLER_71_385 VGND VGND VPWR VPWR sky130_fd_sc_hd__decap_3
XFILLER_71_396 VGND VGND VPWR VPWR sky130_fd_sc_hd__decap_3
XFILLER_12_485 VGND VGND VPWR VPWR sky130_fd_sc_hd__decap_3
XFILLER_76_9 VGND VGND VPWR VPWR sky130_fd_sc_hd__decap_3
XFILLER_8_489 VGND VGND VPWR VPWR sky130_fd_sc_hd__fill_2
XFILLER_8_456 VGND VGND VPWR VPWR sky130_fd_sc_hd__decap_3
XFILLER_79_452 VGND VGND VPWR VPWR sky130_fd_sc_hd__decap_3
X_3160_ _2913_/X _3170_/A2 _3170_/B1 _5064_/Q VGND VGND VPWR VPWR _5064_/D sky130_fd_sc_hd__a22o_2
X_3091_ _2929_/X _3093_/A2 _3096_/B1 _5005_/Q VGND VGND VPWR VPWR _5005_/D sky130_fd_sc_hd__a22o_2
XTAP_TAPCELL_ROW_65_815 VGND VPWR sky130_fd_sc_hd__tapvpwrvgnd_1
XFILLER_35_500 VGND VGND VPWR VPWR sky130_fd_sc_hd__decap_3
XFILLER_35_511 VGND VGND VPWR VPWR sky130_fd_sc_hd__decap_3
XFILLER_47_360 VGND VGND VPWR VPWR sky130_fd_sc_hd__decap_3
XFILLER_50_514 VGND VGND VPWR VPWR sky130_fd_sc_hd__decap_3
XFILLER_62_352 VGND VGND VPWR VPWR sky130_fd_sc_hd__decap_3
XFILLER_62_374 VGND VGND VPWR VPWR sky130_fd_sc_hd__decap_3
XPHY_EDGE_ROW_8_Right_8 VGND VGND VPWR VPWR sky130_fd_sc_hd__decap_3
XFILLER_50_547 VGND VGND VPWR VPWR sky130_fd_sc_hd__decap_3
X_3993_ _3992_/A _3992_/B _3992_/Y _4546_/A VGND VGND VPWR VPWR _3993_/X sky130_fd_sc_hd__a211o_2
XTAP_TAPCELL_ROW_73_892 VGND VPWR sky130_fd_sc_hd__tapvpwrvgnd_1
X_2944_ _5205_/Q _2455_/X _3456_/B _5253_/Q _2943_/X VGND VGND VPWR VPWR _2944_/X
+ sky130_fd_sc_hd__a221o_2
XFILLER_30_282 VGND VGND VPWR VPWR sky130_fd_sc_hd__decap_3
X_2875_ _2870_/A _2679_/B _2681_/B VGND VGND VPWR VPWR _2876_/B sky130_fd_sc_hd__a21bo_2
X_4614_ _4614_/A _4614_/B VGND VGND VPWR VPWR _4614_/X sky130_fd_sc_hd__or2_2
X_4545_ _4545_/A _4607_/A VGND VGND VPWR VPWR _4545_/Y sky130_fd_sc_hd__nand2_2
Xmax_cap120 _3208_/B VGND VGND VPWR VPWR _3221_/A2 sky130_fd_sc_hd__buf_6
Xmax_cap131 _2948_/B VGND VGND VPWR VPWR _2961_/A2 sky130_fd_sc_hd__buf_6
Xmax_cap142 _5132_/Q VGND VGND VPWR VPWR _2848_/S1 sky130_fd_sc_hd__buf_12
X_4476_ _4341_/A _4471_/B _4532_/A _4473_/X _4475_/X VGND VGND VPWR VPWR _4476_/X
+ sky130_fd_sc_hd__o311a_2
X_3427_ _5260_/Q _3448_/B _3427_/C VGND VGND VPWR VPWR _3427_/X sky130_fd_sc_hd__and3_2
XPHY_EDGE_ROW_39_Right_39 VGND VGND VPWR VPWR sky130_fd_sc_hd__decap_3
XFILLER_89_249 VGND VGND VPWR VPWR sky130_fd_sc_hd__decap_3
X_3358_ _5185_/Q _3380_/C _3357_/Y _3337_/A VGND VGND VPWR VPWR _3358_/Y sky130_fd_sc_hd__o31ai_2
XFILLER_57_113 VGND VGND VPWR VPWR sky130_fd_sc_hd__decap_3
XFILLER_85_444 VGND VGND VPWR VPWR sky130_fd_sc_hd__decap_3
X_3289_ _5137_/Q _3265_/B _3288_/Y _3448_/B VGND VGND VPWR VPWR _5137_/D sky130_fd_sc_hd__o211a_2
XFILLER_85_466 VGND VGND VPWR VPWR sky130_fd_sc_hd__decap_3
XFILLER_85_455 VGND VGND VPWR VPWR sky130_fd_sc_hd__fill_2
XFILLER_38_360 VGND VGND VPWR VPWR sky130_fd_sc_hd__decap_3
XFILLER_45_319 VGND VGND VPWR VPWR sky130_fd_sc_hd__decap_3
X_5028_ _5092_/CLK _5028_/D VGND VGND VPWR VPWR _5028_/Q sky130_fd_sc_hd__dfxtp_2
XFILLER_26_533 VGND VGND VPWR VPWR sky130_fd_sc_hd__fill_2
XFILLER_38_393 VGND VGND VPWR VPWR sky130_fd_sc_hd__decap_3
XFILLER_65_190 VGND VGND VPWR VPWR sky130_fd_sc_hd__decap_3
XFILLER_41_525 VGND VGND VPWR VPWR sky130_fd_sc_hd__fill_1
XTAP_TAPCELL_ROW_0_197 VGND VPWR sky130_fd_sc_hd__tapvpwrvgnd_1
XFILLER_53_396 VGND VGND VPWR VPWR sky130_fd_sc_hd__decap_3
XPHY_EDGE_ROW_48_Right_48 VGND VGND VPWR VPWR sky130_fd_sc_hd__decap_3
XPHY_EDGE_ROW_57_Right_57 VGND VGND VPWR VPWR sky130_fd_sc_hd__decap_3
XFILLER_0_153 VGND VGND VPWR VPWR sky130_fd_sc_hd__decap_3
XTAP_TAPCELL_ROW_8_275 VGND VPWR sky130_fd_sc_hd__tapvpwrvgnd_1
XFILLER_0_175 VGND VGND VPWR VPWR sky130_fd_sc_hd__decap_3
XFILLER_0_197 VGND VGND VPWR VPWR sky130_fd_sc_hd__decap_3
XFILLER_88_282 VGND VGND VPWR VPWR sky130_fd_sc_hd__decap_3
XFILLER_76_477 VGND VGND VPWR VPWR sky130_fd_sc_hd__decap_3
XFILLER_28_71 VGND VGND VPWR VPWR sky130_fd_sc_hd__decap_3
XFILLER_29_371 VGND VGND VPWR VPWR sky130_fd_sc_hd__decap_3
XFILLER_48_179 VGND VGND VPWR VPWR sky130_fd_sc_hd__decap_3
XFILLER_76_499 VGND VGND VPWR VPWR sky130_fd_sc_hd__fill_1
XFILLER_17_544 VGND VGND VPWR VPWR sky130_fd_sc_hd__decap_3
XFILLER_29_393 VGND VGND VPWR VPWR sky130_fd_sc_hd__decap_3
XFILLER_44_374 VGND VGND VPWR VPWR sky130_fd_sc_hd__decap_3
XFILLER_71_160 VGND VGND VPWR VPWR sky130_fd_sc_hd__decap_3
XPHY_EDGE_ROW_66_Right_66 VGND VGND VPWR VPWR sky130_fd_sc_hd__decap_3
XFILLER_32_536 VGND VGND VPWR VPWR sky130_fd_sc_hd__decap_3
XTAP_TAPCELL_ROW_70_862 VGND VPWR sky130_fd_sc_hd__tapvpwrvgnd_1
XTAP_TAPCELL_ROW_42_597 VGND VPWR sky130_fd_sc_hd__tapvpwrvgnd_1
X_2660_ _2655_/X _2656_/X _2659_/X _2435_/Y VGND VGND VPWR VPWR _4429_/B sky130_fd_sc_hd__a22o_2
XFILLER_8_253 VGND VGND VPWR VPWR sky130_fd_sc_hd__fill_1
XFILLER_8_297 VGND VGND VPWR VPWR sky130_fd_sc_hd__decap_3
X_2591_ _5108_/Q _4996_/Q _4980_/Q _4964_/Q _2658_/S0 _2671_/S1 VGND VGND VPWR VPWR
+ _2591_/X sky130_fd_sc_hd__mux4_2
XPHY_EDGE_ROW_75_Right_75 VGND VGND VPWR VPWR sky130_fd_sc_hd__decap_3
XFILLER_5_42 VGND VGND VPWR VPWR sky130_fd_sc_hd__decap_3
X_4330_ _4779_/S _4330_/B VGND VGND VPWR VPWR _4330_/Y sky130_fd_sc_hd__nor2_2
XFILLER_4_492 VGND VGND VPWR VPWR sky130_fd_sc_hd__decap_3
X_4261_ _5216_/Q _4700_/S VGND VGND VPWR VPWR _4261_/X sky130_fd_sc_hd__or2_2
X_3212_ _2906_/X _3221_/A2 _3208_/Y _5110_/Q VGND VGND VPWR VPWR _5110_/D sky130_fd_sc_hd__a22o_2
XFILLER_67_411 VGND VGND VPWR VPWR sky130_fd_sc_hd__decap_3
XFILLER_67_422 VGND VGND VPWR VPWR sky130_fd_sc_hd__decap_3
X_4192_ _2452_/Y _4191_/Y _4189_/X _4850_/B VGND VGND VPWR VPWR _4192_/X sky130_fd_sc_hd__a211o_2
XFILLER_79_293 VGND VGND VPWR VPWR sky130_fd_sc_hd__decap_3
XFILLER_67_444 VGND VGND VPWR VPWR sky130_fd_sc_hd__decap_3
X_3143_ _2916_/X _3152_/A2 _3136_/Y _5049_/Q VGND VGND VPWR VPWR _5049_/D sky130_fd_sc_hd__a22o_2
XTAP_TAPCELL_ROW_78_940 VGND VPWR sky130_fd_sc_hd__tapvpwrvgnd_1
X_3074_ _2935_/X _3074_/A2 _3061_/Y _4991_/Q VGND VGND VPWR VPWR _4991_/D sky130_fd_sc_hd__a22o_2
XPHY_EDGE_ROW_84_Right_84 VGND VGND VPWR VPWR sky130_fd_sc_hd__decap_3
XFILLER_82_414 VGND VGND VPWR VPWR sky130_fd_sc_hd__decap_3
XFILLER_82_403 VGND VGND VPWR VPWR sky130_fd_sc_hd__decap_3
XFILLER_23_514 VGND VGND VPWR VPWR sky130_fd_sc_hd__decap_3
XFILLER_24_29 VGND VGND VPWR VPWR sky130_fd_sc_hd__decap_3
XFILLER_35_396 VGND VGND VPWR VPWR sky130_fd_sc_hd__decap_3
XFILLER_50_333 VGND VGND VPWR VPWR sky130_fd_sc_hd__decap_3
XFILLER_50_355 VGND VGND VPWR VPWR sky130_fd_sc_hd__decap_3
X_3976_ _4464_/A _4477_/A _4010_/S VGND VGND VPWR VPWR _3977_/A sky130_fd_sc_hd__mux2_1
XFILLER_50_399 VGND VGND VPWR VPWR sky130_fd_sc_hd__decap_3
X_2927_ _4876_/Q _2936_/A2 _2926_/X _2936_/B2 VGND VGND VPWR VPWR _4876_/D sky130_fd_sc_hd__a22o_2
X_2858_ _2887_/B _4037_/B VGND VGND VPWR VPWR _2858_/Y sky130_fd_sc_hd__nor2_2
XPHY_EDGE_ROW_93_Right_93 VGND VGND VPWR VPWR sky130_fd_sc_hd__decap_3
X_2789_ _4892_/Q _4876_/Q _5100_/Q _5084_/Q _2812_/S0 _2848_/S1 VGND VGND VPWR VPWR
+ _2790_/B sky130_fd_sc_hd__mux4_2
X_4528_ _4528_/A _4528_/B VGND VGND VPWR VPWR _4558_/B sky130_fd_sc_hd__nand2_2
XFILLER_6_9 VGND VGND VPWR VPWR sky130_fd_sc_hd__decap_3
X_4459_ _4457_/Y _4489_/B VGND VGND VPWR VPWR _4460_/B sky130_fd_sc_hd__and2b_2
XTAP_TAPCELL_ROW_5_245 VGND VPWR sky130_fd_sc_hd__tapvpwrvgnd_1
XFILLER_85_252 VGND VGND VPWR VPWR sky130_fd_sc_hd__fill_2
XFILLER_58_477 VGND VGND VPWR VPWR sky130_fd_sc_hd__decap_3
XFILLER_65_25 VGND VGND VPWR VPWR sky130_fd_sc_hd__decap_3
XFILLER_73_425 VGND VGND VPWR VPWR sky130_fd_sc_hd__fill_2
XTAP_TAPCELL_ROW_86_1017 VGND VPWR sky130_fd_sc_hd__tapvpwrvgnd_1
XFILLER_85_263 VGND VGND VPWR VPWR sky130_fd_sc_hd__decap_3
XFILLER_45_149 VGND VGND VPWR VPWR sky130_fd_sc_hd__decap_3
XFILLER_85_296 VGND VGND VPWR VPWR sky130_fd_sc_hd__decap_3
XTAP_TAPCELL_ROW_84_998 VGND VPWR sky130_fd_sc_hd__tapvpwrvgnd_1
XFILLER_41_300 VGND VGND VPWR VPWR sky130_fd_sc_hd__fill_1
XFILLER_53_160 VGND VGND VPWR VPWR sky130_fd_sc_hd__decap_3
XFILLER_41_355 VGND VGND VPWR VPWR sky130_fd_sc_hd__decap_3
XFILLER_81_57 VGND VGND VPWR VPWR sky130_fd_sc_hd__decap_3
XFILLER_5_212 VGND VGND VPWR VPWR sky130_fd_sc_hd__decap_3
XFILLER_5_245 VGND VGND VPWR VPWR sky130_fd_sc_hd__fill_1
XFILLER_5_267 VGND VGND VPWR VPWR sky130_fd_sc_hd__decap_3
XFILLER_49_411 VGND VGND VPWR VPWR sky130_fd_sc_hd__decap_3
XFILLER_39_81 VGND VGND VPWR VPWR sky130_fd_sc_hd__decap_3
XFILLER_49_455 VGND VGND VPWR VPWR sky130_fd_sc_hd__decap_3
XFILLER_76_241 VGND VGND VPWR VPWR sky130_fd_sc_hd__decap_3
XFILLER_64_403 VGND VGND VPWR VPWR sky130_fd_sc_hd__decap_3
XTAP_TAPCELL_ROW_75_910 VGND VPWR sky130_fd_sc_hd__tapvpwrvgnd_1
XFILLER_76_285 VGND VGND VPWR VPWR sky130_fd_sc_hd__decap_3
XTAP_TAPCELL_ROW_47_645 VGND VPWR sky130_fd_sc_hd__tapvpwrvgnd_1
XFILLER_91_233 VGND VGND VPWR VPWR sky130_fd_sc_hd__fill_1
X_3830_ _5063_/Q _5047_/Q _5031_/Q _5015_/Q _3834_/S0 _3834_/S1 VGND VGND VPWR VPWR
+ _3831_/B sky130_fd_sc_hd__mux4_2
XFILLER_32_388 VGND VGND VPWR VPWR sky130_fd_sc_hd__fill_2
X_3761_ _3831_/A _3760_/X _5130_/Q VGND VGND VPWR VPWR _3761_/X sky130_fd_sc_hd__o21a_2
X_2712_ _5133_/Q _2712_/B VGND VGND VPWR VPWR _2712_/X sky130_fd_sc_hd__or2_2
XFILLER_9_551 VGND VGND VPWR VPWR sky130_fd_sc_hd__fill_2
X_3692_ _4477_/A _3692_/B VGND VGND VPWR VPWR _4284_/B sky130_fd_sc_hd__and2_2
X_2643_ _5125_/Q _2642_/X _5126_/Q VGND VGND VPWR VPWR _2643_/X sky130_fd_sc_hd__o21a_2
X_2574_ _4885_/Q _4869_/Q _5093_/Q _5077_/Q _2658_/S0 _2671_/S1 VGND VGND VPWR VPWR
+ _2575_/B sky130_fd_sc_hd__mux4_2
X_4313_ _4313_/A _4313_/B _4313_/C _4313_/D VGND VGND VPWR VPWR _4324_/B sky130_fd_sc_hd__and4_2
XFILLER_87_517 VGND VGND VPWR VPWR sky130_fd_sc_hd__decap_3
X_4244_ _4313_/B _4244_/B _4244_/C VGND VGND VPWR VPWR _4244_/X sky130_fd_sc_hd__and3_2
XFILLER_67_252 VGND VGND VPWR VPWR sky130_fd_sc_hd__decap_3
X_4175_ _4464_/A _4464_/B _4523_/S VGND VGND VPWR VPWR _4175_/X sky130_fd_sc_hd__mux2_1
XFILLER_27_116 VGND VGND VPWR VPWR sky130_fd_sc_hd__fill_1
XFILLER_55_414 VGND VGND VPWR VPWR sky130_fd_sc_hd__decap_3
XFILLER_67_263 VGND VGND VPWR VPWR sky130_fd_sc_hd__decap_3
X_3126_ _2922_/X _3116_/Y _3133_/B1 _5035_/Q VGND VGND VPWR VPWR _5035_/D sky130_fd_sc_hd__a22o_2
XFILLER_82_200 VGND VGND VPWR VPWR sky130_fd_sc_hd__decap_3
XFILLER_55_447 VGND VGND VPWR VPWR sky130_fd_sc_hd__fill_1
XFILLER_67_296 VGND VGND VPWR VPWR sky130_fd_sc_hd__decap_3
X_3057_ _2938_/X _3043_/B _3043_/Y _4976_/Q VGND VGND VPWR VPWR _4976_/D sky130_fd_sc_hd__a22o_2
XFILLER_82_277 VGND VGND VPWR VPWR sky130_fd_sc_hd__decap_3
XFILLER_63_491 VGND VGND VPWR VPWR sky130_fd_sc_hd__decap_3
XFILLER_70_439 VGND VGND VPWR VPWR sky130_fd_sc_hd__decap_3
XFILLER_23_333 VGND VGND VPWR VPWR sky130_fd_sc_hd__decap_3
XFILLER_23_355 VGND VGND VPWR VPWR sky130_fd_sc_hd__decap_3
XFILLER_50_130 VGND VGND VPWR VPWR sky130_fd_sc_hd__decap_3
XFILLER_50_141 VGND VGND VPWR VPWR sky130_fd_sc_hd__fill_2
XTAP_TAPCELL_ROW_81_968 VGND VPWR sky130_fd_sc_hd__tapvpwrvgnd_1
XFILLER_50_163 VGND VGND VPWR VPWR sky130_fd_sc_hd__decap_3
XFILLER_51_38 VGND VGND VPWR VPWR sky130_fd_sc_hd__decap_3
X_3959_ _3954_/X _4320_/B _4107_/B VGND VGND VPWR VPWR _3959_/X sky130_fd_sc_hd__mux2_1
XFILLER_4_6 VGND VGND VPWR VPWR sky130_fd_sc_hd__fill_2
XFILLER_2_259 VGND VGND VPWR VPWR sky130_fd_sc_hd__fill_1
XTAP_TAPCELL_ROW_92_1076 VGND VPWR sky130_fd_sc_hd__tapvpwrvgnd_1
XFILLER_78_517 VGND VGND VPWR VPWR sky130_fd_sc_hd__decap_3
XFILLER_76_24 VGND VGND VPWR VPWR sky130_fd_sc_hd__decap_3
XFILLER_58_274 VGND VGND VPWR VPWR sky130_fd_sc_hd__decap_3
XFILLER_46_436 VGND VGND VPWR VPWR sky130_fd_sc_hd__fill_1
XFILLER_46_447 VGND VGND VPWR VPWR sky130_fd_sc_hd__decap_3
XFILLER_61_417 VGND VGND VPWR VPWR sky130_fd_sc_hd__decap_3
XFILLER_54_480 VGND VGND VPWR VPWR sky130_fd_sc_hd__decap_3
XFILLER_54_491 VGND VGND VPWR VPWR sky130_fd_sc_hd__fill_1
XFILLER_73_299 VGND VGND VPWR VPWR sky130_fd_sc_hd__decap_3
XTAP_TAPCELL_ROW_44_615 VGND VPWR sky130_fd_sc_hd__tapvpwrvgnd_1
XFILLER_14_355 VGND VGND VPWR VPWR sky130_fd_sc_hd__decap_3
XFILLER_26_193 VGND VGND VPWR VPWR sky130_fd_sc_hd__decap_3
XFILLER_14_377 VGND VGND VPWR VPWR sky130_fd_sc_hd__decap_3
XFILLER_41_163 VGND VGND VPWR VPWR sky130_fd_sc_hd__decap_3
XTAP_TAPCELL_ROW_52_692 VGND VPWR sky130_fd_sc_hd__tapvpwrvgnd_1
XFILLER_41_60 VGND VGND VPWR VPWR sky130_fd_sc_hd__decap_3
XFILLER_37_447 VGND VGND VPWR VPWR sky130_fd_sc_hd__fill_1
XFILLER_64_211 VGND VGND VPWR VPWR sky130_fd_sc_hd__decap_3
XFILLER_52_406 VGND VGND VPWR VPWR sky130_fd_sc_hd__decap_3
X_4931_ _4982_/CLK _4931_/D VGND VGND VPWR VPWR _4931_/Q sky130_fd_sc_hd__dfxtp_2
X_4862_ _5171_/Q _3252_/C _3228_/Y _3235_/X VGND VGND VPWR VPWR _5171_/D sky130_fd_sc_hd__o22a_2
XFILLER_32_152 VGND VGND VPWR VPWR sky130_fd_sc_hd__decap_3
XFILLER_60_483 VGND VGND VPWR VPWR sky130_fd_sc_hd__fill_2
X_3813_ _3831_/A _3812_/X _5130_/Q VGND VGND VPWR VPWR _3813_/X sky130_fd_sc_hd__o21a_2
X_4793_ _4115_/A _2490_/B _3874_/D _2689_/A _4792_/Y VGND VGND VPWR VPWR _4796_/B
+ sky130_fd_sc_hd__o221a_2
X_3744_ _4779_/S _3744_/B VGND VGND VPWR VPWR _4326_/A sky130_fd_sc_hd__nor2_2
X_3675_ _4077_/S _3672_/X _3674_/X VGND VGND VPWR VPWR _4103_/B sky130_fd_sc_hd__a21oi_2
Xoutput100 _2734_/X VGND VGND VPWR VPWR MEM_STR_DATA[2] sky130_fd_sc_hd__clkdlybuf4s25_1
X_2626_ _5068_/Q _5052_/Q _5036_/Q _5020_/Q _2658_/S0 _2671_/S1 VGND VGND VPWR VPWR
+ _2627_/B sky130_fd_sc_hd__mux4_2
XPHY_EDGE_ROW_65_Left_159 VGND VGND VPWR VPWR sky130_fd_sc_hd__decap_3
Xclkbuf_leaf_33_CLK clkload1/A VGND VGND VPWR VPWR _5210_/CLK sky130_fd_sc_hd__clkbuf_8
X_2557_ _2552_/X _2553_/X _2556_/X _2435_/Y VGND VGND VPWR VPWR _4466_/B sky130_fd_sc_hd__a22o_2
X_2488_ _5166_/Q _4551_/A VGND VGND VPWR VPWR _2689_/A sky130_fd_sc_hd__nand2_2
XFILLER_87_314 VGND VGND VPWR VPWR sky130_fd_sc_hd__decap_3
X_4227_ _4226_/X _4175_/X _4340_/A VGND VGND VPWR VPWR _4314_/B sky130_fd_sc_hd__mux2_1
XFILLER_87_358 VGND VGND VPWR VPWR sky130_fd_sc_hd__decap_3
XFILLER_28_436 VGND VGND VPWR VPWR sky130_fd_sc_hd__decap_3
XFILLER_55_222 VGND VGND VPWR VPWR sky130_fd_sc_hd__fill_2
X_4158_ _3793_/Y _3869_/Y _4002_/Y _2621_/A VGND VGND VPWR VPWR _4158_/X sky130_fd_sc_hd__a22o_2
XPHY_EDGE_ROW_74_Left_168 VGND VGND VPWR VPWR sky130_fd_sc_hd__decap_3
XFILLER_83_520 VGND VGND VPWR VPWR sky130_fd_sc_hd__decap_3
XFILLER_43_417 VGND VGND VPWR VPWR sky130_fd_sc_hd__decap_3
XFILLER_55_266 VGND VGND VPWR VPWR sky130_fd_sc_hd__decap_3
X_4089_ _4040_/A _4040_/B _3809_/B VGND VGND VPWR VPWR _4091_/B sky130_fd_sc_hd__a21o_2
X_3109_ _2926_/X _3099_/B _3099_/Y _5020_/Q VGND VGND VPWR VPWR _5020_/D sky130_fd_sc_hd__a22o_2
XFILLER_36_480 VGND VGND VPWR VPWR sky130_fd_sc_hd__decap_3
XFILLER_43_439 VGND VGND VPWR VPWR sky130_fd_sc_hd__decap_3
XFILLER_70_214 VGND VGND VPWR VPWR sky130_fd_sc_hd__decap_3
XFILLER_62_26 VGND VGND VPWR VPWR sky130_fd_sc_hd__fill_2
XFILLER_23_152 VGND VGND VPWR VPWR sky130_fd_sc_hd__decap_3
XFILLER_23_163 VGND VGND VPWR VPWR sky130_fd_sc_hd__decap_3
XFILLER_62_59 VGND VGND VPWR VPWR sky130_fd_sc_hd__decap_3
XFILLER_51_494 VGND VGND VPWR VPWR sky130_fd_sc_hd__decap_3
XTAP_TAPCELL_ROW_21_397 VGND VPWR sky130_fd_sc_hd__tapvpwrvgnd_1
XPHY_EDGE_ROW_83_Left_177 VGND VGND VPWR VPWR sky130_fd_sc_hd__decap_3
XFILLER_11_30 VGND VGND VPWR VPWR sky130_fd_sc_hd__decap_3
XFILLER_11_74 VGND VGND VPWR VPWR sky130_fd_sc_hd__decap_3
XFILLER_3_546 VGND VGND VPWR VPWR sky130_fd_sc_hd__decap_3
Xclkbuf_leaf_24_CLK clkload2/A VGND VGND VPWR VPWR _5112_/CLK sky130_fd_sc_hd__clkbuf_8
XFILLER_87_12 VGND VGND VPWR VPWR sky130_fd_sc_hd__decap_3
XFILLER_78_336 VGND VGND VPWR VPWR sky130_fd_sc_hd__decap_3
XPHY_EDGE_ROW_92_Left_186 VGND VGND VPWR VPWR sky130_fd_sc_hd__decap_3
XFILLER_93_317 VGND VGND VPWR VPWR sky130_fd_sc_hd__fill_2
XFILLER_46_233 VGND VGND VPWR VPWR sky130_fd_sc_hd__decap_3
XFILLER_86_391 VGND VGND VPWR VPWR sky130_fd_sc_hd__decap_3
XTAP_TAPCELL_ROW_57_740 VGND VPWR sky130_fd_sc_hd__tapvpwrvgnd_1
XFILLER_34_417 VGND VGND VPWR VPWR sky130_fd_sc_hd__decap_3
XFILLER_34_439 VGND VGND VPWR VPWR sky130_fd_sc_hd__decap_3
XFILLER_61_225 VGND VGND VPWR VPWR sky130_fd_sc_hd__decap_3
XTAP_TAPCELL_ROW_29_475 VGND VPWR sky130_fd_sc_hd__tapvpwrvgnd_1
XFILLER_61_258 VGND VGND VPWR VPWR sky130_fd_sc_hd__decap_3
XPHY_EDGE_ROW_1_Left_95 VGND VGND VPWR VPWR sky130_fd_sc_hd__decap_3
XFILLER_14_141 VGND VGND VPWR VPWR sky130_fd_sc_hd__fill_1
XTAP_TAPCELL_ROW_12_320 VGND VPWR sky130_fd_sc_hd__tapvpwrvgnd_1
XFILLER_52_81 VGND VGND VPWR VPWR sky130_fd_sc_hd__decap_3
Xinput13 INSTR_STREAM[20] VGND VGND VPWR VPWR input13/X sky130_fd_sc_hd__clkdlybuf4s25_1
Xinput46 MEM_LD_DATA[7] VGND VGND VPWR VPWR input46/X sky130_fd_sc_hd__clkdlybuf4s25_1
Xinput35 MEM_LD_DATA[11] VGND VGND VPWR VPWR input35/X sky130_fd_sc_hd__clkdlybuf4s25_1
Xinput24 INSTR_STREAM[30] VGND VGND VPWR VPWR _3448_/C sky130_fd_sc_hd__clkdlybuf4s25_1
XFILLER_6_362 VGND VGND VPWR VPWR sky130_fd_sc_hd__fill_2
XFILLER_6_395 VGND VGND VPWR VPWR sky130_fd_sc_hd__decap_3
Xclkbuf_leaf_15_CLK clkload0/A VGND VGND VPWR VPWR _5200_/CLK sky130_fd_sc_hd__clkbuf_8
X_3460_ _3454_/X _3455_/X _3459_/X VGND VGND VPWR VPWR _5184_/D sky130_fd_sc_hd__o21a_2
X_3391_ _5147_/Q _3392_/B VGND VGND VPWR VPWR _3391_/X sky130_fd_sc_hd__or2_2
XFILLER_69_303 VGND VGND VPWR VPWR sky130_fd_sc_hd__decap_3
X_5130_ clkload7/A _5130_/D VGND VGND VPWR VPWR _5130_/Q sky130_fd_sc_hd__dfxtp_2
XFILLER_69_358 VGND VGND VPWR VPWR sky130_fd_sc_hd__decap_3
X_5061_ _5078_/CLK _5061_/D VGND VGND VPWR VPWR _5061_/Q sky130_fd_sc_hd__dfxtp_2
X_4012_ _4011_/Y _4009_/X _4077_/S VGND VGND VPWR VPWR _4012_/X sky130_fd_sc_hd__mux2_1
XFILLER_65_542 VGND VGND VPWR VPWR sky130_fd_sc_hd__decap_3
XFILLER_37_255 VGND VGND VPWR VPWR sky130_fd_sc_hd__decap_3
XFILLER_18_480 VGND VGND VPWR VPWR sky130_fd_sc_hd__decap_3
XFILLER_52_225 VGND VGND VPWR VPWR sky130_fd_sc_hd__decap_3
XFILLER_92_383 VGND VGND VPWR VPWR sky130_fd_sc_hd__decap_3
XFILLER_80_523 VGND VGND VPWR VPWR sky130_fd_sc_hd__decap_3
X_4914_ _5103_/CLK _4914_/D VGND VGND VPWR VPWR _4914_/Q sky130_fd_sc_hd__dfxtp_2
XTAP_TAPCELL_ROW_63_798 VGND VPWR sky130_fd_sc_hd__tapvpwrvgnd_1
XFILLER_20_111 VGND VGND VPWR VPWR sky130_fd_sc_hd__decap_3
X_4845_ _5252_/Q _4847_/B VGND VGND VPWR VPWR _4845_/X sky130_fd_sc_hd__or2_2
X_4776_ _4804_/A _4776_/B VGND VGND VPWR VPWR _4776_/X sky130_fd_sc_hd__or2_2
X_3727_ _4285_/B _4285_/C VGND VGND VPWR VPWR _3727_/X sky130_fd_sc_hd__and2_2
X_3658_ _5154_/Q _4403_/A _4547_/A VGND VGND VPWR VPWR _4173_/A sky130_fd_sc_hd__mux2_1
X_3589_ _3867_/A _4763_/A VGND VGND VPWR VPWR _4542_/S sky130_fd_sc_hd__nor2_2
X_2609_ _4048_/A _2857_/B _2585_/A VGND VGND VPWR VPWR _2859_/A sky130_fd_sc_hd__a21o_2
XFILLER_87_100 VGND VGND VPWR VPWR sky130_fd_sc_hd__decap_3
X_5259_ _5263_/CLK _5259_/D VGND VGND VPWR VPWR _5259_/Q sky130_fd_sc_hd__dfxtp_2
XFILLER_43_225 VGND VGND VPWR VPWR sky130_fd_sc_hd__fill_1
XTAP_TAPCELL_ROW_54_710 VGND VPWR sky130_fd_sc_hd__tapvpwrvgnd_1
XFILLER_83_383 VGND VGND VPWR VPWR sky130_fd_sc_hd__decap_3
XFILLER_43_258 VGND VGND VPWR VPWR sky130_fd_sc_hd__decap_3
XTAP_TAPCELL_ROW_26_445 VGND VPWR sky130_fd_sc_hd__tapvpwrvgnd_1
XFILLER_11_111 VGND VGND VPWR VPWR sky130_fd_sc_hd__fill_1
XFILLER_11_177 VGND VGND VPWR VPWR sky130_fd_sc_hd__decap_3
XFILLER_7_137 VGND VGND VPWR VPWR sky130_fd_sc_hd__decap_3
XFILLER_78_144 VGND VGND VPWR VPWR sky130_fd_sc_hd__decap_3
XFILLER_21_9 VGND VGND VPWR VPWR sky130_fd_sc_hd__decap_3
XFILLER_59_380 VGND VGND VPWR VPWR sky130_fd_sc_hd__decap_3
XFILLER_19_255 VGND VGND VPWR VPWR sky130_fd_sc_hd__decap_3
XFILLER_34_203 VGND VGND VPWR VPWR sky130_fd_sc_hd__decap_3
XFILLER_62_512 VGND VGND VPWR VPWR sky130_fd_sc_hd__decap_3
XFILLER_74_383 VGND VGND VPWR VPWR sky130_fd_sc_hd__decap_3
Xclkbuf_leaf_4_CLK clkbuf_leaf_8_CLK/A VGND VGND VPWR VPWR clkload4/A sky130_fd_sc_hd__clkbuf_8
XFILLER_34_247 VGND VGND VPWR VPWR sky130_fd_sc_hd__decap_3
XFILLER_62_545 VGND VGND VPWR VPWR sky130_fd_sc_hd__decap_3
XFILLER_15_461 VGND VGND VPWR VPWR sky130_fd_sc_hd__fill_2
XFILLER_22_409 VGND VGND VPWR VPWR sky130_fd_sc_hd__decap_3
X_2960_ _2932_/X _2961_/A2 _2961_/B1 _4894_/Q VGND VGND VPWR VPWR _4894_/D sky130_fd_sc_hd__a22o_2
XFILLER_63_91 VGND VGND VPWR VPWR sky130_fd_sc_hd__decap_3
X_2891_ _5190_/Q _2455_/X _3456_/B _5238_/Q _2890_/X VGND VGND VPWR VPWR _2891_/X
+ sky130_fd_sc_hd__a221o_2
XFILLER_30_464 VGND VGND VPWR VPWR sky130_fd_sc_hd__decap_3
X_4630_ _4600_/Y _4629_/X _4866_/A VGND VGND VPWR VPWR _5225_/D sky130_fd_sc_hd__a21oi_2
XTAP_TAPCELL_ROW_60_768 VGND VPWR sky130_fd_sc_hd__tapvpwrvgnd_1
XFILLER_30_486 VGND VGND VPWR VPWR sky130_fd_sc_hd__decap_3
X_4561_ _4866_/A _4561_/B VGND VGND VPWR VPWR _5223_/D sky130_fd_sc_hd__nor2_2
X_4492_ _4492_/A _4492_/B VGND VGND VPWR VPWR _4511_/A sky130_fd_sc_hd__nor2_2
X_3512_ _5195_/Q _4850_/B _3585_/A _3511_/Y VGND VGND VPWR VPWR _3513_/B sky130_fd_sc_hd__o2bb2a_2
X_3443_ _5179_/Q _3429_/C _3228_/Y _3442_/X VGND VGND VPWR VPWR _5179_/D sky130_fd_sc_hd__o22a_2
XFILLER_69_100 VGND VGND VPWR VPWR sky130_fd_sc_hd__fill_1
X_5113_ clkload9/A _5113_/D VGND VGND VPWR VPWR _5113_/Q sky130_fd_sc_hd__dfxtp_2
X_3374_ _5145_/Q _3337_/A _3373_/Y _3442_/B VGND VGND VPWR VPWR _5145_/D sky130_fd_sc_hd__o211a_2
X_5044_ clkload8/A _5044_/D VGND VGND VPWR VPWR _5044_/Q sky130_fd_sc_hd__dfxtp_2
XTAP_TAPCELL_ROW_68_846 VGND VPWR sky130_fd_sc_hd__tapvpwrvgnd_1
XFILLER_84_136 VGND VGND VPWR VPWR sky130_fd_sc_hd__decap_3
XFILLER_27_29 VGND VGND VPWR VPWR sky130_fd_sc_hd__decap_3
XFILLER_72_309 VGND VGND VPWR VPWR sky130_fd_sc_hd__decap_3
XFILLER_84_169 VGND VGND VPWR VPWR sky130_fd_sc_hd__decap_3
XFILLER_25_214 VGND VGND VPWR VPWR sky130_fd_sc_hd__decap_3
XFILLER_53_523 VGND VGND VPWR VPWR sky130_fd_sc_hd__decap_3
XFILLER_65_361 VGND VGND VPWR VPWR sky130_fd_sc_hd__decap_3
XFILLER_25_225 VGND VGND VPWR VPWR sky130_fd_sc_hd__decap_3
XFILLER_92_180 VGND VGND VPWR VPWR sky130_fd_sc_hd__fill_2
XFILLER_80_342 VGND VGND VPWR VPWR sky130_fd_sc_hd__decap_3
XFILLER_25_269 VGND VGND VPWR VPWR sky130_fd_sc_hd__decap_3
XFILLER_80_397 VGND VGND VPWR VPWR sky130_fd_sc_hd__decap_3
X_4828_ input44/X _4816_/Y _4827_/X _3442_/B VGND VGND VPWR VPWR _5243_/D sky130_fd_sc_hd__o211a_2
XFILLER_21_497 VGND VGND VPWR VPWR sky130_fd_sc_hd__decap_3
X_4759_ _4759_/A VGND VGND VPWR VPWR _4759_/Y sky130_fd_sc_hd__inv_2
XTAP_TAPCELL_ROW_31_492 VGND VPWR sky130_fd_sc_hd__tapvpwrvgnd_1
XFILLER_4_118 VGND VGND VPWR VPWR sky130_fd_sc_hd__fill_1
XFILLER_88_431 VGND VGND VPWR VPWR sky130_fd_sc_hd__fill_1
XFILLER_0_368 VGND VGND VPWR VPWR sky130_fd_sc_hd__decap_3
XFILLER_88_486 VGND VGND VPWR VPWR sky130_fd_sc_hd__decap_3
XFILLER_48_339 VGND VGND VPWR VPWR sky130_fd_sc_hd__decap_3
XFILLER_75_125 VGND VGND VPWR VPWR sky130_fd_sc_hd__decap_3
XFILLER_29_542 VGND VGND VPWR VPWR sky130_fd_sc_hd__decap_3
XFILLER_75_169 VGND VGND VPWR VPWR sky130_fd_sc_hd__decap_3
XTAP_TAPCELL_ROW_89_1048 VGND VPWR sky130_fd_sc_hd__tapvpwrvgnd_1
XFILLER_84_35 VGND VGND VPWR VPWR sky130_fd_sc_hd__fill_1
XFILLER_44_512 VGND VGND VPWR VPWR sky130_fd_sc_hd__fill_1
XFILLER_56_361 VGND VGND VPWR VPWR sky130_fd_sc_hd__decap_3
XFILLER_56_383 VGND VGND VPWR VPWR sky130_fd_sc_hd__decap_3
XTAP_TAPCELL_ROW_39_570 VGND VPWR sky130_fd_sc_hd__tapvpwrvgnd_1
XFILLER_17_73 VGND VGND VPWR VPWR sky130_fd_sc_hd__decap_3
XFILLER_71_364 VGND VGND VPWR VPWR sky130_fd_sc_hd__decap_3
XFILLER_31_228 VGND VGND VPWR VPWR sky130_fd_sc_hd__decap_3
XFILLER_33_50 VGND VGND VPWR VPWR sky130_fd_sc_hd__decap_3
XFILLER_12_475 VGND VGND VPWR VPWR sky130_fd_sc_hd__fill_1
XFILLER_12_497 VGND VGND VPWR VPWR sky130_fd_sc_hd__decap_3
XFILLER_79_431 VGND VGND VPWR VPWR sky130_fd_sc_hd__decap_3
XFILLER_39_328 VGND VGND VPWR VPWR sky130_fd_sc_hd__decap_3
X_3090_ _2926_/X _3093_/A2 _3096_/B1 _5004_/Q VGND VGND VPWR VPWR _5004_/D sky130_fd_sc_hd__a22o_2
XFILLER_54_309 VGND VGND VPWR VPWR sky130_fd_sc_hd__decap_3
XFILLER_66_147 VGND VGND VPWR VPWR sky130_fd_sc_hd__decap_3
XTAP_TAPCELL_ROW_65_816 VGND VPWR sky130_fd_sc_hd__tapvpwrvgnd_1
XFILLER_35_545 VGND VGND VPWR VPWR sky130_fd_sc_hd__decap_3
X_3992_ _3992_/A _3992_/B VGND VGND VPWR VPWR _3992_/Y sky130_fd_sc_hd__nor2_2
X_2943_ _5237_/Q _4850_/A _3458_/B _5221_/Q VGND VGND VPWR VPWR _2943_/X sky130_fd_sc_hd__a22o_2
XTAP_TAPCELL_ROW_73_893 VGND VPWR sky130_fd_sc_hd__tapvpwrvgnd_1
XFILLER_30_250 VGND VGND VPWR VPWR sky130_fd_sc_hd__fill_2
X_2874_ _2887_/B _2874_/B VGND VGND VPWR VPWR _2874_/Y sky130_fd_sc_hd__nor2_2
X_4613_ _4537_/X _4607_/Y _4610_/X _4612_/X VGND VGND VPWR VPWR _4617_/B sky130_fd_sc_hd__o211a_2
X_4544_ _4804_/A _4634_/B _4806_/A VGND VGND VPWR VPWR _4607_/A sky130_fd_sc_hd__and3b_2
Xmax_cap110 _3226_/Y VGND VGND VPWR VPWR _3429_/C sky130_fd_sc_hd__buf_4
Xmax_cap121 _3190_/B VGND VGND VPWR VPWR _3203_/A2 sky130_fd_sc_hd__buf_6
Xmax_cap132 _2897_/B VGND VGND VPWR VPWR _2936_/B2 sky130_fd_sc_hd__buf_6
Xmax_cap143 _5131_/Q VGND VGND VPWR VPWR _2812_/S0 sky130_fd_sc_hd__buf_12
XFILLER_7_490 VGND VGND VPWR VPWR sky130_fd_sc_hd__decap_3
X_4475_ _4475_/A _4477_/C _4474_/Y VGND VGND VPWR VPWR _4475_/X sky130_fd_sc_hd__or3b_2
X_3426_ _5159_/Q _3450_/C _3228_/Y _3425_/X VGND VGND VPWR VPWR _5159_/D sky130_fd_sc_hd__o22a_2
X_3357_ _5144_/Q _3371_/C VGND VGND VPWR VPWR _3357_/Y sky130_fd_sc_hd__nor2_2
XFILLER_57_169 VGND VGND VPWR VPWR sky130_fd_sc_hd__fill_1
X_5027_ _5063_/CLK _5027_/D VGND VGND VPWR VPWR _5027_/Q sky130_fd_sc_hd__dfxtp_2
X_3288_ _3294_/B _3284_/Y _3287_/X VGND VGND VPWR VPWR _3288_/Y sky130_fd_sc_hd__o21ai_2
XFILLER_85_478 VGND VGND VPWR VPWR sky130_fd_sc_hd__fill_1
XFILLER_38_383 VGND VGND VPWR VPWR sky130_fd_sc_hd__fill_1
XFILLER_54_27 VGND VGND VPWR VPWR sky130_fd_sc_hd__fill_1
XFILLER_13_206 VGND VGND VPWR VPWR sky130_fd_sc_hd__decap_3
XFILLER_53_364 VGND VGND VPWR VPWR sky130_fd_sc_hd__decap_3
XTAP_TAPCELL_ROW_36_540 VGND VPWR sky130_fd_sc_hd__tapvpwrvgnd_1
XFILLER_80_161 VGND VGND VPWR VPWR sky130_fd_sc_hd__decap_3
XFILLER_13_228 VGND VGND VPWR VPWR sky130_fd_sc_hd__decap_3
XFILLER_41_537 VGND VGND VPWR VPWR sky130_fd_sc_hd__fill_1
XTAP_TAPCELL_ROW_0_198 VGND VPWR sky130_fd_sc_hd__tapvpwrvgnd_1
XFILLER_80_194 VGND VGND VPWR VPWR sky130_fd_sc_hd__fill_2
XFILLER_70_48 VGND VGND VPWR VPWR sky130_fd_sc_hd__decap_3
XFILLER_5_449 VGND VGND VPWR VPWR sky130_fd_sc_hd__fill_1
XFILLER_79_68 VGND VGND VPWR VPWR sky130_fd_sc_hd__decap_3
XFILLER_79_57 VGND VGND VPWR VPWR sky130_fd_sc_hd__fill_2
XTAP_TAPCELL_ROW_8_276 VGND VPWR sky130_fd_sc_hd__tapvpwrvgnd_1
XFILLER_88_250 VGND VGND VPWR VPWR sky130_fd_sc_hd__fill_2
XFILLER_0_165 VGND VGND VPWR VPWR sky130_fd_sc_hd__decap_3
XFILLER_0_187 VGND VGND VPWR VPWR sky130_fd_sc_hd__decap_3
XFILLER_88_294 VGND VGND VPWR VPWR sky130_fd_sc_hd__decap_3
XFILLER_36_309 VGND VGND VPWR VPWR sky130_fd_sc_hd__decap_3
XFILLER_48_147 VGND VGND VPWR VPWR sky130_fd_sc_hd__decap_3
XFILLER_17_501 VGND VGND VPWR VPWR sky130_fd_sc_hd__decap_3
XFILLER_28_83 VGND VGND VPWR VPWR sky130_fd_sc_hd__fill_1
XFILLER_91_404 VGND VGND VPWR VPWR sky130_fd_sc_hd__decap_3
XFILLER_29_383 VGND VGND VPWR VPWR sky130_fd_sc_hd__decap_3
XFILLER_44_320 VGND VGND VPWR VPWR sky130_fd_sc_hd__decap_3
XFILLER_44_331 VGND VGND VPWR VPWR sky130_fd_sc_hd__decap_3
XFILLER_44_353 VGND VGND VPWR VPWR sky130_fd_sc_hd__decap_3
XFILLER_32_548 VGND VGND VPWR VPWR sky130_fd_sc_hd__decap_3
XFILLER_44_386 VGND VGND VPWR VPWR sky130_fd_sc_hd__decap_3
XFILLER_71_183 VGND VGND VPWR VPWR sky130_fd_sc_hd__decap_3
XFILLER_71_194 VGND VGND VPWR VPWR sky130_fd_sc_hd__decap_3
XFILLER_44_82 VGND VGND VPWR VPWR sky130_fd_sc_hd__fill_2
XTAP_TAPCELL_ROW_70_863 VGND VPWR sky130_fd_sc_hd__tapvpwrvgnd_1
XTAP_TAPCELL_ROW_42_598 VGND VPWR sky130_fd_sc_hd__tapvpwrvgnd_1
XFILLER_8_232 VGND VGND VPWR VPWR sky130_fd_sc_hd__decap_3
X_2590_ _4948_/Q _4932_/Q _4916_/Q _4900_/Q _2658_/S0 _2671_/S1 VGND VGND VPWR VPWR
+ _2590_/X sky130_fd_sc_hd__mux4_2
XFILLER_5_54 VGND VGND VPWR VPWR sky130_fd_sc_hd__fill_2
XFILLER_5_87 VGND VGND VPWR VPWR sky130_fd_sc_hd__decap_3
X_4260_ _4244_/X _4247_/X _4259_/Y _4241_/Y _4546_/A VGND VGND VPWR VPWR _4260_/X
+ sky130_fd_sc_hd__o32a_2
X_4191_ _4191_/A _4191_/B VGND VGND VPWR VPWR _4191_/Y sky130_fd_sc_hd__xnor2_2
X_3211_ _2903_/X _3221_/A2 _3208_/Y _5109_/Q VGND VGND VPWR VPWR _5109_/D sky130_fd_sc_hd__a22o_2
X_3142_ _2913_/X _3152_/A2 _3136_/Y _5048_/Q VGND VGND VPWR VPWR _5048_/D sky130_fd_sc_hd__a22o_2
XFILLER_67_467 VGND VGND VPWR VPWR sky130_fd_sc_hd__decap_3
XTAP_TAPCELL_ROW_78_941 VGND VPWR sky130_fd_sc_hd__tapvpwrvgnd_1
XFILLER_39_169 VGND VGND VPWR VPWR sky130_fd_sc_hd__decap_3
X_3073_ _2932_/X _3074_/A2 _3061_/Y _4990_/Q VGND VGND VPWR VPWR _4990_/D sky130_fd_sc_hd__a22o_2
XFILLER_35_331 VGND VGND VPWR VPWR sky130_fd_sc_hd__decap_3
XFILLER_47_180 VGND VGND VPWR VPWR sky130_fd_sc_hd__decap_3
XFILLER_54_128 VGND VGND VPWR VPWR sky130_fd_sc_hd__decap_3
XFILLER_82_437 VGND VGND VPWR VPWR sky130_fd_sc_hd__decap_3
XFILLER_35_342 VGND VGND VPWR VPWR sky130_fd_sc_hd__decap_3
XFILLER_62_150 VGND VGND VPWR VPWR sky130_fd_sc_hd__fill_1
XFILLER_23_548 VGND VGND VPWR VPWR sky130_fd_sc_hd__decap_3
XFILLER_35_386 VGND VGND VPWR VPWR sky130_fd_sc_hd__decap_3
XFILLER_50_312 VGND VGND VPWR VPWR sky130_fd_sc_hd__decap_3
X_3975_ _4077_/S _3972_/Y _3974_/X _4173_/A VGND VGND VPWR VPWR _3975_/X sky130_fd_sc_hd__a211o_2
XFILLER_10_209 VGND VGND VPWR VPWR sky130_fd_sc_hd__decap_3
XFILLER_50_378 VGND VGND VPWR VPWR sky130_fd_sc_hd__decap_3
X_2926_ _2926_/A _2926_/B VGND VGND VPWR VPWR _2926_/X sky130_fd_sc_hd__or2_2
X_2857_ _4048_/A _2857_/B VGND VGND VPWR VPWR _4037_/B sky130_fd_sc_hd__xnor2_2
XFILLER_40_29 VGND VGND VPWR VPWR sky130_fd_sc_hd__fill_1
X_2788_ _2851_/A _3323_/B VGND VGND VPWR VPWR _2788_/X sky130_fd_sc_hd__and2_2
XFILLER_2_419 VGND VGND VPWR VPWR sky130_fd_sc_hd__fill_1
X_4527_ _4419_/A _4715_/B _4525_/X _4526_/Y VGND VGND VPWR VPWR _4528_/B sky130_fd_sc_hd__a22o_2
X_4458_ _4551_/A _4471_/A VGND VGND VPWR VPWR _4489_/B sky130_fd_sc_hd__nand2_2
X_3409_ _5151_/Q _5257_/D _5258_/D VGND VGND VPWR VPWR _5151_/D sky130_fd_sc_hd__o21ba_2
XFILLER_77_209 VGND VGND VPWR VPWR sky130_fd_sc_hd__decap_3
X_4389_ _5154_/Q _5153_/Q _5152_/Q VGND VGND VPWR VPWR _4402_/A sky130_fd_sc_hd__or3_2
XTAP_TAPCELL_ROW_5_246 VGND VPWR sky130_fd_sc_hd__tapvpwrvgnd_1
XFILLER_58_456 VGND VGND VPWR VPWR sky130_fd_sc_hd__fill_2
XFILLER_18_309 VGND VGND VPWR VPWR sky130_fd_sc_hd__decap_3
XTAP_TAPCELL_ROW_86_1018 VGND VPWR sky130_fd_sc_hd__tapvpwrvgnd_1
XTAP_TAPCELL_ROW_84_999 VGND VPWR sky130_fd_sc_hd__tapvpwrvgnd_1
XFILLER_41_312 VGND VGND VPWR VPWR sky130_fd_sc_hd__fill_1
XFILLER_41_323 VGND VGND VPWR VPWR sky130_fd_sc_hd__fill_1
XFILLER_81_481 VGND VGND VPWR VPWR sky130_fd_sc_hd__decap_3
XFILLER_81_36 VGND VGND VPWR VPWR sky130_fd_sc_hd__decap_3
XFILLER_41_334 VGND VGND VPWR VPWR sky130_fd_sc_hd__fill_2
XFILLER_14_85 VGND VGND VPWR VPWR sky130_fd_sc_hd__decap_3
XFILLER_5_279 VGND VGND VPWR VPWR sky130_fd_sc_hd__fill_1
XFILLER_1_452 VGND VGND VPWR VPWR sky130_fd_sc_hd__fill_2
XFILLER_39_60 VGND VGND VPWR VPWR sky130_fd_sc_hd__fill_2
XFILLER_49_423 VGND VGND VPWR VPWR sky130_fd_sc_hd__decap_3
XFILLER_76_220 VGND VGND VPWR VPWR sky130_fd_sc_hd__decap_3
XFILLER_49_478 VGND VGND VPWR VPWR sky130_fd_sc_hd__decap_3
XTAP_TAPCELL_ROW_75_911 VGND VPWR sky130_fd_sc_hd__tapvpwrvgnd_1
XFILLER_76_264 VGND VGND VPWR VPWR sky130_fd_sc_hd__decap_3
XFILLER_76_253 VGND VGND VPWR VPWR sky130_fd_sc_hd__decap_3
XFILLER_17_331 VGND VGND VPWR VPWR sky130_fd_sc_hd__decap_3
XTAP_TAPCELL_ROW_47_646 VGND VPWR sky130_fd_sc_hd__tapvpwrvgnd_1
XFILLER_51_109 VGND VGND VPWR VPWR sky130_fd_sc_hd__decap_3
XFILLER_55_81 VGND VGND VPWR VPWR sky130_fd_sc_hd__decap_3
XFILLER_91_278 VGND VGND VPWR VPWR sky130_fd_sc_hd__fill_2
XFILLER_91_256 VGND VGND VPWR VPWR sky130_fd_sc_hd__fill_1
XFILLER_32_312 VGND VGND VPWR VPWR sky130_fd_sc_hd__decap_3
XFILLER_72_492 VGND VGND VPWR VPWR sky130_fd_sc_hd__decap_3
XFILLER_32_345 VGND VGND VPWR VPWR sky130_fd_sc_hd__decap_3
XFILLER_20_507 VGND VGND VPWR VPWR sky130_fd_sc_hd__decap_3
X_3760_ _5073_/Q _5057_/Q _5041_/Q _5025_/Q _5127_/Q _5128_/Q VGND VGND VPWR VPWR
+ _3760_/X sky130_fd_sc_hd__mux4_2
X_2711_ _5107_/Q _4995_/Q _4979_/Q _4963_/Q _2812_/S0 _2848_/S1 VGND VGND VPWR VPWR
+ _2712_/B sky130_fd_sc_hd__mux4_2
X_3691_ _4477_/A _3692_/B VGND VGND VPWR VPWR _4704_/S sky130_fd_sc_hd__nor2_2
X_2642_ _4891_/Q _4875_/Q _5099_/Q _5083_/Q _5123_/Q _5124_/Q VGND VGND VPWR VPWR
+ _2642_/X sky130_fd_sc_hd__mux4_2
X_2573_ _5155_/Q _4445_/A VGND VGND VPWR VPWR _2573_/Y sky130_fd_sc_hd__nand2_2
XTAP_TAPCELL_ROW_10_292 VGND VPWR sky130_fd_sc_hd__tapvpwrvgnd_1
X_4312_ _4312_/A _4312_/B VGND VGND VPWR VPWR _4313_/D sky130_fd_sc_hd__or2_2
X_4243_ _3920_/X _4222_/Y _3682_/D VGND VGND VPWR VPWR _4244_/C sky130_fd_sc_hd__a21o_2
XFILLER_87_529 VGND VGND VPWR VPWR sky130_fd_sc_hd__decap_3
XFILLER_67_220 VGND VGND VPWR VPWR sky130_fd_sc_hd__decap_3
XFILLER_67_231 VGND VGND VPWR VPWR sky130_fd_sc_hd__decap_3
X_4174_ _4173_/A _4077_/X _4173_/Y _3668_/B VGND VGND VPWR VPWR _4174_/X sky130_fd_sc_hd__a211o_2
XFILLER_67_275 VGND VGND VPWR VPWR sky130_fd_sc_hd__decap_3
X_3125_ _2919_/X _3117_/B _3133_/B1 _5034_/Q VGND VGND VPWR VPWR _5034_/D sky130_fd_sc_hd__a22o_2
XTAP_TAPCELL_ROW_2_216 VGND VPWR sky130_fd_sc_hd__tapvpwrvgnd_1
XFILLER_55_426 VGND VGND VPWR VPWR sky130_fd_sc_hd__decap_3
X_3056_ _2935_/X _3056_/A2 _3043_/Y _4975_/Q VGND VGND VPWR VPWR _4975_/D sky130_fd_sc_hd__a22o_2
XFILLER_82_234 VGND VGND VPWR VPWR sky130_fd_sc_hd__decap_3
XFILLER_70_407 VGND VGND VPWR VPWR sky130_fd_sc_hd__decap_3
XFILLER_82_256 VGND VGND VPWR VPWR sky130_fd_sc_hd__fill_1
XFILLER_35_172 VGND VGND VPWR VPWR sky130_fd_sc_hd__fill_1
XTAP_TAPCELL_ROW_18_370 VGND VPWR sky130_fd_sc_hd__tapvpwrvgnd_1
XFILLER_82_289 VGND VGND VPWR VPWR sky130_fd_sc_hd__decap_3
XFILLER_35_194 VGND VGND VPWR VPWR sky130_fd_sc_hd__decap_3
XTAP_TAPCELL_ROW_81_969 VGND VPWR sky130_fd_sc_hd__tapvpwrvgnd_1
XFILLER_11_529 VGND VGND VPWR VPWR sky130_fd_sc_hd__decap_3
XFILLER_23_389 VGND VGND VPWR VPWR sky130_fd_sc_hd__decap_3
XFILLER_50_175 VGND VGND VPWR VPWR sky130_fd_sc_hd__decap_3
XFILLER_50_197 VGND VGND VPWR VPWR sky130_fd_sc_hd__decap_3
X_3958_ _3956_/Y _4063_/B _4063_/A VGND VGND VPWR VPWR _4320_/B sky130_fd_sc_hd__mux2_1
X_3889_ _4405_/A _4449_/B VGND VGND VPWR VPWR _4042_/B sky130_fd_sc_hd__and2b_2
X_2909_ _5194_/Q _2455_/X _3456_/B _5242_/Q VGND VGND VPWR VPWR _2910_/B sky130_fd_sc_hd__a22o_2
XTAP_TAPCELL_ROW_92_1077 VGND VPWR sky130_fd_sc_hd__tapvpwrvgnd_1
XFILLER_78_529 VGND VGND VPWR VPWR sky130_fd_sc_hd__decap_3
XFILLER_58_220 VGND VGND VPWR VPWR sky130_fd_sc_hd__decap_3
XFILLER_86_551 VGND VGND VPWR VPWR sky130_fd_sc_hd__fill_2
XFILLER_58_253 VGND VGND VPWR VPWR sky130_fd_sc_hd__fill_2
XFILLER_46_459 VGND VGND VPWR VPWR sky130_fd_sc_hd__fill_1
XFILLER_73_212 VGND VGND VPWR VPWR sky130_fd_sc_hd__decap_3
XFILLER_73_234 VGND VGND VPWR VPWR sky130_fd_sc_hd__decap_3
XFILLER_73_256 VGND VGND VPWR VPWR sky130_fd_sc_hd__decap_3
XFILLER_92_35 VGND VGND VPWR VPWR sky130_fd_sc_hd__decap_3
XFILLER_14_312 VGND VGND VPWR VPWR sky130_fd_sc_hd__decap_3
XFILLER_26_161 VGND VGND VPWR VPWR sky130_fd_sc_hd__decap_3
XTAP_TAPCELL_ROW_44_616 VGND VPWR sky130_fd_sc_hd__tapvpwrvgnd_1
XFILLER_25_73 VGND VGND VPWR VPWR sky130_fd_sc_hd__decap_3
XFILLER_41_153 VGND VGND VPWR VPWR sky130_fd_sc_hd__decap_3
XFILLER_41_186 VGND VGND VPWR VPWR sky130_fd_sc_hd__decap_3
XTAP_TAPCELL_ROW_52_693 VGND VPWR sky130_fd_sc_hd__tapvpwrvgnd_1
XFILLER_6_533 VGND VGND VPWR VPWR sky130_fd_sc_hd__decap_3
Xclkbuf_0_CLK CLK VGND VGND VPWR VPWR clkbuf_0_CLK/X sky130_fd_sc_hd__clkbuf_16
XFILLER_49_231 VGND VGND VPWR VPWR sky130_fd_sc_hd__decap_3
XFILLER_2_66 VGND VGND VPWR VPWR sky130_fd_sc_hd__fill_1
XFILLER_37_404 VGND VGND VPWR VPWR sky130_fd_sc_hd__decap_3
XFILLER_92_521 VGND VGND VPWR VPWR sky130_fd_sc_hd__decap_3
XFILLER_64_256 VGND VGND VPWR VPWR sky130_fd_sc_hd__decap_3
XFILLER_45_481 VGND VGND VPWR VPWR sky130_fd_sc_hd__decap_3
XFILLER_52_418 VGND VGND VPWR VPWR sky130_fd_sc_hd__fill_2
XFILLER_64_278 VGND VGND VPWR VPWR sky130_fd_sc_hd__decap_3
X_4930_ _5122_/CLK _4930_/D VGND VGND VPWR VPWR _4930_/Q sky130_fd_sc_hd__dfxtp_2
X_4861_ _5170_/Q _3252_/C _3228_/Y _3233_/X VGND VGND VPWR VPWR _5170_/D sky130_fd_sc_hd__o22a_2
XFILLER_32_164 VGND VGND VPWR VPWR sky130_fd_sc_hd__decap_3
XFILLER_60_451 VGND VGND VPWR VPWR sky130_fd_sc_hd__decap_3
XFILLER_60_473 VGND VGND VPWR VPWR sky130_fd_sc_hd__decap_3
X_3812_ _5064_/Q _5048_/Q _5032_/Q _5016_/Q _3834_/S0 _3834_/S1 VGND VGND VPWR VPWR
+ _3812_/X sky130_fd_sc_hd__mux4_2
XTAP_TAPCELL_ROW_15_340 VGND VPWR sky130_fd_sc_hd__tapvpwrvgnd_1
XFILLER_20_326 VGND VGND VPWR VPWR sky130_fd_sc_hd__fill_1
X_4792_ _2443_/Y _2490_/B _4716_/B _3768_/B VGND VGND VPWR VPWR _4792_/Y sky130_fd_sc_hd__a22oi_2
X_3743_ _3744_/B VGND VGND VPWR VPWR _3743_/Y sky130_fd_sc_hd__inv_2
X_3674_ _4077_/S _3674_/B VGND VGND VPWR VPWR _3674_/X sky130_fd_sc_hd__and2b_2
Xoutput101 _2743_/X VGND VGND VPWR VPWR MEM_STR_DATA[3] sky130_fd_sc_hd__clkdlybuf4s25_1
X_2625_ _4892_/Q _4876_/Q _5100_/Q _5084_/Q _2658_/S0 _2671_/S1 VGND VGND VPWR VPWR
+ _2625_/X sky130_fd_sc_hd__mux4_2
X_2556_ _2554_/X _2555_/X _5125_/Q VGND VGND VPWR VPWR _2556_/X sky130_fd_sc_hd__mux2_1
X_2487_ _2481_/X _2483_/X _2486_/X _2435_/Y VGND VGND VPWR VPWR _4551_/A sky130_fd_sc_hd__a22o_2
XFILLER_87_326 VGND VGND VPWR VPWR sky130_fd_sc_hd__decap_3
X_4226_ _4468_/A _4523_/S _4225_/X VGND VGND VPWR VPWR _4226_/X sky130_fd_sc_hd__o21a_2
XFILLER_28_415 VGND VGND VPWR VPWR sky130_fd_sc_hd__decap_3
XFILLER_68_551 VGND VGND VPWR VPWR sky130_fd_sc_hd__fill_2
X_4157_ _4035_/X _4032_/X _4173_/A VGND VGND VPWR VPWR _4157_/X sky130_fd_sc_hd__mux2_1
X_3108_ _2922_/X _3098_/Y _3099_/Y _5019_/Q VGND VGND VPWR VPWR _5019_/D sky130_fd_sc_hd__a22o_2
XFILLER_83_543 VGND VGND VPWR VPWR sky130_fd_sc_hd__decap_3
XFILLER_55_256 VGND VGND VPWR VPWR sky130_fd_sc_hd__fill_1
X_4088_ _4088_/A _4088_/B _4088_/C _4088_/D VGND VGND VPWR VPWR _4088_/X sky130_fd_sc_hd__or4_2
XFILLER_55_278 VGND VGND VPWR VPWR sky130_fd_sc_hd__fill_2
XFILLER_70_204 VGND VGND VPWR VPWR sky130_fd_sc_hd__fill_1
X_3039_ _2941_/X _3024_/B _3024_/Y _4961_/Q VGND VGND VPWR VPWR _4961_/D sky130_fd_sc_hd__a22o_2
XFILLER_36_492 VGND VGND VPWR VPWR sky130_fd_sc_hd__fill_1
XFILLER_11_304 VGND VGND VPWR VPWR sky130_fd_sc_hd__decap_3
XFILLER_51_473 VGND VGND VPWR VPWR sky130_fd_sc_hd__decap_3
XFILLER_11_337 VGND VGND VPWR VPWR sky130_fd_sc_hd__decap_3
XFILLER_23_175 VGND VGND VPWR VPWR sky130_fd_sc_hd__decap_3
XFILLER_11_42 VGND VGND VPWR VPWR sky130_fd_sc_hd__decap_3
XTAP_TAPCELL_ROW_21_398 VGND VPWR sky130_fd_sc_hd__tapvpwrvgnd_1
XFILLER_11_86 VGND VGND VPWR VPWR sky130_fd_sc_hd__decap_3
XFILLER_87_24 VGND VGND VPWR VPWR sky130_fd_sc_hd__decap_3
XFILLER_87_68 VGND VGND VPWR VPWR sky130_fd_sc_hd__decap_3
XFILLER_87_57 VGND VGND VPWR VPWR sky130_fd_sc_hd__decap_3
XFILLER_78_315 VGND VGND VPWR VPWR sky130_fd_sc_hd__decap_3
XFILLER_78_348 VGND VGND VPWR VPWR sky130_fd_sc_hd__decap_3
XFILLER_59_551 VGND VGND VPWR VPWR sky130_fd_sc_hd__fill_2
XFILLER_19_415 VGND VGND VPWR VPWR sky130_fd_sc_hd__decap_3
XFILLER_46_212 VGND VGND VPWR VPWR sky130_fd_sc_hd__decap_3
XFILLER_46_245 VGND VGND VPWR VPWR sky130_fd_sc_hd__decap_3
XFILLER_46_256 VGND VGND VPWR VPWR sky130_fd_sc_hd__decap_3
XFILLER_74_543 VGND VGND VPWR VPWR sky130_fd_sc_hd__decap_3
XTAP_TAPCELL_ROW_57_741 VGND VPWR sky130_fd_sc_hd__tapvpwrvgnd_1
XFILLER_27_481 VGND VGND VPWR VPWR sky130_fd_sc_hd__decap_3
XFILLER_36_61 VGND VGND VPWR VPWR sky130_fd_sc_hd__fill_1
XFILLER_61_204 VGND VGND VPWR VPWR sky130_fd_sc_hd__decap_3
XTAP_TAPCELL_ROW_29_476 VGND VPWR sky130_fd_sc_hd__tapvpwrvgnd_1
XFILLER_36_83 VGND VGND VPWR VPWR sky130_fd_sc_hd__fill_1
XFILLER_36_94 VGND VGND VPWR VPWR sky130_fd_sc_hd__fill_1
XFILLER_61_237 VGND VGND VPWR VPWR sky130_fd_sc_hd__decap_3
XFILLER_14_197 VGND VGND VPWR VPWR sky130_fd_sc_hd__fill_1
XFILLER_42_484 VGND VGND VPWR VPWR sky130_fd_sc_hd__decap_3
Xinput36 MEM_LD_DATA[12] VGND VGND VPWR VPWR input36/X sky130_fd_sc_hd__clkdlybuf4s25_1
Xinput25 INSTR_STREAM[31] VGND VGND VPWR VPWR _3450_/B sky130_fd_sc_hd__clkdlybuf4s25_1
Xinput14 INSTR_STREAM[21] VGND VGND VPWR VPWR _3247_/B sky130_fd_sc_hd__clkdlybuf4s25_1
XFILLER_10_392 VGND VGND VPWR VPWR sky130_fd_sc_hd__decap_3
XFILLER_6_341 VGND VGND VPWR VPWR sky130_fd_sc_hd__decap_3
Xinput47 MEM_LD_DATA[8] VGND VGND VPWR VPWR input47/X sky130_fd_sc_hd__clkdlybuf4s25_1
X_3390_ _3387_/X _3388_/X _5185_/Q VGND VGND VPWR VPWR _3390_/X sky130_fd_sc_hd__o21a_2
XFILLER_69_337 VGND VGND VPWR VPWR sky130_fd_sc_hd__decap_3
X_5060_ _5210_/CLK _5060_/D VGND VGND VPWR VPWR _5060_/Q sky130_fd_sc_hd__dfxtp_2
XFILLER_28_3 VGND VGND VPWR VPWR sky130_fd_sc_hd__decap_3
X_4011_ _4011_/A VGND VGND VPWR VPWR _4011_/Y sky130_fd_sc_hd__inv_2
XFILLER_84_307 VGND VGND VPWR VPWR sky130_fd_sc_hd__fill_1
XFILLER_77_90 VGND VGND VPWR VPWR sky130_fd_sc_hd__decap_3
XFILLER_37_223 VGND VGND VPWR VPWR sky130_fd_sc_hd__fill_1
XFILLER_77_381 VGND VGND VPWR VPWR sky130_fd_sc_hd__decap_3
XFILLER_37_234 VGND VGND VPWR VPWR sky130_fd_sc_hd__decap_3
XFILLER_92_340 VGND VGND VPWR VPWR sky130_fd_sc_hd__decap_3
XFILLER_25_429 VGND VGND VPWR VPWR sky130_fd_sc_hd__fill_2
XFILLER_52_237 VGND VGND VPWR VPWR sky130_fd_sc_hd__decap_3
XFILLER_52_259 VGND VGND VPWR VPWR sky130_fd_sc_hd__decap_3
X_4913_ _5103_/CLK _4913_/D VGND VGND VPWR VPWR _4913_/Q sky130_fd_sc_hd__dfxtp_2
XFILLER_92_395 VGND VGND VPWR VPWR sky130_fd_sc_hd__decap_3
XFILLER_33_440 VGND VGND VPWR VPWR sky130_fd_sc_hd__decap_3
XFILLER_60_281 VGND VGND VPWR VPWR sky130_fd_sc_hd__fill_2
X_4844_ input37/X _4816_/Y _4843_/X _3442_/B VGND VGND VPWR VPWR _5251_/D sky130_fd_sc_hd__o211a_2
XTAP_TAPCELL_ROW_63_799 VGND VPWR sky130_fd_sc_hd__tapvpwrvgnd_1
XFILLER_20_134 VGND VGND VPWR VPWR sky130_fd_sc_hd__fill_1
X_4775_ _4774_/X _4745_/A _4802_/A VGND VGND VPWR VPWR _4776_/B sky130_fd_sc_hd__mux2_1
XFILLER_20_189 VGND VGND VPWR VPWR sky130_fd_sc_hd__decap_3
X_3726_ _4730_/S _4275_/B VGND VGND VPWR VPWR _4285_/C sky130_fd_sc_hd__nand2b_2
X_3657_ _3657_/A VGND VGND VPWR VPWR _3657_/Y sky130_fd_sc_hd__inv_2
X_3588_ _5177_/Q _3999_/A _5178_/Q VGND VGND VPWR VPWR _4763_/A sky130_fd_sc_hd__or3b_2
X_2608_ _2855_/A _3875_/A _2594_/X VGND VGND VPWR VPWR _2857_/B sky130_fd_sc_hd__a21o_2
XFILLER_0_528 VGND VGND VPWR VPWR sky130_fd_sc_hd__decap_3
X_2539_ _5125_/Q _2539_/B VGND VGND VPWR VPWR _2539_/X sky130_fd_sc_hd__or2_2
XFILLER_0_539 VGND VGND VPWR VPWR sky130_fd_sc_hd__decap_3
XFILLER_57_27 VGND VGND VPWR VPWR sky130_fd_sc_hd__decap_3
X_5258_ _5262_/CLK _5258_/D VGND VGND VPWR VPWR _5258_/Q sky130_fd_sc_hd__dfxtp_2
XFILLER_87_178 VGND VGND VPWR VPWR sky130_fd_sc_hd__decap_3
XFILLER_87_156 VGND VGND VPWR VPWR sky130_fd_sc_hd__decap_3
XFILLER_56_510 VGND VGND VPWR VPWR sky130_fd_sc_hd__decap_3
XFILLER_75_329 VGND VGND VPWR VPWR sky130_fd_sc_hd__decap_3
X_4209_ _5176_/Q _4704_/S _4284_/B _3999_/B VGND VGND VPWR VPWR _4211_/B sky130_fd_sc_hd__a211o_2
X_5189_ clkload5/A _5189_/D VGND VGND VPWR VPWR _5189_/Q sky130_fd_sc_hd__dfxtp_2
XFILLER_28_256 VGND VGND VPWR VPWR sky130_fd_sc_hd__decap_3
XFILLER_83_351 VGND VGND VPWR VPWR sky130_fd_sc_hd__decap_3
XFILLER_16_418 VGND VGND VPWR VPWR sky130_fd_sc_hd__fill_2
XFILLER_16_429 VGND VGND VPWR VPWR sky130_fd_sc_hd__decap_3
XFILLER_43_215 VGND VGND VPWR VPWR sky130_fd_sc_hd__decap_3
XFILLER_73_37 VGND VGND VPWR VPWR sky130_fd_sc_hd__decap_3
XTAP_TAPCELL_ROW_54_711 VGND VPWR sky130_fd_sc_hd__tapvpwrvgnd_1
XFILLER_71_546 VGND VGND VPWR VPWR sky130_fd_sc_hd__decap_3
XTAP_TAPCELL_ROW_26_446 VGND VPWR sky130_fd_sc_hd__tapvpwrvgnd_1
XFILLER_51_281 VGND VGND VPWR VPWR sky130_fd_sc_hd__decap_3
XFILLER_11_156 VGND VGND VPWR VPWR sky130_fd_sc_hd__decap_3
XFILLER_11_189 VGND VGND VPWR VPWR sky130_fd_sc_hd__decap_3
XFILLER_7_116 VGND VGND VPWR VPWR sky130_fd_sc_hd__decap_3
XFILLER_22_74 VGND VGND VPWR VPWR sky130_fd_sc_hd__decap_3
XFILLER_3_355 VGND VGND VPWR VPWR sky130_fd_sc_hd__fill_2
XFILLER_3_399 VGND VGND VPWR VPWR sky130_fd_sc_hd__fill_1
XFILLER_78_123 VGND VGND VPWR VPWR sky130_fd_sc_hd__decap_3
XFILLER_66_307 VGND VGND VPWR VPWR sky130_fd_sc_hd__fill_1
XFILLER_66_318 VGND VGND VPWR VPWR sky130_fd_sc_hd__fill_2
XFILLER_19_223 VGND VGND VPWR VPWR sky130_fd_sc_hd__fill_1
XFILLER_19_234 VGND VGND VPWR VPWR sky130_fd_sc_hd__decap_3
XFILLER_47_60 VGND VGND VPWR VPWR sky130_fd_sc_hd__decap_3
XFILLER_19_267 VGND VGND VPWR VPWR sky130_fd_sc_hd__decap_3
XFILLER_47_93 VGND VGND VPWR VPWR sky130_fd_sc_hd__decap_3
XFILLER_62_524 VGND VGND VPWR VPWR sky130_fd_sc_hd__decap_3
XFILLER_42_281 VGND VGND VPWR VPWR sky130_fd_sc_hd__decap_3
X_2890_ _5222_/Q _4850_/A _3458_/B _5206_/Q VGND VGND VPWR VPWR _2890_/X sky130_fd_sc_hd__a22o_2
XFILLER_30_432 VGND VGND VPWR VPWR sky130_fd_sc_hd__decap_3
XTAP_TAPCELL_ROW_60_769 VGND VPWR sky130_fd_sc_hd__tapvpwrvgnd_1
XFILLER_30_498 VGND VGND VPWR VPWR sky130_fd_sc_hd__decap_3
X_4560_ _5223_/Q _4850_/B _4136_/Y _4559_/X VGND VGND VPWR VPWR _4561_/B sky130_fd_sc_hd__o2bb2a_2
XFILLER_8_65 VGND VGND VPWR VPWR sky130_fd_sc_hd__decap_3
X_4491_ _4456_/B _4457_/Y _4489_/B _4489_/A VGND VGND VPWR VPWR _4492_/B sky130_fd_sc_hd__o211a_2
X_3511_ _3511_/A _3511_/B VGND VGND VPWR VPWR _3511_/Y sky130_fd_sc_hd__xnor2_2
X_3442_ _5260_/Q _3442_/B _3442_/C VGND VGND VPWR VPWR _3442_/X sky130_fd_sc_hd__and3_2
X_3373_ _2425_/Y _3368_/Y _3378_/B _3372_/X VGND VGND VPWR VPWR _3373_/Y sky130_fd_sc_hd__o31ai_2
X_5112_ _5112_/CLK _5112_/D VGND VGND VPWR VPWR _5112_/Q sky130_fd_sc_hd__dfxtp_2
XFILLER_57_307 VGND VGND VPWR VPWR sky130_fd_sc_hd__decap_3
XFILLER_69_178 VGND VGND VPWR VPWR sky130_fd_sc_hd__decap_3
X_5043_ _5063_/CLK _5043_/D VGND VGND VPWR VPWR _5043_/Q sky130_fd_sc_hd__dfxtp_2
XTAP_TAPCELL_ROW_68_847 VGND VPWR sky130_fd_sc_hd__tapvpwrvgnd_1
XFILLER_65_340 VGND VGND VPWR VPWR sky130_fd_sc_hd__decap_3
XFILLER_53_502 VGND VGND VPWR VPWR sky130_fd_sc_hd__fill_2
XFILLER_65_373 VGND VGND VPWR VPWR sky130_fd_sc_hd__decap_3
XFILLER_25_237 VGND VGND VPWR VPWR sky130_fd_sc_hd__decap_3
XFILLER_53_535 VGND VGND VPWR VPWR sky130_fd_sc_hd__decap_3
XFILLER_80_365 VGND VGND VPWR VPWR sky130_fd_sc_hd__decap_3
XFILLER_40_218 VGND VGND VPWR VPWR sky130_fd_sc_hd__decap_3
XTAP_TAPCELL_ROW_23_416 VGND VPWR sky130_fd_sc_hd__tapvpwrvgnd_1
X_4827_ _5243_/Q _4847_/B VGND VGND VPWR VPWR _4827_/X sky130_fd_sc_hd__or2_2
XFILLER_21_465 VGND VGND VPWR VPWR sky130_fd_sc_hd__decap_3
XFILLER_21_476 VGND VGND VPWR VPWR sky130_fd_sc_hd__decap_3
X_4758_ _4471_/B _4429_/B _4787_/S VGND VGND VPWR VPWR _4759_/A sky130_fd_sc_hd__mux2_1
XTAP_TAPCELL_ROW_31_493 VGND VPWR sky130_fd_sc_hd__tapvpwrvgnd_1
X_4689_ _2443_/Y _4333_/B _4689_/S VGND VGND VPWR VPWR _4689_/X sky130_fd_sc_hd__mux2_1
X_3709_ _4958_/Q _4942_/Q _4926_/Q _4910_/Q _3834_/S0 _3834_/S1 VGND VGND VPWR VPWR
+ _3709_/X sky130_fd_sc_hd__mux4_2
XFILLER_68_26 VGND VGND VPWR VPWR sky130_fd_sc_hd__fill_2
XFILLER_0_325 VGND VGND VPWR VPWR sky130_fd_sc_hd__decap_3
XFILLER_88_443 VGND VGND VPWR VPWR sky130_fd_sc_hd__decap_3
XFILLER_88_421 VGND VGND VPWR VPWR sky130_fd_sc_hd__fill_2
XFILLER_48_307 VGND VGND VPWR VPWR sky130_fd_sc_hd__fill_1
XTAP_TAPCELL_ROW_89_1049 VGND VPWR sky130_fd_sc_hd__tapvpwrvgnd_1
XFILLER_84_47 VGND VGND VPWR VPWR sky130_fd_sc_hd__decap_3
XFILLER_16_215 VGND VGND VPWR VPWR sky130_fd_sc_hd__fill_1
XTAP_TAPCELL_ROW_39_571 VGND VPWR sky130_fd_sc_hd__tapvpwrvgnd_1
XFILLER_90_129 VGND VGND VPWR VPWR sky130_fd_sc_hd__decap_3
XFILLER_44_546 VGND VGND VPWR VPWR sky130_fd_sc_hd__decap_3
XFILLER_56_395 VGND VGND VPWR VPWR sky130_fd_sc_hd__decap_3
XFILLER_71_321 VGND VGND VPWR VPWR sky130_fd_sc_hd__decap_3
XFILLER_71_343 VGND VGND VPWR VPWR sky130_fd_sc_hd__decap_3
XFILLER_17_85 VGND VGND VPWR VPWR sky130_fd_sc_hd__decap_3
XFILLER_31_207 VGND VGND VPWR VPWR sky130_fd_sc_hd__decap_3
XFILLER_71_376 VGND VGND VPWR VPWR sky130_fd_sc_hd__decap_3
XFILLER_24_270 VGND VGND VPWR VPWR sky130_fd_sc_hd__decap_3
XFILLER_12_432 VGND VGND VPWR VPWR sky130_fd_sc_hd__fill_1
XFILLER_8_447 VGND VGND VPWR VPWR sky130_fd_sc_hd__decap_3
XFILLER_79_498 VGND VGND VPWR VPWR sky130_fd_sc_hd__decap_3
XFILLER_47_340 VGND VGND VPWR VPWR sky130_fd_sc_hd__fill_1
XFILLER_66_137 VGND VGND VPWR VPWR sky130_fd_sc_hd__decap_3
XFILLER_47_351 VGND VGND VPWR VPWR sky130_fd_sc_hd__decap_3
XTAP_TAPCELL_ROW_65_817 VGND VPWR sky130_fd_sc_hd__tapvpwrvgnd_1
XFILLER_47_384 VGND VGND VPWR VPWR sky130_fd_sc_hd__decap_3
XFILLER_74_170 VGND VGND VPWR VPWR sky130_fd_sc_hd__decap_3
XFILLER_62_343 VGND VGND VPWR VPWR sky130_fd_sc_hd__decap_3
XFILLER_62_365 VGND VGND VPWR VPWR sky130_fd_sc_hd__decap_3
XFILLER_74_91 VGND VGND VPWR VPWR sky130_fd_sc_hd__decap_3
X_3991_ _2607_/Y _3925_/Y _3990_/Y VGND VGND VPWR VPWR _3991_/Y sky130_fd_sc_hd__o21ai_2
XFILLER_62_398 VGND VGND VPWR VPWR sky130_fd_sc_hd__decap_3
X_2942_ _4881_/Q _2897_/Y _2941_/X _2897_/B VGND VGND VPWR VPWR _4881_/D sky130_fd_sc_hd__a22o_2
XTAP_TAPCELL_ROW_73_894 VGND VPWR sky130_fd_sc_hd__tapvpwrvgnd_1
XFILLER_15_281 VGND VGND VPWR VPWR sky130_fd_sc_hd__decap_3
XFILLER_30_273 VGND VGND VPWR VPWR sky130_fd_sc_hd__decap_3
X_2873_ _4223_/A _2873_/B VGND VGND VPWR VPWR _2874_/B sky130_fd_sc_hd__xnor2_2
X_4612_ _3876_/A _4224_/A _4083_/X _4611_/X VGND VGND VPWR VPWR _4612_/X sky130_fd_sc_hd__o211a_2
X_4543_ _4542_/S _4534_/C _4535_/Y VGND VGND VPWR VPWR _4634_/B sky130_fd_sc_hd__a21o_2
Xmax_cap122 _3172_/Y VGND VGND VPWR VPWR _3185_/B1 sky130_fd_sc_hd__buf_6
Xmax_cap133 _2888_/Y VGND VGND VPWR VPWR _3456_/B sky130_fd_sc_hd__buf_6
Xmax_cap144 _5128_/Q VGND VGND VPWR VPWR _3834_/S1 sky130_fd_sc_hd__buf_12
Xmax_cap111 _4800_/B VGND VGND VPWR VPWR _4850_/B sky130_fd_sc_hd__buf_12
X_4474_ _4464_/B _3924_/B _4466_/B VGND VGND VPWR VPWR _4474_/Y sky130_fd_sc_hd__a21oi_2
X_3425_ _5260_/Q _3448_/B _3425_/C VGND VGND VPWR VPWR _3425_/X sky130_fd_sc_hd__and3_2
X_3356_ _5144_/Q _3371_/C VGND VGND VPWR VPWR _3380_/C sky130_fd_sc_hd__and2_2
X_3287_ _5185_/Q _3298_/B _3286_/Y _3265_/B VGND VGND VPWR VPWR _3287_/X sky130_fd_sc_hd__o31a_2
XFILLER_85_435 VGND VGND VPWR VPWR sky130_fd_sc_hd__decap_3
XFILLER_57_159 VGND VGND VPWR VPWR sky130_fd_sc_hd__decap_3
X_5026_ _5098_/CLK _5026_/D VGND VGND VPWR VPWR _5026_/Q sky130_fd_sc_hd__dfxtp_2
XFILLER_38_351 VGND VGND VPWR VPWR sky130_fd_sc_hd__decap_3
XFILLER_65_181 VGND VGND VPWR VPWR sky130_fd_sc_hd__decap_3
XFILLER_72_129 VGND VGND VPWR VPWR sky130_fd_sc_hd__fill_2
XFILLER_41_505 VGND VGND VPWR VPWR sky130_fd_sc_hd__fill_1
XFILLER_53_343 VGND VGND VPWR VPWR sky130_fd_sc_hd__decap_3
XTAP_TAPCELL_ROW_36_541 VGND VPWR sky130_fd_sc_hd__tapvpwrvgnd_1
XTAP_TAPCELL_ROW_0_188 VGND VPWR sky130_fd_sc_hd__tapvpwrvgnd_1
XTAP_TAPCELL_ROW_0_199 VGND VPWR sky130_fd_sc_hd__tapvpwrvgnd_1
XFILLER_70_27 VGND VGND VPWR VPWR sky130_fd_sc_hd__fill_1
XFILLER_5_428 VGND VGND VPWR VPWR sky130_fd_sc_hd__decap_3
XFILLER_0_111 VGND VGND VPWR VPWR sky130_fd_sc_hd__fill_1
XFILLER_0_133 VGND VGND VPWR VPWR sky130_fd_sc_hd__decap_3
XFILLER_0_144 VGND VGND VPWR VPWR sky130_fd_sc_hd__decap_3
XTAP_TAPCELL_ROW_8_277 VGND VPWR sky130_fd_sc_hd__tapvpwrvgnd_1
XFILLER_48_115 VGND VGND VPWR VPWR sky130_fd_sc_hd__decap_3
XFILLER_88_262 VGND VGND VPWR VPWR sky130_fd_sc_hd__decap_3
XFILLER_76_424 VGND VGND VPWR VPWR sky130_fd_sc_hd__fill_2
XFILLER_76_413 VGND VGND VPWR VPWR sky130_fd_sc_hd__decap_3
XFILLER_48_137 VGND VGND VPWR VPWR sky130_fd_sc_hd__decap_3
XFILLER_76_468 VGND VGND VPWR VPWR sky130_fd_sc_hd__decap_3
XFILLER_76_446 VGND VGND VPWR VPWR sky130_fd_sc_hd__decap_3
XFILLER_29_340 VGND VGND VPWR VPWR sky130_fd_sc_hd__fill_1
XFILLER_29_362 VGND VGND VPWR VPWR sky130_fd_sc_hd__fill_1
XFILLER_91_416 VGND VGND VPWR VPWR sky130_fd_sc_hd__decap_3
XFILLER_32_505 VGND VGND VPWR VPWR sky130_fd_sc_hd__decap_3
XFILLER_44_365 VGND VGND VPWR VPWR sky130_fd_sc_hd__decap_3
XFILLER_44_398 VGND VGND VPWR VPWR sky130_fd_sc_hd__decap_3
XTAP_TAPCELL_ROW_70_864 VGND VPWR sky130_fd_sc_hd__tapvpwrvgnd_1
XFILLER_8_200 VGND VGND VPWR VPWR sky130_fd_sc_hd__fill_2
XFILLER_81_9 VGND VGND VPWR VPWR sky130_fd_sc_hd__decap_3
XTAP_TAPCELL_ROW_42_599 VGND VPWR sky130_fd_sc_hd__tapvpwrvgnd_1
XFILLER_60_71 VGND VGND VPWR VPWR sky130_fd_sc_hd__decap_3
XFILLER_60_93 VGND VGND VPWR VPWR sky130_fd_sc_hd__decap_3
XFILLER_4_483 VGND VGND VPWR VPWR sky130_fd_sc_hd__decap_3
X_4190_ _4149_/A _4148_/A _4148_/B _3794_/B VGND VGND VPWR VPWR _4191_/B sky130_fd_sc_hd__a31o_2
X_3210_ _2900_/X _3221_/A2 _3208_/Y _5108_/Q VGND VGND VPWR VPWR _5108_/D sky130_fd_sc_hd__a22o_2
XFILLER_79_251 VGND VGND VPWR VPWR sky130_fd_sc_hd__fill_1
XFILLER_67_402 VGND VGND VPWR VPWR sky130_fd_sc_hd__decap_3
X_3141_ _2910_/X _3152_/A2 _3136_/Y _5047_/Q VGND VGND VPWR VPWR _5047_/D sky130_fd_sc_hd__a22o_2
XFILLER_79_284 VGND VGND VPWR VPWR sky130_fd_sc_hd__decap_3
XFILLER_10_3 VGND VGND VPWR VPWR sky130_fd_sc_hd__decap_3
XFILLER_39_148 VGND VGND VPWR VPWR sky130_fd_sc_hd__decap_3
XTAP_TAPCELL_ROW_78_942 VGND VPWR sky130_fd_sc_hd__tapvpwrvgnd_1
XFILLER_67_479 VGND VGND VPWR VPWR sky130_fd_sc_hd__decap_3
X_3072_ _2929_/X _3074_/A2 _3061_/Y _4989_/Q VGND VGND VPWR VPWR _4989_/D sky130_fd_sc_hd__a22o_2
XFILLER_23_505 VGND VGND VPWR VPWR sky130_fd_sc_hd__decap_3
XFILLER_35_376 VGND VGND VPWR VPWR sky130_fd_sc_hd__fill_2
XFILLER_50_324 VGND VGND VPWR VPWR sky130_fd_sc_hd__decap_3
XTAP_TAPCELL_ROW_33_511 VGND VPWR sky130_fd_sc_hd__tapvpwrvgnd_1
XFILLER_50_346 VGND VGND VPWR VPWR sky130_fd_sc_hd__decap_3
X_3974_ _4449_/B _4010_/S _3973_/Y VGND VGND VPWR VPWR _3974_/X sky130_fd_sc_hd__o21a_2
XFILLER_50_368 VGND VGND VPWR VPWR sky130_fd_sc_hd__decap_3
X_2925_ _5199_/Q _2455_/X _3456_/B _5247_/Q VGND VGND VPWR VPWR _2926_/B sky130_fd_sc_hd__a22o_2
X_2856_ _2887_/B _2856_/B VGND VGND VPWR VPWR _2856_/Y sky130_fd_sc_hd__nor2_2
X_2787_ _5134_/Q _2782_/X _2784_/X _2786_/X VGND VGND VPWR VPWR _3323_/B sky130_fd_sc_hd__a22o_2
X_4526_ _4686_/S _4656_/B _4641_/B VGND VGND VPWR VPWR _4526_/Y sky130_fd_sc_hd__a21oi_2
XFILLER_49_28 VGND VGND VPWR VPWR sky130_fd_sc_hd__decap_3
X_4457_ _4551_/A _4471_/A VGND VGND VPWR VPWR _4457_/Y sky130_fd_sc_hd__nor2_2
X_3408_ _3265_/Y _3406_/X _3407_/X _3448_/B VGND VGND VPWR VPWR _5150_/D sky130_fd_sc_hd__o211a_2
X_4388_ _4551_/A _4387_/X _4551_/B VGND VGND VPWR VPWR _4388_/Y sky130_fd_sc_hd__o21bai_2
X_3339_ _5142_/Q _3337_/A _3338_/X _3442_/B VGND VGND VPWR VPWR _5142_/D sky130_fd_sc_hd__o211a_2
XTAP_TAPCELL_ROW_5_247 VGND VPWR sky130_fd_sc_hd__tapvpwrvgnd_1
XFILLER_85_243 VGND VGND VPWR VPWR sky130_fd_sc_hd__decap_3
XFILLER_85_221 VGND VGND VPWR VPWR sky130_fd_sc_hd__decap_3
XFILLER_73_416 VGND VGND VPWR VPWR sky130_fd_sc_hd__decap_3
XFILLER_85_276 VGND VGND VPWR VPWR sky130_fd_sc_hd__decap_3
XFILLER_66_490 VGND VGND VPWR VPWR sky130_fd_sc_hd__decap_3
X_5009_ _5121_/CLK _5009_/D VGND VGND VPWR VPWR _5009_/Q sky130_fd_sc_hd__dfxtp_2
XTAP_TAPCELL_ROW_86_1019 VGND VPWR sky130_fd_sc_hd__tapvpwrvgnd_1
XFILLER_85_287 VGND VGND VPWR VPWR sky130_fd_sc_hd__decap_3
XFILLER_26_365 VGND VGND VPWR VPWR sky130_fd_sc_hd__decap_3
XFILLER_38_192 VGND VGND VPWR VPWR sky130_fd_sc_hd__decap_3
XFILLER_53_195 VGND VGND VPWR VPWR sky130_fd_sc_hd__decap_3
XFILLER_41_379 VGND VGND VPWR VPWR sky130_fd_sc_hd__decap_3
XFILLER_5_203 VGND VGND VPWR VPWR sky130_fd_sc_hd__decap_3
XFILLER_30_85 VGND VGND VPWR VPWR sky130_fd_sc_hd__decap_3
XFILLER_49_402 VGND VGND VPWR VPWR sky130_fd_sc_hd__decap_3
XFILLER_39_72 VGND VGND VPWR VPWR sky130_fd_sc_hd__fill_1
XFILLER_49_435 VGND VGND VPWR VPWR sky130_fd_sc_hd__decap_3
XFILLER_76_232 VGND VGND VPWR VPWR sky130_fd_sc_hd__decap_3
XTAP_TAPCELL_ROW_75_912 VGND VPWR sky130_fd_sc_hd__tapvpwrvgnd_1
XFILLER_17_310 VGND VGND VPWR VPWR sky130_fd_sc_hd__fill_2
XFILLER_64_449 VGND VGND VPWR VPWR sky130_fd_sc_hd__fill_1
XTAP_TAPCELL_ROW_47_647 VGND VPWR sky130_fd_sc_hd__tapvpwrvgnd_1
XFILLER_29_192 VGND VGND VPWR VPWR sky130_fd_sc_hd__decap_3
XFILLER_55_60 VGND VGND VPWR VPWR sky130_fd_sc_hd__decap_3
XFILLER_17_376 VGND VGND VPWR VPWR sky130_fd_sc_hd__decap_3
XFILLER_32_324 VGND VGND VPWR VPWR sky130_fd_sc_hd__fill_1
XFILLER_32_357 VGND VGND VPWR VPWR sky130_fd_sc_hd__decap_3
XFILLER_32_379 VGND VGND VPWR VPWR sky130_fd_sc_hd__decap_3
X_2710_ _2708_/X _2709_/X _5133_/Q VGND VGND VPWR VPWR _2710_/X sky130_fd_sc_hd__mux2_1
X_3690_ _3684_/X _3686_/X _3689_/X _2432_/Y VGND VGND VPWR VPWR _3692_/B sky130_fd_sc_hd__a22o_2
X_2641_ _2667_/A _2641_/B VGND VGND VPWR VPWR _2641_/X sky130_fd_sc_hd__or2_2
X_2572_ _2565_/X _2567_/X _2570_/X _2435_/Y VGND VGND VPWR VPWR _4445_/A sky130_fd_sc_hd__a22o_2
XTAP_TAPCELL_ROW_10_293 VGND VPWR sky130_fd_sc_hd__tapvpwrvgnd_1
X_4311_ _4311_/A _4311_/B _4311_/C VGND VGND VPWR VPWR _4313_/C sky130_fd_sc_hd__or3_2
X_4242_ _4242_/A _4242_/B _3920_/X VGND VGND VPWR VPWR _4244_/B sky130_fd_sc_hd__or3b_2
XFILLER_67_243 VGND VGND VPWR VPWR sky130_fd_sc_hd__decap_3
X_4173_ _4173_/A _4173_/B VGND VGND VPWR VPWR _4173_/Y sky130_fd_sc_hd__nor2_2
X_3124_ _2916_/X _3117_/B _3133_/B1 _5033_/Q VGND VGND VPWR VPWR _5033_/D sky130_fd_sc_hd__a22o_2
XTAP_TAPCELL_ROW_2_217 VGND VPWR sky130_fd_sc_hd__tapvpwrvgnd_1
XFILLER_55_438 VGND VGND VPWR VPWR sky130_fd_sc_hd__decap_3
XFILLER_55_449 VGND VGND VPWR VPWR sky130_fd_sc_hd__decap_3
XFILLER_67_287 VGND VGND VPWR VPWR sky130_fd_sc_hd__decap_3
X_3055_ _2932_/X _3056_/A2 _3043_/Y _4974_/Q VGND VGND VPWR VPWR _4974_/D sky130_fd_sc_hd__a22o_2
XFILLER_35_19 VGND VGND VPWR VPWR sky130_fd_sc_hd__decap_3
XFILLER_82_246 VGND VGND VPWR VPWR sky130_fd_sc_hd__decap_3
XFILLER_35_151 VGND VGND VPWR VPWR sky130_fd_sc_hd__fill_1
XFILLER_23_324 VGND VGND VPWR VPWR sky130_fd_sc_hd__decap_3
XFILLER_23_346 VGND VGND VPWR VPWR sky130_fd_sc_hd__decap_3
XTAP_TAPCELL_ROW_18_371 VGND VPWR sky130_fd_sc_hd__tapvpwrvgnd_1
XFILLER_90_290 VGND VGND VPWR VPWR sky130_fd_sc_hd__fill_2
X_3957_ _4473_/A _4787_/S VGND VGND VPWR VPWR _4063_/B sky130_fd_sc_hd__or2_2
XFILLER_51_29 VGND VGND VPWR VPWR sky130_fd_sc_hd__decap_3
X_2908_ _5226_/Q _4850_/A _3458_/B _5210_/Q VGND VGND VPWR VPWR _2910_/A sky130_fd_sc_hd__a22o_2
X_3888_ _3992_/A _3888_/B VGND VGND VPWR VPWR _4042_/A sky130_fd_sc_hd__and2_2
X_2839_ _4961_/Q _4945_/Q _4929_/Q _4913_/Q _5131_/Q _2848_/S1 VGND VGND VPWR VPWR
+ _2839_/X sky130_fd_sc_hd__mux4_2
X_4509_ _4510_/B _4510_/A VGND VGND VPWR VPWR _4509_/X sky130_fd_sc_hd__and2b_2
XTAP_TAPCELL_ROW_92_1078 VGND VPWR sky130_fd_sc_hd__tapvpwrvgnd_1
XFILLER_76_15 VGND VGND VPWR VPWR sky130_fd_sc_hd__decap_3
XFILLER_58_243 VGND VGND VPWR VPWR sky130_fd_sc_hd__decap_3
XFILLER_18_129 VGND VGND VPWR VPWR sky130_fd_sc_hd__fill_1
XFILLER_46_427 VGND VGND VPWR VPWR sky130_fd_sc_hd__decap_3
XFILLER_58_298 VGND VGND VPWR VPWR sky130_fd_sc_hd__decap_3
XFILLER_61_408 VGND VGND VPWR VPWR sky130_fd_sc_hd__decap_3
XFILLER_54_460 VGND VGND VPWR VPWR sky130_fd_sc_hd__fill_2
XFILLER_73_279 VGND VGND VPWR VPWR sky130_fd_sc_hd__fill_1
XTAP_TAPCELL_ROW_44_617 VGND VPWR sky130_fd_sc_hd__tapvpwrvgnd_1
XFILLER_81_290 VGND VGND VPWR VPWR sky130_fd_sc_hd__decap_3
XFILLER_14_368 VGND VGND VPWR VPWR sky130_fd_sc_hd__decap_3
XTAP_TAPCELL_ROW_52_694 VGND VPWR sky130_fd_sc_hd__tapvpwrvgnd_1
XFILLER_10_552 VGND VGND VPWR VPWR sky130_fd_sc_hd__fill_1
XFILLER_41_95 VGND VGND VPWR VPWR sky130_fd_sc_hd__decap_3
XFILLER_69_508 VGND VGND VPWR VPWR sky130_fd_sc_hd__decap_3
XFILLER_89_390 VGND VGND VPWR VPWR sky130_fd_sc_hd__fill_2
XFILLER_77_552 VGND VGND VPWR VPWR sky130_fd_sc_hd__fill_1
XFILLER_37_416 VGND VGND VPWR VPWR sky130_fd_sc_hd__decap_3
XFILLER_37_438 VGND VGND VPWR VPWR sky130_fd_sc_hd__decap_3
XFILLER_37_449 VGND VGND VPWR VPWR sky130_fd_sc_hd__decap_3
XFILLER_49_276 VGND VGND VPWR VPWR sky130_fd_sc_hd__decap_3
XFILLER_49_287 VGND VGND VPWR VPWR sky130_fd_sc_hd__fill_2
XFILLER_64_235 VGND VGND VPWR VPWR sky130_fd_sc_hd__fill_1
XFILLER_92_544 VGND VGND VPWR VPWR sky130_fd_sc_hd__decap_3
XFILLER_17_162 VGND VGND VPWR VPWR sky130_fd_sc_hd__decap_3
XFILLER_45_493 VGND VGND VPWR VPWR sky130_fd_sc_hd__decap_3
XFILLER_60_430 VGND VGND VPWR VPWR sky130_fd_sc_hd__decap_3
X_4860_ _5169_/Q _3252_/C _3228_/Y _3231_/X VGND VGND VPWR VPWR _5169_/D sky130_fd_sc_hd__o22a_2
XFILLER_20_305 VGND VGND VPWR VPWR sky130_fd_sc_hd__decap_3
XFILLER_60_463 VGND VGND VPWR VPWR sky130_fd_sc_hd__decap_3
X_3811_ _5129_/Q _3811_/B VGND VGND VPWR VPWR _3811_/X sky130_fd_sc_hd__or2_2
XTAP_TAPCELL_ROW_15_341 VGND VPWR sky130_fd_sc_hd__tapvpwrvgnd_1
XFILLER_82_91 VGND VGND VPWR VPWR sky130_fd_sc_hd__decap_3
XFILLER_32_176 VGND VGND VPWR VPWR sky130_fd_sc_hd__decap_3
X_4791_ _4786_/X _4790_/X _4763_/A VGND VGND VPWR VPWR _4791_/X sky130_fd_sc_hd__a21o_2
X_3742_ _4471_/A _3742_/B VGND VGND VPWR VPWR _3744_/B sky130_fd_sc_hd__and2_2
X_3673_ _4477_/A _4468_/A _4010_/S VGND VGND VPWR VPWR _3674_/B sky130_fd_sc_hd__mux2_1
X_2624_ _2865_/A _4164_/A _3873_/B _2537_/Y _2623_/A VGND VGND VPWR VPWR _2870_/A
+ sky130_fd_sc_hd__a311o_2
Xoutput102 _2752_/X VGND VGND VPWR VPWR MEM_STR_DATA[4] sky130_fd_sc_hd__clkdlybuf4s25_1
X_2555_ _4951_/Q _4935_/Q _4919_/Q _4903_/Q _2658_/S0 _2671_/S1 VGND VGND VPWR VPWR
+ _2555_/X sky130_fd_sc_hd__mux4_2
X_2486_ _2484_/X _2485_/X _2667_/A VGND VGND VPWR VPWR _2486_/X sky130_fd_sc_hd__mux2_1
XFILLER_87_305 VGND VGND VPWR VPWR sky130_fd_sc_hd__decap_3
X_4225_ _4477_/A _4225_/B VGND VGND VPWR VPWR _4225_/X sky130_fd_sc_hd__or2_2
X_4156_ _4346_/A _4027_/X _4150_/X _4155_/X VGND VGND VPWR VPWR _4156_/X sky130_fd_sc_hd__o211a_2
XFILLER_28_427 VGND VGND VPWR VPWR sky130_fd_sc_hd__decap_3
XFILLER_55_213 VGND VGND VPWR VPWR sky130_fd_sc_hd__decap_3
X_3107_ _2919_/X _3099_/B _3099_/Y _5018_/Q VGND VGND VPWR VPWR _5018_/D sky130_fd_sc_hd__a22o_2
XFILLER_43_408 VGND VGND VPWR VPWR sky130_fd_sc_hd__decap_3
X_4087_ _4087_/A _4087_/B _4087_/C _4087_/D VGND VGND VPWR VPWR _4088_/D sky130_fd_sc_hd__or4_2
X_3038_ _2938_/X _3024_/B _3024_/Y _4960_/Q VGND VGND VPWR VPWR _4960_/D sky130_fd_sc_hd__a22o_2
XFILLER_23_110 VGND VGND VPWR VPWR sky130_fd_sc_hd__fill_2
XFILLER_70_249 VGND VGND VPWR VPWR sky130_fd_sc_hd__decap_3
XFILLER_11_316 VGND VGND VPWR VPWR sky130_fd_sc_hd__decap_3
XFILLER_51_485 VGND VGND VPWR VPWR sky130_fd_sc_hd__decap_3
X_4989_ _5119_/CLK _4989_/D VGND VGND VPWR VPWR _4989_/Q sky130_fd_sc_hd__dfxtp_2
XFILLER_11_21 VGND VGND VPWR VPWR sky130_fd_sc_hd__decap_3
XTAP_TAPCELL_ROW_21_399 VGND VPWR sky130_fd_sc_hd__tapvpwrvgnd_1
XFILLER_11_54 VGND VGND VPWR VPWR sky130_fd_sc_hd__fill_2
XFILLER_3_526 VGND VGND VPWR VPWR sky130_fd_sc_hd__decap_3
XFILLER_11_98 VGND VGND VPWR VPWR sky130_fd_sc_hd__fill_1
XFILLER_78_327 VGND VGND VPWR VPWR sky130_fd_sc_hd__decap_3
XFILLER_59_530 VGND VGND VPWR VPWR sky130_fd_sc_hd__decap_3
XFILLER_19_405 VGND VGND VPWR VPWR sky130_fd_sc_hd__decap_3
XFILLER_74_500 VGND VGND VPWR VPWR sky130_fd_sc_hd__decap_3
XFILLER_19_427 VGND VGND VPWR VPWR sky130_fd_sc_hd__decap_3
XFILLER_46_224 VGND VGND VPWR VPWR sky130_fd_sc_hd__decap_3
XFILLER_86_382 VGND VGND VPWR VPWR sky130_fd_sc_hd__decap_3
XTAP_TAPCELL_ROW_57_742 VGND VPWR sky130_fd_sc_hd__tapvpwrvgnd_1
XFILLER_34_408 VGND VGND VPWR VPWR sky130_fd_sc_hd__decap_3
XFILLER_36_73 VGND VGND VPWR VPWR sky130_fd_sc_hd__decap_3
XFILLER_46_268 VGND VGND VPWR VPWR sky130_fd_sc_hd__fill_1
XTAP_TAPCELL_ROW_29_477 VGND VPWR sky130_fd_sc_hd__tapvpwrvgnd_1
XFILLER_27_493 VGND VGND VPWR VPWR sky130_fd_sc_hd__decap_3
XFILLER_42_430 VGND VGND VPWR VPWR sky130_fd_sc_hd__decap_3
XFILLER_61_249 VGND VGND VPWR VPWR sky130_fd_sc_hd__decap_3
XFILLER_42_441 VGND VGND VPWR VPWR sky130_fd_sc_hd__decap_3
XFILLER_14_165 VGND VGND VPWR VPWR sky130_fd_sc_hd__decap_3
XFILLER_52_50 VGND VGND VPWR VPWR sky130_fd_sc_hd__decap_3
XTAP_TAPCELL_ROW_12_311 VGND VPWR sky130_fd_sc_hd__tapvpwrvgnd_1
XFILLER_52_72 VGND VGND VPWR VPWR sky130_fd_sc_hd__decap_3
XFILLER_52_94 VGND VGND VPWR VPWR sky130_fd_sc_hd__decap_3
Xinput37 MEM_LD_DATA[13] VGND VGND VPWR VPWR input37/X sky130_fd_sc_hd__clkdlybuf4s25_1
Xinput26 INSTR_STREAM[3] VGND VGND VPWR VPWR _3416_/C sky130_fd_sc_hd__clkdlybuf4s25_1
Xinput15 INSTR_STREAM[22] VGND VGND VPWR VPWR input15/X sky130_fd_sc_hd__clkdlybuf4s25_1
XFILLER_6_353 VGND VGND VPWR VPWR sky130_fd_sc_hd__decap_3
Xinput48 MEM_LD_DATA[9] VGND VGND VPWR VPWR input48/X sky130_fd_sc_hd__clkdlybuf4s25_1
XFILLER_6_386 VGND VGND VPWR VPWR sky130_fd_sc_hd__decap_3
XFILLER_69_349 VGND VGND VPWR VPWR sky130_fd_sc_hd__decap_3
X_4010_ _4249_/A _3917_/B _4010_/S VGND VGND VPWR VPWR _4011_/A sky130_fd_sc_hd__mux2_1
XFILLER_37_202 VGND VGND VPWR VPWR sky130_fd_sc_hd__decap_3
XFILLER_65_511 VGND VGND VPWR VPWR sky130_fd_sc_hd__fill_1
XFILLER_77_393 VGND VGND VPWR VPWR sky130_fd_sc_hd__decap_3
XFILLER_37_246 VGND VGND VPWR VPWR sky130_fd_sc_hd__decap_3
XFILLER_92_352 VGND VGND VPWR VPWR sky130_fd_sc_hd__decap_3
XFILLER_18_460 VGND VGND VPWR VPWR sky130_fd_sc_hd__decap_3
XFILLER_25_419 VGND VGND VPWR VPWR sky130_fd_sc_hd__fill_2
XFILLER_52_205 VGND VGND VPWR VPWR sky130_fd_sc_hd__fill_1
XFILLER_52_216 VGND VGND VPWR VPWR sky130_fd_sc_hd__decap_3
XFILLER_92_374 VGND VGND VPWR VPWR sky130_fd_sc_hd__decap_3
XFILLER_80_514 VGND VGND VPWR VPWR sky130_fd_sc_hd__decap_3
XFILLER_45_290 VGND VGND VPWR VPWR sky130_fd_sc_hd__decap_3
XFILLER_52_249 VGND VGND VPWR VPWR sky130_fd_sc_hd__decap_3
X_4912_ _5122_/CLK _4912_/D VGND VGND VPWR VPWR _4912_/Q sky130_fd_sc_hd__dfxtp_2
XFILLER_80_547 VGND VGND VPWR VPWR sky130_fd_sc_hd__decap_3
XFILLER_33_452 VGND VGND VPWR VPWR sky130_fd_sc_hd__decap_3
X_4843_ _5251_/Q _4847_/B VGND VGND VPWR VPWR _4843_/X sky130_fd_sc_hd__or2_2
X_4774_ _4471_/A _4787_/S _3952_/Y VGND VGND VPWR VPWR _4774_/X sky130_fd_sc_hd__o21a_2
XFILLER_20_168 VGND VGND VPWR VPWR sky130_fd_sc_hd__decap_3
X_3725_ _4432_/B _3882_/B VGND VGND VPWR VPWR _4275_/B sky130_fd_sc_hd__nand2_2
X_3656_ _4067_/A _4493_/A _4010_/S VGND VGND VPWR VPWR _3657_/A sky130_fd_sc_hd__mux2_1
X_3587_ _5177_/Q _5176_/Q _5178_/Q VGND VGND VPWR VPWR _4806_/A sky130_fd_sc_hd__and3b_2
X_2607_ _5153_/Q _4449_/B VGND VGND VPWR VPWR _2607_/Y sky130_fd_sc_hd__xnor2_2
X_2538_ _4888_/Q _4872_/Q _5096_/Q _5080_/Q _2658_/S0 _2671_/S1 VGND VGND VPWR VPWR
+ _2539_/B sky130_fd_sc_hd__mux4_2
X_5257_ _5262_/CLK _5257_/D VGND VGND VPWR VPWR _5257_/Q sky130_fd_sc_hd__dfxtp_2
XFILLER_87_113 VGND VGND VPWR VPWR sky130_fd_sc_hd__decap_3
XFILLER_57_39 VGND VGND VPWR VPWR sky130_fd_sc_hd__decap_3
X_4208_ _4208_/A _4208_/B VGND VGND VPWR VPWR _4712_/B sky130_fd_sc_hd__nand2_2
X_2469_ _5125_/Q _2469_/B VGND VGND VPWR VPWR _2469_/X sky130_fd_sc_hd__or2_2
X_5188_ clkload5/A _5188_/D VGND VGND VPWR VPWR _5188_/Q sky130_fd_sc_hd__dfxtp_2
X_4139_ _4139_/A _4360_/B VGND VGND VPWR VPWR _4666_/A sky130_fd_sc_hd__nand2_2
XFILLER_71_514 VGND VGND VPWR VPWR sky130_fd_sc_hd__decap_3
XTAP_TAPCELL_ROW_54_712 VGND VPWR sky130_fd_sc_hd__tapvpwrvgnd_1
XFILLER_83_374 VGND VGND VPWR VPWR sky130_fd_sc_hd__decap_3
XFILLER_24_430 VGND VGND VPWR VPWR sky130_fd_sc_hd__decap_3
XFILLER_83_396 VGND VGND VPWR VPWR sky130_fd_sc_hd__decap_3
XTAP_TAPCELL_ROW_26_447 VGND VPWR sky130_fd_sc_hd__tapvpwrvgnd_1
XFILLER_11_113 VGND VGND VPWR VPWR sky130_fd_sc_hd__decap_3
XFILLER_51_293 VGND VGND VPWR VPWR sky130_fd_sc_hd__decap_3
Xclkbuf_2_0__f_CLK clkbuf_0_CLK/X VGND VGND VPWR VPWR clkbuf_leaf_8_CLK/A sky130_fd_sc_hd__clkbuf_16
XFILLER_3_334 VGND VGND VPWR VPWR sky130_fd_sc_hd__fill_2
XFILLER_78_179 VGND VGND VPWR VPWR sky130_fd_sc_hd__decap_3
XFILLER_19_246 VGND VGND VPWR VPWR sky130_fd_sc_hd__decap_3
XFILLER_47_72 VGND VGND VPWR VPWR sky130_fd_sc_hd__decap_3
XFILLER_59_393 VGND VGND VPWR VPWR sky130_fd_sc_hd__decap_3
XFILLER_74_341 VGND VGND VPWR VPWR sky130_fd_sc_hd__decap_3
XFILLER_62_503 VGND VGND VPWR VPWR sky130_fd_sc_hd__decap_3
XFILLER_74_374 VGND VGND VPWR VPWR sky130_fd_sc_hd__decap_3
XFILLER_34_238 VGND VGND VPWR VPWR sky130_fd_sc_hd__decap_3
XFILLER_15_452 VGND VGND VPWR VPWR sky130_fd_sc_hd__fill_2
XFILLER_63_60 VGND VGND VPWR VPWR sky130_fd_sc_hd__decap_3
XFILLER_15_496 VGND VGND VPWR VPWR sky130_fd_sc_hd__decap_3
XFILLER_42_260 VGND VGND VPWR VPWR sky130_fd_sc_hd__decap_3
XFILLER_30_455 VGND VGND VPWR VPWR sky130_fd_sc_hd__decap_3
XFILLER_42_293 VGND VGND VPWR VPWR sky130_fd_sc_hd__fill_1
XPHY_EDGE_ROW_7_Left_101 VGND VGND VPWR VPWR sky130_fd_sc_hd__decap_3
XFILLER_30_477 VGND VGND VPWR VPWR sky130_fd_sc_hd__decap_3
X_3510_ _3510_/A _3510_/B VGND VGND VPWR VPWR _3511_/B sky130_fd_sc_hd__nor2_2
XFILLER_6_150 VGND VGND VPWR VPWR sky130_fd_sc_hd__decap_3
X_4490_ _4569_/A VGND VGND VPWR VPWR _4492_/A sky130_fd_sc_hd__inv_2
XFILLER_6_183 VGND VGND VPWR VPWR sky130_fd_sc_hd__decap_3
X_3441_ _5178_/Q _3429_/C _3228_/Y _3440_/X VGND VGND VPWR VPWR _5178_/D sky130_fd_sc_hd__o22a_2
X_3372_ _5185_/Q _3370_/Y _3371_/X _3337_/A VGND VGND VPWR VPWR _3372_/X sky130_fd_sc_hd__o31a_2
XFILLER_69_113 VGND VGND VPWR VPWR sky130_fd_sc_hd__fill_2
X_5111_ _5111_/CLK _5111_/D VGND VGND VPWR VPWR _5111_/Q sky130_fd_sc_hd__dfxtp_2
XFILLER_88_90 VGND VGND VPWR VPWR sky130_fd_sc_hd__fill_1
XFILLER_57_319 VGND VGND VPWR VPWR sky130_fd_sc_hd__decap_3
X_5042_ clkload6/A _5042_/D VGND VGND VPWR VPWR _5042_/Q sky130_fd_sc_hd__dfxtp_2
XTAP_TAPCELL_ROW_68_848 VGND VPWR sky130_fd_sc_hd__tapvpwrvgnd_1
XFILLER_38_533 VGND VGND VPWR VPWR sky130_fd_sc_hd__fill_1
XFILLER_65_330 VGND VGND VPWR VPWR sky130_fd_sc_hd__decap_3
XFILLER_25_205 VGND VGND VPWR VPWR sky130_fd_sc_hd__decap_3
XFILLER_53_514 VGND VGND VPWR VPWR sky130_fd_sc_hd__decap_3
XFILLER_65_352 VGND VGND VPWR VPWR sky130_fd_sc_hd__decap_3
XFILLER_25_249 VGND VGND VPWR VPWR sky130_fd_sc_hd__decap_3
XFILLER_53_547 VGND VGND VPWR VPWR sky130_fd_sc_hd__decap_3
XFILLER_65_396 VGND VGND VPWR VPWR sky130_fd_sc_hd__decap_3
XFILLER_80_377 VGND VGND VPWR VPWR sky130_fd_sc_hd__decap_3
XTAP_TAPCELL_ROW_23_417 VGND VPWR sky130_fd_sc_hd__tapvpwrvgnd_1
XFILLER_21_455 VGND VGND VPWR VPWR sky130_fd_sc_hd__decap_3
X_4826_ input43/X _4816_/Y _4825_/X _3448_/B VGND VGND VPWR VPWR _5242_/D sky130_fd_sc_hd__o211a_2
X_4757_ _5234_/Q _4800_/B VGND VGND VPWR VPWR _4757_/Y sky130_fd_sc_hd__nand2_2
XTAP_TAPCELL_ROW_31_494 VGND VPWR sky130_fd_sc_hd__tapvpwrvgnd_1
X_4688_ _4685_/X _4687_/Y _4642_/A _4642_/C VGND VGND VPWR VPWR _4699_/B sky130_fd_sc_hd__a211o_2
X_3708_ _3831_/A _3707_/X _5130_/Q VGND VGND VPWR VPWR _3708_/X sky130_fd_sc_hd__o21a_2
X_3639_ _4449_/B _4787_/S VGND VGND VPWR VPWR _3640_/C sky130_fd_sc_hd__nand2_2
XFILLER_88_400 VGND VGND VPWR VPWR sky130_fd_sc_hd__decap_3
XFILLER_0_315 VGND VGND VPWR VPWR sky130_fd_sc_hd__fill_2
XFILLER_0_359 VGND VGND VPWR VPWR sky130_fd_sc_hd__decap_3
XFILLER_88_477 VGND VGND VPWR VPWR sky130_fd_sc_hd__decap_3
XFILLER_88_455 VGND VGND VPWR VPWR sky130_fd_sc_hd__fill_1
XFILLER_29_500 VGND VGND VPWR VPWR sky130_fd_sc_hd__decap_3
XFILLER_75_116 VGND VGND VPWR VPWR sky130_fd_sc_hd__decap_3
XFILLER_56_341 VGND VGND VPWR VPWR sky130_fd_sc_hd__decap_3
XFILLER_44_503 VGND VGND VPWR VPWR sky130_fd_sc_hd__decap_3
XFILLER_56_374 VGND VGND VPWR VPWR sky130_fd_sc_hd__decap_3
XFILLER_71_300 VGND VGND VPWR VPWR sky130_fd_sc_hd__decap_3
XTAP_TAPCELL_ROW_39_572 VGND VPWR sky130_fd_sc_hd__tapvpwrvgnd_1
XFILLER_17_97 VGND VGND VPWR VPWR sky130_fd_sc_hd__decap_3
XFILLER_71_355 VGND VGND VPWR VPWR sky130_fd_sc_hd__decap_3
XFILLER_12_400 VGND VGND VPWR VPWR sky130_fd_sc_hd__decap_3
XFILLER_71_388 VGND VGND VPWR VPWR sky130_fd_sc_hd__decap_3
XFILLER_71_399 VGND VGND VPWR VPWR sky130_fd_sc_hd__decap_3
XFILLER_24_282 VGND VGND VPWR VPWR sky130_fd_sc_hd__decap_3
XFILLER_33_74 VGND VGND VPWR VPWR sky130_fd_sc_hd__decap_3
XFILLER_8_459 VGND VGND VPWR VPWR sky130_fd_sc_hd__decap_3
XPHY_EDGE_ROW_89_Left_183 VGND VGND VPWR VPWR sky130_fd_sc_hd__decap_3
XFILLER_79_422 VGND VGND VPWR VPWR sky130_fd_sc_hd__decap_3
XFILLER_79_411 VGND VGND VPWR VPWR sky130_fd_sc_hd__fill_1
XFILLER_79_455 VGND VGND VPWR VPWR sky130_fd_sc_hd__fill_2
XFILLER_39_319 VGND VGND VPWR VPWR sky130_fd_sc_hd__decap_3
XFILLER_47_330 VGND VGND VPWR VPWR sky130_fd_sc_hd__decap_3
XFILLER_35_503 VGND VGND VPWR VPWR sky130_fd_sc_hd__fill_1
XFILLER_35_514 VGND VGND VPWR VPWR sky130_fd_sc_hd__decap_3
XFILLER_47_363 VGND VGND VPWR VPWR sky130_fd_sc_hd__decap_3
XTAP_TAPCELL_ROW_65_818 VGND VPWR sky130_fd_sc_hd__tapvpwrvgnd_1
XFILLER_81_108 VGND VGND VPWR VPWR sky130_fd_sc_hd__decap_3
XFILLER_74_182 VGND VGND VPWR VPWR sky130_fd_sc_hd__decap_3
XFILLER_62_355 VGND VGND VPWR VPWR sky130_fd_sc_hd__decap_3
X_3990_ _2607_/Y _3925_/Y _4224_/A VGND VGND VPWR VPWR _3990_/Y sky130_fd_sc_hd__a21oi_2
XFILLER_50_517 VGND VGND VPWR VPWR sky130_fd_sc_hd__decap_3
XFILLER_62_377 VGND VGND VPWR VPWR sky130_fd_sc_hd__decap_3
X_2941_ _5204_/Q _2455_/X _3456_/B _5252_/Q _2940_/X VGND VGND VPWR VPWR _2941_/X
+ sky130_fd_sc_hd__a221o_2
XTAP_TAPCELL_ROW_73_895 VGND VPWR sky130_fd_sc_hd__tapvpwrvgnd_1
X_4611_ _3457_/A _4546_/A _4611_/S VGND VGND VPWR VPWR _4611_/X sky130_fd_sc_hd__mux2_1
X_2872_ _2870_/A _3682_/B _4198_/A VGND VGND VPWR VPWR _2873_/B sky130_fd_sc_hd__a21oi_2
XFILLER_88_3 VGND VGND VPWR VPWR sky130_fd_sc_hd__decap_3
XFILLER_30_285 VGND VGND VPWR VPWR sky130_fd_sc_hd__decap_3
X_4542_ _4403_/Y _4402_/X _4542_/S VGND VGND VPWR VPWR _4804_/A sky130_fd_sc_hd__mux2_1
X_4473_ _4473_/A _4614_/B VGND VGND VPWR VPWR _4473_/X sky130_fd_sc_hd__or2_2
Xmax_cap112 _4700_/S VGND VGND VPWR VPWR _4168_/A sky130_fd_sc_hd__buf_12
Xmax_cap123 _3154_/B VGND VGND VPWR VPWR _3170_/A2 sky130_fd_sc_hd__buf_6
Xmax_cap134 _3172_/B VGND VGND VPWR VPWR _3185_/A2 sky130_fd_sc_hd__buf_6
Xmax_cap145 _5127_/Q VGND VGND VPWR VPWR _3834_/S0 sky130_fd_sc_hd__buf_12
X_3424_ _4866_/A _3424_/B VGND VGND VPWR VPWR _5158_/D sky130_fd_sc_hd__nor2_2
X_3355_ _5185_/Q _3355_/B _3355_/C VGND VGND VPWR VPWR _3355_/X sky130_fd_sc_hd__and3_2
XFILLER_57_116 VGND VGND VPWR VPWR sky130_fd_sc_hd__decap_3
X_3286_ _5137_/Q _3286_/B VGND VGND VPWR VPWR _3286_/Y sky130_fd_sc_hd__nor2_2
X_5025_ _5134_/CLK _5025_/D VGND VGND VPWR VPWR _5025_/Q sky130_fd_sc_hd__dfxtp_2
XFILLER_85_469 VGND VGND VPWR VPWR sky130_fd_sc_hd__decap_3
XFILLER_85_447 VGND VGND VPWR VPWR sky130_fd_sc_hd__fill_1
XFILLER_38_363 VGND VGND VPWR VPWR sky130_fd_sc_hd__fill_1
XFILLER_38_374 VGND VGND VPWR VPWR sky130_fd_sc_hd__decap_3
XFILLER_38_396 VGND VGND VPWR VPWR sky130_fd_sc_hd__decap_3
XFILLER_53_311 VGND VGND VPWR VPWR sky130_fd_sc_hd__decap_3
XFILLER_53_333 VGND VGND VPWR VPWR sky130_fd_sc_hd__decap_3
XFILLER_54_29 VGND VGND VPWR VPWR sky130_fd_sc_hd__decap_3
XFILLER_93_480 VGND VGND VPWR VPWR sky130_fd_sc_hd__decap_3
XFILLER_53_355 VGND VGND VPWR VPWR sky130_fd_sc_hd__decap_3
XFILLER_65_193 VGND VGND VPWR VPWR sky130_fd_sc_hd__fill_1
XTAP_TAPCELL_ROW_36_542 VGND VPWR sky130_fd_sc_hd__tapvpwrvgnd_1
XFILLER_13_219 VGND VGND VPWR VPWR sky130_fd_sc_hd__decap_3
XFILLER_53_399 VGND VGND VPWR VPWR sky130_fd_sc_hd__decap_3
XTAP_TAPCELL_ROW_0_189 VGND VPWR sky130_fd_sc_hd__tapvpwrvgnd_1
XFILLER_21_274 VGND VGND VPWR VPWR sky130_fd_sc_hd__fill_1
X_4809_ _2443_/Y _2479_/B _3779_/A _2452_/Y VGND VGND VPWR VPWR _4809_/X sky130_fd_sc_hd__a22o_2
XPHY_EDGE_ROW_17_Right_17 VGND VGND VPWR VPWR sky130_fd_sc_hd__decap_3
XFILLER_79_26 VGND VGND VPWR VPWR sky130_fd_sc_hd__decap_3
XFILLER_79_48 VGND VGND VPWR VPWR sky130_fd_sc_hd__decap_3
XTAP_TAPCELL_ROW_8_278 VGND VPWR sky130_fd_sc_hd__tapvpwrvgnd_1
XFILLER_0_156 VGND VGND VPWR VPWR sky130_fd_sc_hd__decap_3
XFILLER_0_178 VGND VGND VPWR VPWR sky130_fd_sc_hd__decap_3
XPHY_EDGE_ROW_26_Right_26 VGND VGND VPWR VPWR sky130_fd_sc_hd__decap_3
XFILLER_88_285 VGND VGND VPWR VPWR sky130_fd_sc_hd__decap_3
XFILLER_28_41 VGND VGND VPWR VPWR sky130_fd_sc_hd__decap_3
XFILLER_28_74 VGND VGND VPWR VPWR sky130_fd_sc_hd__decap_3
XFILLER_63_108 VGND VGND VPWR VPWR sky130_fd_sc_hd__decap_3
XFILLER_17_547 VGND VGND VPWR VPWR sky130_fd_sc_hd__decap_3
XFILLER_28_85 VGND VGND VPWR VPWR sky130_fd_sc_hd__decap_3
XFILLER_29_374 VGND VGND VPWR VPWR sky130_fd_sc_hd__decap_3
XFILLER_29_396 VGND VGND VPWR VPWR sky130_fd_sc_hd__decap_3
XFILLER_84_480 VGND VGND VPWR VPWR sky130_fd_sc_hd__decap_3
XFILLER_32_539 VGND VGND VPWR VPWR sky130_fd_sc_hd__decap_3
XFILLER_44_377 VGND VGND VPWR VPWR sky130_fd_sc_hd__decap_3
XFILLER_40_550 VGND VGND VPWR VPWR sky130_fd_sc_hd__decap_3
XTAP_TAPCELL_ROW_70_865 VGND VPWR sky130_fd_sc_hd__tapvpwrvgnd_1
XPHY_EDGE_ROW_35_Right_35 VGND VGND VPWR VPWR sky130_fd_sc_hd__decap_3
XFILLER_4_451 VGND VGND VPWR VPWR sky130_fd_sc_hd__decap_3
XFILLER_5_45 VGND VGND VPWR VPWR sky130_fd_sc_hd__decap_3
XFILLER_4_495 VGND VGND VPWR VPWR sky130_fd_sc_hd__decap_3
XPHY_EDGE_ROW_44_Right_44 VGND VGND VPWR VPWR sky130_fd_sc_hd__decap_3
XFILLER_67_425 VGND VGND VPWR VPWR sky130_fd_sc_hd__decap_3
X_3140_ _2906_/X _3152_/A2 _3136_/Y _5046_/Q VGND VGND VPWR VPWR _5046_/D sky130_fd_sc_hd__a22o_2
XFILLER_67_447 VGND VGND VPWR VPWR sky130_fd_sc_hd__fill_1
XTAP_TAPCELL_ROW_78_943 VGND VPWR sky130_fd_sc_hd__tapvpwrvgnd_1
XFILLER_79_296 VGND VGND VPWR VPWR sky130_fd_sc_hd__fill_1
X_3071_ _2926_/X _3074_/A2 _3061_/Y _4988_/Q VGND VGND VPWR VPWR _4988_/D sky130_fd_sc_hd__a22o_2
XFILLER_82_417 VGND VGND VPWR VPWR sky130_fd_sc_hd__decap_3
XFILLER_35_311 VGND VGND VPWR VPWR sky130_fd_sc_hd__decap_3
XFILLER_82_428 VGND VGND VPWR VPWR sky130_fd_sc_hd__decap_3
XFILLER_35_355 VGND VGND VPWR VPWR sky130_fd_sc_hd__decap_3
XFILLER_23_517 VGND VGND VPWR VPWR sky130_fd_sc_hd__decap_3
XFILLER_35_399 VGND VGND VPWR VPWR sky130_fd_sc_hd__decap_3
XFILLER_50_303 VGND VGND VPWR VPWR sky130_fd_sc_hd__decap_3
XTAP_TAPCELL_ROW_33_512 VGND VPWR sky130_fd_sc_hd__tapvpwrvgnd_1
XFILLER_90_472 VGND VGND VPWR VPWR sky130_fd_sc_hd__fill_1
XFILLER_50_336 VGND VGND VPWR VPWR sky130_fd_sc_hd__decap_3
XFILLER_50_358 VGND VGND VPWR VPWR sky130_fd_sc_hd__decap_3
X_3973_ _4067_/A _4010_/S _4077_/S VGND VGND VPWR VPWR _3973_/Y sky130_fd_sc_hd__a21oi_2
XPHY_EDGE_ROW_53_Right_53 VGND VGND VPWR VPWR sky130_fd_sc_hd__decap_3
X_2924_ _5231_/Q _4850_/A _3458_/B _5215_/Q VGND VGND VPWR VPWR _2926_/A sky130_fd_sc_hd__a22o_2
X_2855_ _2855_/A _3875_/A VGND VGND VPWR VPWR _2856_/B sky130_fd_sc_hd__xnor2_2
X_4525_ _4624_/A _4622_/B _4524_/X _4067_/Y _4686_/S VGND VGND VPWR VPWR _4525_/X
+ sky130_fd_sc_hd__a221o_2
X_2786_ _2831_/S _2785_/X _2437_/Y VGND VGND VPWR VPWR _2786_/X sky130_fd_sc_hd__o21a_2
X_4456_ _4456_/A _4456_/B VGND VGND VPWR VPWR _4460_/A sky130_fd_sc_hd__nor2_2
XPHY_EDGE_ROW_62_Right_62 VGND VGND VPWR VPWR sky130_fd_sc_hd__decap_3
X_4387_ _4471_/B _4386_/X _4341_/A VGND VGND VPWR VPWR _4387_/X sky130_fd_sc_hd__o21a_2
X_3407_ _5185_/Q _3265_/B _5150_/Q VGND VGND VPWR VPWR _3407_/X sky130_fd_sc_hd__a21o_2
X_3338_ _5185_/Q _3335_/Y _3337_/Y _3265_/Y VGND VGND VPWR VPWR _3338_/X sky130_fd_sc_hd__a22o_2
XTAP_TAPCELL_ROW_5_248 VGND VPWR sky130_fd_sc_hd__tapvpwrvgnd_1
XFILLER_65_28 VGND VGND VPWR VPWR sky130_fd_sc_hd__fill_2
X_3269_ _5155_/Q _3269_/B VGND VGND VPWR VPWR _3270_/B sky130_fd_sc_hd__nor2_2
X_5008_ _5115_/CLK _5008_/D VGND VGND VPWR VPWR _5008_/Q sky130_fd_sc_hd__dfxtp_2
XFILLER_85_299 VGND VGND VPWR VPWR sky130_fd_sc_hd__fill_2
XFILLER_53_130 VGND VGND VPWR VPWR sky130_fd_sc_hd__decap_3
XPHY_EDGE_ROW_71_Right_71 VGND VGND VPWR VPWR sky130_fd_sc_hd__decap_3
XFILLER_81_27 VGND VGND VPWR VPWR sky130_fd_sc_hd__decap_3
XFILLER_41_347 VGND VGND VPWR VPWR sky130_fd_sc_hd__decap_3
XFILLER_41_358 VGND VGND VPWR VPWR sky130_fd_sc_hd__decap_3
XFILLER_5_215 VGND VGND VPWR VPWR sky130_fd_sc_hd__fill_1
XPHY_EDGE_ROW_80_Right_80 VGND VGND VPWR VPWR sky130_fd_sc_hd__decap_3
XFILLER_49_414 VGND VGND VPWR VPWR sky130_fd_sc_hd__decap_3
XFILLER_39_84 VGND VGND VPWR VPWR sky130_fd_sc_hd__fill_2
XFILLER_49_458 VGND VGND VPWR VPWR sky130_fd_sc_hd__decap_3
XFILLER_64_406 VGND VGND VPWR VPWR sky130_fd_sc_hd__decap_3
XTAP_TAPCELL_ROW_75_913 VGND VPWR sky130_fd_sc_hd__tapvpwrvgnd_1
XFILLER_64_428 VGND VGND VPWR VPWR sky130_fd_sc_hd__decap_3
XFILLER_91_203 VGND VGND VPWR VPWR sky130_fd_sc_hd__fill_1
XFILLER_76_288 VGND VGND VPWR VPWR sky130_fd_sc_hd__decap_3
XFILLER_44_141 VGND VGND VPWR VPWR sky130_fd_sc_hd__decap_3
XFILLER_55_72 VGND VGND VPWR VPWR sky130_fd_sc_hd__decap_3
XTAP_TAPCELL_ROW_47_648 VGND VPWR sky130_fd_sc_hd__tapvpwrvgnd_1
XFILLER_91_269 VGND VGND VPWR VPWR sky130_fd_sc_hd__decap_3
XFILLER_44_185 VGND VGND VPWR VPWR sky130_fd_sc_hd__decap_3
XTAP_TAPCELL_ROW_83_990 VGND VPWR sky130_fd_sc_hd__tapvpwrvgnd_1
XFILLER_40_391 VGND VGND VPWR VPWR sky130_fd_sc_hd__fill_2
XFILLER_71_93 VGND VGND VPWR VPWR sky130_fd_sc_hd__decap_3
X_2640_ _5067_/Q _5051_/Q _5035_/Q _5019_/Q _5123_/Q _2671_/S1 VGND VGND VPWR VPWR
+ _2641_/B sky130_fd_sc_hd__mux4_2
X_2571_ _2565_/X _2567_/X _2570_/X _2435_/Y VGND VGND VPWR VPWR _4493_/A sky130_fd_sc_hd__a22oi_2
XTAP_TAPCELL_ROW_10_294 VGND VPWR sky130_fd_sc_hd__tapvpwrvgnd_1
X_4310_ _4546_/A _4310_/B VGND VGND VPWR VPWR _4310_/Y sky130_fd_sc_hd__nor2_2
X_4241_ _4285_/C _4241_/B VGND VGND VPWR VPWR _4241_/Y sky130_fd_sc_hd__xnor2_2
XFILLER_67_200 VGND VGND VPWR VPWR sky130_fd_sc_hd__fill_1
XFILLER_67_211 VGND VGND VPWR VPWR sky130_fd_sc_hd__decap_3
X_4172_ _4172_/A _4172_/B VGND VGND VPWR VPWR _4172_/X sky130_fd_sc_hd__or2_2
XFILLER_67_266 VGND VGND VPWR VPWR sky130_fd_sc_hd__decap_3
X_3123_ _2913_/X _3117_/B _3133_/B1 _5032_/Q VGND VGND VPWR VPWR _5032_/D sky130_fd_sc_hd__a22o_2
XTAP_TAPCELL_ROW_2_218 VGND VPWR sky130_fd_sc_hd__tapvpwrvgnd_1
XFILLER_55_417 VGND VGND VPWR VPWR sky130_fd_sc_hd__decap_3
XFILLER_67_299 VGND VGND VPWR VPWR sky130_fd_sc_hd__decap_3
X_3054_ _2929_/X _3056_/A2 _3043_/Y _4973_/Q VGND VGND VPWR VPWR _4973_/D sky130_fd_sc_hd__a22o_2
XFILLER_82_225 VGND VGND VPWR VPWR sky130_fd_sc_hd__decap_3
XFILLER_82_203 VGND VGND VPWR VPWR sky130_fd_sc_hd__decap_3
XFILLER_48_491 VGND VGND VPWR VPWR sky130_fd_sc_hd__fill_2
XFILLER_63_494 VGND VGND VPWR VPWR sky130_fd_sc_hd__fill_1
XTAP_TAPCELL_ROW_18_372 VGND VPWR sky130_fd_sc_hd__tapvpwrvgnd_1
XFILLER_23_358 VGND VGND VPWR VPWR sky130_fd_sc_hd__fill_1
XFILLER_50_166 VGND VGND VPWR VPWR sky130_fd_sc_hd__decap_3
X_3956_ _4471_/A _4787_/S _3955_/Y VGND VGND VPWR VPWR _3956_/Y sky130_fd_sc_hd__o21ai_2
X_2907_ _4870_/Q _2936_/A2 _2906_/X _2936_/B2 VGND VGND VPWR VPWR _4870_/D sky130_fd_sc_hd__a22o_2
XFILLER_31_391 VGND VGND VPWR VPWR sky130_fd_sc_hd__fill_1
X_3887_ _4493_/B _4405_/B VGND VGND VPWR VPWR _3888_/B sky130_fd_sc_hd__nand2_2
Xclkbuf_leaf_36_CLK clkload1/A VGND VGND VPWR VPWR _5119_/CLK sky130_fd_sc_hd__clkbuf_8
X_2838_ _5133_/Q _2838_/B VGND VGND VPWR VPWR _2838_/X sky130_fd_sc_hd__or2_2
X_2769_ _5134_/Q _2764_/X _2766_/X _2768_/X VGND VGND VPWR VPWR _3302_/B sky130_fd_sc_hd__a22o_2
X_4508_ _4452_/A _4452_/B _4444_/A VGND VGND VPWR VPWR _4510_/B sky130_fd_sc_hd__o21ba_2
X_4439_ _4464_/B _4466_/A VGND VGND VPWR VPWR _4498_/B sky130_fd_sc_hd__nand2_2
XTAP_TAPCELL_ROW_92_1079 VGND VPWR sky130_fd_sc_hd__tapvpwrvgnd_1
XFILLER_58_211 VGND VGND VPWR VPWR sky130_fd_sc_hd__decap_3
XFILLER_86_542 VGND VGND VPWR VPWR sky130_fd_sc_hd__decap_3
XFILLER_76_27 VGND VGND VPWR VPWR sky130_fd_sc_hd__fill_1
XFILLER_46_406 VGND VGND VPWR VPWR sky130_fd_sc_hd__decap_3
XFILLER_58_277 VGND VGND VPWR VPWR sky130_fd_sc_hd__decap_3
XFILLER_73_225 VGND VGND VPWR VPWR sky130_fd_sc_hd__decap_3
XFILLER_39_491 VGND VGND VPWR VPWR sky130_fd_sc_hd__decap_3
XFILLER_26_141 VGND VGND VPWR VPWR sky130_fd_sc_hd__fill_2
XTAP_TAPCELL_ROW_44_618 VGND VPWR sky130_fd_sc_hd__tapvpwrvgnd_1
XFILLER_41_111 VGND VGND VPWR VPWR sky130_fd_sc_hd__fill_1
XFILLER_41_122 VGND VGND VPWR VPWR sky130_fd_sc_hd__fill_2
XFILLER_54_483 VGND VGND VPWR VPWR sky130_fd_sc_hd__fill_1
XFILLER_14_358 VGND VGND VPWR VPWR sky130_fd_sc_hd__decap_3
XFILLER_41_133 VGND VGND VPWR VPWR sky130_fd_sc_hd__fill_1
XFILLER_41_144 VGND VGND VPWR VPWR sky130_fd_sc_hd__decap_3
XFILLER_41_166 VGND VGND VPWR VPWR sky130_fd_sc_hd__fill_2
XTAP_TAPCELL_ROW_80_960 VGND VPWR sky130_fd_sc_hd__tapvpwrvgnd_1
XTAP_TAPCELL_ROW_52_695 VGND VPWR sky130_fd_sc_hd__tapvpwrvgnd_1
XFILLER_10_531 VGND VGND VPWR VPWR sky130_fd_sc_hd__fill_1
XFILLER_41_52 VGND VGND VPWR VPWR sky130_fd_sc_hd__decap_3
XFILLER_41_63 VGND VGND VPWR VPWR sky130_fd_sc_hd__fill_2
Xclkbuf_leaf_27_CLK clkload2/A VGND VGND VPWR VPWR _5118_/CLK sky130_fd_sc_hd__clkbuf_8
XFILLER_1_240 VGND VGND VPWR VPWR sky130_fd_sc_hd__decap_3
XFILLER_49_211 VGND VGND VPWR VPWR sky130_fd_sc_hd__decap_3
XFILLER_77_520 VGND VGND VPWR VPWR sky130_fd_sc_hd__decap_3
XFILLER_66_71 VGND VGND VPWR VPWR sky130_fd_sc_hd__fill_1
XFILLER_92_512 VGND VGND VPWR VPWR sky130_fd_sc_hd__decap_3
XFILLER_66_82 VGND VGND VPWR VPWR sky130_fd_sc_hd__fill_2
XFILLER_45_461 VGND VGND VPWR VPWR sky130_fd_sc_hd__decap_3
XFILLER_52_409 VGND VGND VPWR VPWR sky130_fd_sc_hd__decap_3
XFILLER_64_269 VGND VGND VPWR VPWR sky130_fd_sc_hd__decap_3
XFILLER_72_291 VGND VGND VPWR VPWR sky130_fd_sc_hd__decap_3
XFILLER_32_155 VGND VGND VPWR VPWR sky130_fd_sc_hd__decap_3
XFILLER_60_442 VGND VGND VPWR VPWR sky130_fd_sc_hd__decap_3
X_4790_ _4804_/A _4737_/X _4789_/Y _4634_/Y VGND VGND VPWR VPWR _4790_/X sky130_fd_sc_hd__a211o_2
X_3810_ _4888_/Q _4872_/Q _5096_/Q _5080_/Q _3834_/S0 _3834_/S1 VGND VGND VPWR VPWR
+ _3811_/B sky130_fd_sc_hd__mux4_2
XTAP_TAPCELL_ROW_15_342 VGND VPWR sky130_fd_sc_hd__tapvpwrvgnd_1
XPHY_EDGE_ROW_25_Left_119 VGND VGND VPWR VPWR sky130_fd_sc_hd__decap_3
XFILLER_82_81 VGND VGND VPWR VPWR sky130_fd_sc_hd__decap_3
X_3741_ _4471_/A _3742_/B VGND VGND VPWR VPWR _4779_/S sky130_fd_sc_hd__nor2_2
XFILLER_13_380 VGND VGND VPWR VPWR sky130_fd_sc_hd__decap_3
XFILLER_9_340 VGND VGND VPWR VPWR sky130_fd_sc_hd__decap_3
Xclkbuf_leaf_18_CLK clkload0/A VGND VGND VPWR VPWR _5253_/CLK sky130_fd_sc_hd__clkbuf_8
X_3672_ _4432_/B _4429_/B _4010_/S VGND VGND VPWR VPWR _3672_/X sky130_fd_sc_hd__mux2_1
X_2623_ _2623_/A _4689_/S VGND VGND VPWR VPWR _3873_/B sky130_fd_sc_hd__nor2_2
Xoutput103 _2761_/X VGND VGND VPWR VPWR MEM_STR_DATA[5] sky130_fd_sc_hd__clkdlybuf4s25_1
X_2554_ _5111_/Q _4999_/Q _4983_/Q _4967_/Q _2658_/S0 _2671_/S1 VGND VGND VPWR VPWR
+ _2554_/X sky130_fd_sc_hd__mux4_2
X_2485_ _5121_/Q _5009_/Q _4993_/Q _4977_/Q _5123_/Q _5124_/Q VGND VGND VPWR VPWR
+ _2485_/X sky130_fd_sc_hd__mux4_2
XPHY_EDGE_ROW_34_Left_128 VGND VGND VPWR VPWR sky130_fd_sc_hd__decap_3
XFILLER_87_317 VGND VGND VPWR VPWR sky130_fd_sc_hd__decap_3
XFILLER_68_531 VGND VGND VPWR VPWR sky130_fd_sc_hd__fill_1
X_4224_ _4224_/A _4242_/B _4224_/C _3919_/Y VGND VGND VPWR VPWR _4224_/X sky130_fd_sc_hd__or4b_2
XFILLER_28_406 VGND VGND VPWR VPWR sky130_fd_sc_hd__decap_3
XFILLER_68_542 VGND VGND VPWR VPWR sky130_fd_sc_hd__decap_3
X_4155_ _4155_/A _4155_/B VGND VGND VPWR VPWR _4155_/X sky130_fd_sc_hd__or2_2
XFILLER_46_19 VGND VGND VPWR VPWR sky130_fd_sc_hd__fill_1
X_3106_ _2916_/X _3099_/B _3099_/Y _5017_/Q VGND VGND VPWR VPWR _5017_/D sky130_fd_sc_hd__a22o_2
XFILLER_83_523 VGND VGND VPWR VPWR sky130_fd_sc_hd__decap_3
XFILLER_83_501 VGND VGND VPWR VPWR sky130_fd_sc_hd__decap_3
XFILLER_55_247 VGND VGND VPWR VPWR sky130_fd_sc_hd__decap_3
X_4086_ _3892_/Y _4083_/X _4085_/X VGND VGND VPWR VPWR _4087_/D sky130_fd_sc_hd__o21ai_2
XFILLER_36_472 VGND VGND VPWR VPWR sky130_fd_sc_hd__decap_3
XFILLER_55_269 VGND VGND VPWR VPWR sky130_fd_sc_hd__decap_3
X_3037_ _2935_/X _3024_/B _3024_/Y _4959_/Q VGND VGND VPWR VPWR _4959_/D sky130_fd_sc_hd__a22o_2
XFILLER_23_122 VGND VGND VPWR VPWR sky130_fd_sc_hd__decap_3
XFILLER_36_483 VGND VGND VPWR VPWR sky130_fd_sc_hd__decap_3
XFILLER_51_420 VGND VGND VPWR VPWR sky130_fd_sc_hd__decap_3
XPHY_EDGE_ROW_43_Left_137 VGND VGND VPWR VPWR sky130_fd_sc_hd__decap_3
XFILLER_62_29 VGND VGND VPWR VPWR sky130_fd_sc_hd__fill_1
XFILLER_23_166 VGND VGND VPWR VPWR sky130_fd_sc_hd__fill_2
XFILLER_51_497 VGND VGND VPWR VPWR sky130_fd_sc_hd__decap_3
X_4988_ _5117_/CLK _4988_/D VGND VGND VPWR VPWR _4988_/Q sky130_fd_sc_hd__dfxtp_2
X_3939_ _3940_/B VGND VGND VPWR VPWR _3939_/Y sky130_fd_sc_hd__inv_2
XFILLER_11_33 VGND VGND VPWR VPWR sky130_fd_sc_hd__decap_3
XFILLER_11_77 VGND VGND VPWR VPWR sky130_fd_sc_hd__decap_3
XFILLER_3_549 VGND VGND VPWR VPWR sky130_fd_sc_hd__decap_3
XPHY_EDGE_ROW_52_Left_146 VGND VGND VPWR VPWR sky130_fd_sc_hd__decap_3
XFILLER_87_15 VGND VGND VPWR VPWR sky130_fd_sc_hd__fill_1
XFILLER_59_520 VGND VGND VPWR VPWR sky130_fd_sc_hd__fill_2
XFILLER_78_339 VGND VGND VPWR VPWR sky130_fd_sc_hd__decap_3
XFILLER_59_542 VGND VGND VPWR VPWR sky130_fd_sc_hd__decap_3
XFILLER_74_512 VGND VGND VPWR VPWR sky130_fd_sc_hd__decap_3
XFILLER_74_523 VGND VGND VPWR VPWR sky130_fd_sc_hd__decap_3
XFILLER_46_236 VGND VGND VPWR VPWR sky130_fd_sc_hd__decap_3
XTAP_TAPCELL_ROW_57_743 VGND VPWR sky130_fd_sc_hd__tapvpwrvgnd_1
XFILLER_86_394 VGND VGND VPWR VPWR sky130_fd_sc_hd__decap_3
XFILLER_27_472 VGND VGND VPWR VPWR sky130_fd_sc_hd__decap_3
XTAP_TAPCELL_ROW_29_478 VGND VPWR sky130_fd_sc_hd__tapvpwrvgnd_1
XPHY_EDGE_ROW_61_Left_155 VGND VGND VPWR VPWR sky130_fd_sc_hd__decap_3
XFILLER_36_85 VGND VGND VPWR VPWR sky130_fd_sc_hd__decap_3
XFILLER_61_228 VGND VGND VPWR VPWR sky130_fd_sc_hd__decap_3
XFILLER_42_475 VGND VGND VPWR VPWR sky130_fd_sc_hd__fill_1
XTAP_TAPCELL_ROW_12_312 VGND VPWR sky130_fd_sc_hd__tapvpwrvgnd_1
XFILLER_10_361 VGND VGND VPWR VPWR sky130_fd_sc_hd__decap_3
Xinput27 INSTR_STREAM[4] VGND VGND VPWR VPWR _3418_/C sky130_fd_sc_hd__clkdlybuf4s25_1
Xinput16 INSTR_STREAM[23] VGND VGND VPWR VPWR _3252_/B sky130_fd_sc_hd__clkdlybuf4s25_1
XFILLER_6_332 VGND VGND VPWR VPWR sky130_fd_sc_hd__decap_3
Xinput49 RESET VGND VGND VPWR VPWR _4714_/A sky130_fd_sc_hd__buf_4
Xinput38 MEM_LD_DATA[14] VGND VGND VPWR VPWR input38/X sky130_fd_sc_hd__clkdlybuf4s25_1
XPHY_EDGE_ROW_70_Left_164 VGND VGND VPWR VPWR sky130_fd_sc_hd__decap_3
XFILLER_6_398 VGND VGND VPWR VPWR sky130_fd_sc_hd__decap_3
XFILLER_69_306 VGND VGND VPWR VPWR sky130_fd_sc_hd__decap_3
XFILLER_77_81 VGND VGND VPWR VPWR sky130_fd_sc_hd__decap_3
XFILLER_77_70 VGND VGND VPWR VPWR sky130_fd_sc_hd__decap_3
XFILLER_37_214 VGND VGND VPWR VPWR sky130_fd_sc_hd__decap_3
XFILLER_77_372 VGND VGND VPWR VPWR sky130_fd_sc_hd__decap_3
XFILLER_37_225 VGND VGND VPWR VPWR sky130_fd_sc_hd__decap_3
XFILLER_65_545 VGND VGND VPWR VPWR sky130_fd_sc_hd__decap_3
Xclkbuf_leaf_7_CLK clkbuf_leaf_8_CLK/A VGND VGND VPWR VPWR clkload7/A sky130_fd_sc_hd__clkbuf_8
XFILLER_92_320 VGND VGND VPWR VPWR sky130_fd_sc_hd__fill_1
XFILLER_37_258 VGND VGND VPWR VPWR sky130_fd_sc_hd__decap_3
XFILLER_37_269 VGND VGND VPWR VPWR sky130_fd_sc_hd__fill_2
XFILLER_80_526 VGND VGND VPWR VPWR sky130_fd_sc_hd__decap_3
XFILLER_18_472 VGND VGND VPWR VPWR sky130_fd_sc_hd__decap_3
XFILLER_18_483 VGND VGND VPWR VPWR sky130_fd_sc_hd__decap_3
XFILLER_33_420 VGND VGND VPWR VPWR sky130_fd_sc_hd__decap_3
XFILLER_52_228 VGND VGND VPWR VPWR sky130_fd_sc_hd__decap_3
X_4911_ _5007_/CLK _4911_/D VGND VGND VPWR VPWR _4911_/Q sky130_fd_sc_hd__dfxtp_2
XFILLER_93_80 VGND VGND VPWR VPWR sky130_fd_sc_hd__decap_3
XFILLER_92_386 VGND VGND VPWR VPWR sky130_fd_sc_hd__decap_3
X_4842_ input36/X _4816_/Y _4841_/X _3442_/B VGND VGND VPWR VPWR _5250_/D sky130_fd_sc_hd__o211a_2
X_4773_ _4804_/A _4773_/B VGND VGND VPWR VPWR _4773_/Y sky130_fd_sc_hd__nand2_2
X_3724_ _4432_/B _3882_/B VGND VGND VPWR VPWR _4730_/S sky130_fd_sc_hd__nor2_2
X_3655_ _5152_/Q _4405_/B _4547_/A VGND VGND VPWR VPWR _4010_/S sky130_fd_sc_hd__mux2_1
X_2606_ _5153_/Q _4449_/B VGND VGND VPWR VPWR _3875_/A sky130_fd_sc_hd__xor2_2
X_3586_ _3580_/Y _3585_/X _4866_/A VGND VGND VPWR VPWR _5205_/D sky130_fd_sc_hd__a21oi_2
X_2537_ _4689_/S _2621_/A VGND VGND VPWR VPWR _2537_/Y sky130_fd_sc_hd__nor2_2
X_5256_ _5263_/CLK _5256_/D VGND VGND VPWR VPWR _5256_/Q sky130_fd_sc_hd__dfxtp_2
X_2468_ _4898_/Q _4882_/Q _5106_/Q _5090_/Q _5123_/Q _5124_/Q VGND VGND VPWR VPWR
+ _2469_/B sky130_fd_sc_hd__mux4_2
XFILLER_87_103 VGND VGND VPWR VPWR sky130_fd_sc_hd__decap_3
X_4207_ _3668_/B _3677_/X _4172_/X VGND VGND VPWR VPWR _4211_/D sky130_fd_sc_hd__o21ai_2
XFILLER_87_169 VGND VGND VPWR VPWR sky130_fd_sc_hd__decap_3
XFILLER_87_147 VGND VGND VPWR VPWR sky130_fd_sc_hd__decap_3
XFILLER_68_350 VGND VGND VPWR VPWR sky130_fd_sc_hd__decap_3
X_5187_ clkload7/A _5187_/D VGND VGND VPWR VPWR _5187_/Q sky130_fd_sc_hd__dfxtp_2
X_4138_ _4172_/A _4133_/X _4137_/X _4132_/X VGND VGND VPWR VPWR _4138_/X sky130_fd_sc_hd__a211o_2
X_4069_ _4068_/Y _3983_/B _4340_/A VGND VGND VPWR VPWR _4070_/B sky130_fd_sc_hd__mux2_1
XTAP_TAPCELL_ROW_54_713 VGND VPWR sky130_fd_sc_hd__tapvpwrvgnd_1
XFILLER_36_280 VGND VGND VPWR VPWR sky130_fd_sc_hd__decap_3
XFILLER_83_386 VGND VGND VPWR VPWR sky130_fd_sc_hd__decap_3
XTAP_TAPCELL_ROW_26_448 VGND VPWR sky130_fd_sc_hd__tapvpwrvgnd_1
XFILLER_51_261 VGND VGND VPWR VPWR sky130_fd_sc_hd__decap_3
XTAP_TAPCELL_ROW_62_790 VGND VPWR sky130_fd_sc_hd__tapvpwrvgnd_1
XFILLER_0_3 VGND VGND VPWR VPWR sky130_fd_sc_hd__decap_3
XPHY_EDGE_ROW_5_Left_99 VGND VGND VPWR VPWR sky130_fd_sc_hd__decap_3
XFILLER_66_309 VGND VGND VPWR VPWR sky130_fd_sc_hd__decap_3
XFILLER_78_147 VGND VGND VPWR VPWR sky130_fd_sc_hd__decap_3
XFILLER_47_40 VGND VGND VPWR VPWR sky130_fd_sc_hd__decap_3
XFILLER_47_501 VGND VGND VPWR VPWR sky130_fd_sc_hd__decap_3
XFILLER_19_225 VGND VGND VPWR VPWR sky130_fd_sc_hd__decap_3
XFILLER_86_191 VGND VGND VPWR VPWR sky130_fd_sc_hd__decap_3
XFILLER_19_258 VGND VGND VPWR VPWR sky130_fd_sc_hd__decap_3
XFILLER_34_206 VGND VGND VPWR VPWR sky130_fd_sc_hd__decap_3
XFILLER_62_515 VGND VGND VPWR VPWR sky130_fd_sc_hd__decap_3
XFILLER_62_548 VGND VGND VPWR VPWR sky130_fd_sc_hd__decap_3
XFILLER_74_386 VGND VGND VPWR VPWR sky130_fd_sc_hd__decap_3
XFILLER_63_94 VGND VGND VPWR VPWR sky130_fd_sc_hd__decap_3
XFILLER_30_489 VGND VGND VPWR VPWR sky130_fd_sc_hd__decap_3
XFILLER_8_56 VGND VGND VPWR VPWR sky130_fd_sc_hd__decap_3
XFILLER_10_191 VGND VGND VPWR VPWR sky130_fd_sc_hd__decap_3
X_3440_ _5260_/Q _3442_/B _3440_/C VGND VGND VPWR VPWR _3440_/X sky130_fd_sc_hd__and3_2
X_3371_ _5145_/Q _5144_/Q _3371_/C VGND VGND VPWR VPWR _3371_/X sky130_fd_sc_hd__and3_2
XFILLER_33_3 VGND VGND VPWR VPWR sky130_fd_sc_hd__decap_3
X_5110_ _5112_/CLK _5110_/D VGND VGND VPWR VPWR _5110_/Q sky130_fd_sc_hd__dfxtp_2
XFILLER_88_80 VGND VGND VPWR VPWR sky130_fd_sc_hd__decap_3
X_5041_ _5134_/CLK _5041_/D VGND VGND VPWR VPWR _5041_/Q sky130_fd_sc_hd__dfxtp_2
XFILLER_69_169 VGND VGND VPWR VPWR sky130_fd_sc_hd__decap_3
XTAP_TAPCELL_ROW_68_849 VGND VPWR sky130_fd_sc_hd__tapvpwrvgnd_1
XFILLER_84_139 VGND VGND VPWR VPWR sky130_fd_sc_hd__fill_1
XFILLER_77_180 VGND VGND VPWR VPWR sky130_fd_sc_hd__decap_3
XFILLER_65_364 VGND VGND VPWR VPWR sky130_fd_sc_hd__decap_3
XFILLER_25_217 VGND VGND VPWR VPWR sky130_fd_sc_hd__decap_3
XFILLER_25_228 VGND VGND VPWR VPWR sky130_fd_sc_hd__decap_3
XFILLER_53_526 VGND VGND VPWR VPWR sky130_fd_sc_hd__decap_3
XFILLER_80_312 VGND VGND VPWR VPWR sky130_fd_sc_hd__decap_3
XFILLER_80_345 VGND VGND VPWR VPWR sky130_fd_sc_hd__fill_2
XTAP_TAPCELL_ROW_23_418 VGND VPWR sky130_fd_sc_hd__tapvpwrvgnd_1
X_4825_ _5242_/Q _4847_/B VGND VGND VPWR VPWR _4825_/X sky130_fd_sc_hd__or2_2
X_4756_ _4754_/X _4755_/Y _4714_/A VGND VGND VPWR VPWR _5233_/D sky130_fd_sc_hd__a21oi_2
XTAP_TAPCELL_ROW_31_495 VGND VPWR sky130_fd_sc_hd__tapvpwrvgnd_1
X_4687_ _4687_/A _4687_/B VGND VGND VPWR VPWR _4687_/Y sky130_fd_sc_hd__nand2_2
X_3707_ _5070_/Q _5054_/Q _5038_/Q _5022_/Q _3834_/S0 _3834_/S1 VGND VGND VPWR VPWR
+ _3707_/X sky130_fd_sc_hd__mux4_2
X_3638_ _4493_/B _4787_/S VGND VGND VPWR VPWR _4706_/A sky130_fd_sc_hd__or2_2
X_3569_ _3567_/Y _3569_/B VGND VGND VPWR VPWR _3570_/B sky130_fd_sc_hd__nand2b_2
XFILLER_88_412 VGND VGND VPWR VPWR sky130_fd_sc_hd__decap_3
XFILLER_48_309 VGND VGND VPWR VPWR sky130_fd_sc_hd__decap_3
X_5239_ _5241_/CLK _5239_/D VGND VGND VPWR VPWR _5239_/Q sky130_fd_sc_hd__dfxtp_2
XFILLER_88_489 VGND VGND VPWR VPWR sky130_fd_sc_hd__decap_3
XFILLER_29_545 VGND VGND VPWR VPWR sky130_fd_sc_hd__decap_3
XFILLER_75_128 VGND VGND VPWR VPWR sky130_fd_sc_hd__decap_3
XFILLER_84_27 VGND VGND VPWR VPWR sky130_fd_sc_hd__fill_1
XFILLER_44_526 VGND VGND VPWR VPWR sky130_fd_sc_hd__decap_3
XFILLER_56_386 VGND VGND VPWR VPWR sky130_fd_sc_hd__decap_3
XFILLER_71_312 VGND VGND VPWR VPWR sky130_fd_sc_hd__decap_3
XTAP_TAPCELL_ROW_39_573 VGND VPWR sky130_fd_sc_hd__tapvpwrvgnd_1
XFILLER_83_172 VGND VGND VPWR VPWR sky130_fd_sc_hd__decap_3
XFILLER_17_76 VGND VGND VPWR VPWR sky130_fd_sc_hd__decap_3
XFILLER_71_367 VGND VGND VPWR VPWR sky130_fd_sc_hd__decap_3
XFILLER_83_194 VGND VGND VPWR VPWR sky130_fd_sc_hd__decap_3
XFILLER_24_250 VGND VGND VPWR VPWR sky130_fd_sc_hd__fill_2
XFILLER_24_261 VGND VGND VPWR VPWR sky130_fd_sc_hd__fill_2
XFILLER_33_53 VGND VGND VPWR VPWR sky130_fd_sc_hd__decap_3
XFILLER_8_438 VGND VGND VPWR VPWR sky130_fd_sc_hd__decap_3
XFILLER_3_121 VGND VGND VPWR VPWR sky130_fd_sc_hd__fill_2
XFILLER_79_434 VGND VGND VPWR VPWR sky130_fd_sc_hd__decap_3
XFILLER_79_445 VGND VGND VPWR VPWR sky130_fd_sc_hd__decap_3
XTAP_TAPCELL_ROW_65_819 VGND VPWR sky130_fd_sc_hd__tapvpwrvgnd_1
XFILLER_35_548 VGND VGND VPWR VPWR sky130_fd_sc_hd__decap_3
XFILLER_47_375 VGND VGND VPWR VPWR sky130_fd_sc_hd__decap_3
XFILLER_62_312 VGND VGND VPWR VPWR sky130_fd_sc_hd__decap_3
XFILLER_74_161 VGND VGND VPWR VPWR sky130_fd_sc_hd__decap_3
X_2940_ _5236_/Q _4850_/A _3458_/B _5220_/Q VGND VGND VPWR VPWR _2940_/X sky130_fd_sc_hd__a22o_2
XTAP_TAPCELL_ROW_73_896 VGND VPWR sky130_fd_sc_hd__tapvpwrvgnd_1
X_2871_ _2887_/B _2871_/B VGND VGND VPWR VPWR _2871_/Y sky130_fd_sc_hd__nor2_2
X_4610_ _2573_/Y _3874_/D _4608_/Y _4609_/X VGND VGND VPWR VPWR _4610_/X sky130_fd_sc_hd__o211a_2
XFILLER_90_92 VGND VGND VPWR VPWR sky130_fd_sc_hd__decap_3
X_4541_ _4541_/A _4802_/A VGND VGND VPWR VPWR _4545_/A sky130_fd_sc_hd__nor2_2
X_4472_ _4551_/A _4532_/A _4588_/A VGND VGND VPWR VPWR _4614_/B sky130_fd_sc_hd__or3_2
Xmax_cap113 _3190_/Y VGND VGND VPWR VPWR _3203_/B1 sky130_fd_sc_hd__buf_6
Xmax_cap124 _3136_/B VGND VGND VPWR VPWR _3152_/A2 sky130_fd_sc_hd__buf_6
Xmax_cap135 _3098_/Y VGND VGND VPWR VPWR _3099_/B sky130_fd_sc_hd__buf_6
XFILLER_7_493 VGND VGND VPWR VPWR sky130_fd_sc_hd__decap_3
Xmax_cap146 _5124_/Q VGND VGND VPWR VPWR _2671_/S1 sky130_fd_sc_hd__buf_12
X_3423_ _5158_/Q _3227_/X _3422_/X VGND VGND VPWR VPWR _3424_/B sky130_fd_sc_hd__a21oi_2
X_3354_ _3353_/A _3353_/B _3361_/D VGND VGND VPWR VPWR _3355_/C sky130_fd_sc_hd__o21ai_2
X_3285_ _5137_/Q _5136_/Q _5135_/Q VGND VGND VPWR VPWR _3298_/B sky130_fd_sc_hd__and3_2
XFILLER_38_320 VGND VGND VPWR VPWR sky130_fd_sc_hd__decap_3
X_5024_ _5106_/CLK _5024_/D VGND VGND VPWR VPWR _5024_/Q sky130_fd_sc_hd__dfxtp_2
XTAP_TAPCELL_ROW_88_1040 VGND VPWR sky130_fd_sc_hd__tapvpwrvgnd_1
XFILLER_65_172 VGND VGND VPWR VPWR sky130_fd_sc_hd__decap_3
XFILLER_93_492 VGND VGND VPWR VPWR sky130_fd_sc_hd__decap_3
XFILLER_93_470 VGND VGND VPWR VPWR sky130_fd_sc_hd__decap_3
XTAP_TAPCELL_ROW_36_543 VGND VPWR sky130_fd_sc_hd__tapvpwrvgnd_1
XFILLER_80_131 VGND VGND VPWR VPWR sky130_fd_sc_hd__decap_3
XFILLER_13_209 VGND VGND VPWR VPWR sky130_fd_sc_hd__fill_2
XFILLER_53_367 VGND VGND VPWR VPWR sky130_fd_sc_hd__decap_3
XFILLER_80_164 VGND VGND VPWR VPWR sky130_fd_sc_hd__decap_3
XFILLER_80_197 VGND VGND VPWR VPWR sky130_fd_sc_hd__decap_3
XFILLER_70_29 VGND VGND VPWR VPWR sky130_fd_sc_hd__decap_3
X_4808_ _4716_/B _4371_/A _3779_/A _3457_/A VGND VGND VPWR VPWR _4808_/X sky130_fd_sc_hd__o2bb2a_2
XFILLER_5_419 VGND VGND VPWR VPWR sky130_fd_sc_hd__decap_3
X_4739_ _4587_/Y _4635_/Y _4738_/X _4786_/A VGND VGND VPWR VPWR _4739_/X sky130_fd_sc_hd__a22o_2
XFILLER_0_113 VGND VGND VPWR VPWR sky130_fd_sc_hd__decap_3
XTAP_TAPCELL_ROW_8_279 VGND VPWR sky130_fd_sc_hd__tapvpwrvgnd_1
XFILLER_48_106 VGND VGND VPWR VPWR sky130_fd_sc_hd__decap_3
XFILLER_88_253 VGND VGND VPWR VPWR sky130_fd_sc_hd__decap_3
XFILLER_88_297 VGND VGND VPWR VPWR sky130_fd_sc_hd__decap_3
XFILLER_91_407 VGND VGND VPWR VPWR sky130_fd_sc_hd__decap_3
XFILLER_29_386 VGND VGND VPWR VPWR sky130_fd_sc_hd__decap_3
XFILLER_44_301 VGND VGND VPWR VPWR sky130_fd_sc_hd__fill_2
XFILLER_44_312 VGND VGND VPWR VPWR sky130_fd_sc_hd__fill_2
XFILLER_56_161 VGND VGND VPWR VPWR sky130_fd_sc_hd__decap_3
XFILLER_56_183 VGND VGND VPWR VPWR sky130_fd_sc_hd__fill_2
XFILLER_91_429 VGND VGND VPWR VPWR sky130_fd_sc_hd__fill_1
XFILLER_84_492 VGND VGND VPWR VPWR sky130_fd_sc_hd__decap_3
XFILLER_44_334 VGND VGND VPWR VPWR sky130_fd_sc_hd__decap_3
XFILLER_44_356 VGND VGND VPWR VPWR sky130_fd_sc_hd__decap_3
XFILLER_56_194 VGND VGND VPWR VPWR sky130_fd_sc_hd__fill_2
XFILLER_44_389 VGND VGND VPWR VPWR sky130_fd_sc_hd__decap_3
XFILLER_44_41 VGND VGND VPWR VPWR sky130_fd_sc_hd__decap_3
XFILLER_44_85 VGND VGND VPWR VPWR sky130_fd_sc_hd__fill_1
XFILLER_71_197 VGND VGND VPWR VPWR sky130_fd_sc_hd__decap_3
XTAP_TAPCELL_ROW_70_866 VGND VPWR sky130_fd_sc_hd__tapvpwrvgnd_1
XFILLER_12_264 VGND VGND VPWR VPWR sky130_fd_sc_hd__decap_3
XFILLER_8_235 VGND VGND VPWR VPWR sky130_fd_sc_hd__fill_1
XFILLER_60_62 VGND VGND VPWR VPWR sky130_fd_sc_hd__decap_3
XFILLER_4_430 VGND VGND VPWR VPWR sky130_fd_sc_hd__decap_3
XFILLER_5_24 VGND VGND VPWR VPWR sky130_fd_sc_hd__fill_1
XFILLER_69_60 VGND VGND VPWR VPWR sky130_fd_sc_hd__decap_3
XFILLER_79_242 VGND VGND VPWR VPWR sky130_fd_sc_hd__decap_3
XFILLER_79_231 VGND VGND VPWR VPWR sky130_fd_sc_hd__fill_2
XFILLER_39_139 VGND VGND VPWR VPWR sky130_fd_sc_hd__decap_3
X_3070_ _2922_/X _3061_/B _3061_/Y _4987_/Q VGND VGND VPWR VPWR _4987_/D sky130_fd_sc_hd__a22o_2
XTAP_TAPCELL_ROW_78_944 VGND VPWR sky130_fd_sc_hd__tapvpwrvgnd_1
XFILLER_35_334 VGND VGND VPWR VPWR sky130_fd_sc_hd__fill_2
XFILLER_35_345 VGND VGND VPWR VPWR sky130_fd_sc_hd__decap_3
XFILLER_47_183 VGND VGND VPWR VPWR sky130_fd_sc_hd__decap_3
XFILLER_35_389 VGND VGND VPWR VPWR sky130_fd_sc_hd__decap_3
XFILLER_50_315 VGND VGND VPWR VPWR sky130_fd_sc_hd__decap_3
X_3972_ _3972_/A VGND VGND VPWR VPWR _3972_/Y sky130_fd_sc_hd__inv_2
XTAP_TAPCELL_ROW_33_513 VGND VPWR sky130_fd_sc_hd__tapvpwrvgnd_1
XFILLER_90_495 VGND VGND VPWR VPWR sky130_fd_sc_hd__fill_1
X_2923_ _4875_/Q _2897_/Y _2922_/X _2897_/B VGND VGND VPWR VPWR _4875_/D sky130_fd_sc_hd__a22o_2
X_2854_ _2887_/B _3875_/B VGND VGND VPWR VPWR _2854_/X sky130_fd_sc_hd__and2b_2
X_2785_ _4955_/Q _4939_/Q _4923_/Q _4907_/Q _5131_/Q _2848_/S1 VGND VGND VPWR VPWR
+ _2785_/X sky130_fd_sc_hd__mux4_2
XTAP_TAPCELL_ROW_41_590 VGND VPWR sky130_fd_sc_hd__tapvpwrvgnd_1
X_4524_ _4449_/B _4523_/S _4624_/A VGND VGND VPWR VPWR _4524_/X sky130_fd_sc_hd__o21ba_2
XFILLER_7_290 VGND VGND VPWR VPWR sky130_fd_sc_hd__decap_3
XFILLER_49_19 VGND VGND VPWR VPWR sky130_fd_sc_hd__decap_3
X_4455_ _4614_/A _4471_/B VGND VGND VPWR VPWR _4456_/B sky130_fd_sc_hd__nor2_2
X_4386_ _4432_/B _4385_/X _4479_/B VGND VGND VPWR VPWR _4386_/X sky130_fd_sc_hd__o21a_2
X_3406_ _3406_/A _3406_/B VGND VGND VPWR VPWR _3406_/X sky130_fd_sc_hd__xor2_2
X_3337_ _3337_/A _3337_/B VGND VGND VPWR VPWR _3337_/Y sky130_fd_sc_hd__nand2_2
XTAP_TAPCELL_ROW_5_249 VGND VPWR sky130_fd_sc_hd__tapvpwrvgnd_1
XFILLER_73_407 VGND VGND VPWR VPWR sky130_fd_sc_hd__decap_3
X_3268_ _5155_/Q _3269_/B VGND VGND VPWR VPWR _3270_/A sky130_fd_sc_hd__and2_2
XFILLER_26_312 VGND VGND VPWR VPWR sky130_fd_sc_hd__decap_3
X_5007_ _5007_/CLK _5007_/D VGND VGND VPWR VPWR _5007_/Q sky130_fd_sc_hd__dfxtp_2
X_3199_ _2922_/X _3190_/B _3190_/Y _5099_/Q VGND VGND VPWR VPWR _5099_/D sky130_fd_sc_hd__a22o_2
XFILLER_81_484 VGND VGND VPWR VPWR sky130_fd_sc_hd__fill_2
XFILLER_53_186 VGND VGND VPWR VPWR sky130_fd_sc_hd__decap_3
XFILLER_81_39 VGND VGND VPWR VPWR sky130_fd_sc_hd__decap_3
XFILLER_22_551 VGND VGND VPWR VPWR sky130_fd_sc_hd__fill_2
XFILLER_14_88 VGND VGND VPWR VPWR sky130_fd_sc_hd__decap_3
XFILLER_30_32 VGND VGND VPWR VPWR sky130_fd_sc_hd__decap_3
XFILLER_89_551 VGND VGND VPWR VPWR sky130_fd_sc_hd__fill_2
XFILLER_1_488 VGND VGND VPWR VPWR sky130_fd_sc_hd__decap_3
XFILLER_49_426 VGND VGND VPWR VPWR sky130_fd_sc_hd__decap_3
XFILLER_76_267 VGND VGND VPWR VPWR sky130_fd_sc_hd__decap_3
XFILLER_76_256 VGND VGND VPWR VPWR sky130_fd_sc_hd__decap_3
XFILLER_57_481 VGND VGND VPWR VPWR sky130_fd_sc_hd__decap_3
XTAP_TAPCELL_ROW_75_914 VGND VPWR sky130_fd_sc_hd__tapvpwrvgnd_1
XFILLER_17_334 VGND VGND VPWR VPWR sky130_fd_sc_hd__fill_2
XFILLER_55_40 VGND VGND VPWR VPWR sky130_fd_sc_hd__decap_3
XTAP_TAPCELL_ROW_47_649 VGND VPWR sky130_fd_sc_hd__tapvpwrvgnd_1
XFILLER_17_367 VGND VGND VPWR VPWR sky130_fd_sc_hd__decap_3
XFILLER_55_84 VGND VGND VPWR VPWR sky130_fd_sc_hd__decap_3
XFILLER_32_315 VGND VGND VPWR VPWR sky130_fd_sc_hd__decap_3
XFILLER_32_348 VGND VGND VPWR VPWR sky130_fd_sc_hd__decap_3
XFILLER_44_197 VGND VGND VPWR VPWR sky130_fd_sc_hd__fill_1
XFILLER_72_495 VGND VGND VPWR VPWR sky130_fd_sc_hd__decap_3
XTAP_TAPCELL_ROW_83_991 VGND VPWR sky130_fd_sc_hd__tapvpwrvgnd_1
XFILLER_71_50 VGND VGND VPWR VPWR sky130_fd_sc_hd__decap_3
XFILLER_40_370 VGND VGND VPWR VPWR sky130_fd_sc_hd__decap_3
XFILLER_9_522 VGND VGND VPWR VPWR sky130_fd_sc_hd__decap_3
X_2570_ _2568_/X _2569_/X _2667_/A VGND VGND VPWR VPWR _2570_/X sky130_fd_sc_hd__mux2_1
XTAP_TAPCELL_ROW_10_295 VGND VPWR sky130_fd_sc_hd__tapvpwrvgnd_1
XFILLER_4_271 VGND VGND VPWR VPWR sky130_fd_sc_hd__decap_3
X_4240_ _4195_/Y _4285_/D _4717_/S _4285_/C VGND VGND VPWR VPWR _4275_/C sky130_fd_sc_hd__a211o_2
X_4171_ _4171_/A _4473_/A VGND VGND VPWR VPWR _4172_/B sky130_fd_sc_hd__nor2_2
XFILLER_67_223 VGND VGND VPWR VPWR sky130_fd_sc_hd__fill_1
XFILLER_67_234 VGND VGND VPWR VPWR sky130_fd_sc_hd__decap_3
X_3122_ _2910_/X _3117_/B _3133_/B1 _5031_/Q VGND VGND VPWR VPWR _5031_/D sky130_fd_sc_hd__a22o_2
XTAP_TAPCELL_ROW_2_219 VGND VPWR sky130_fd_sc_hd__tapvpwrvgnd_1
XFILLER_55_429 VGND VGND VPWR VPWR sky130_fd_sc_hd__fill_1
XFILLER_67_278 VGND VGND VPWR VPWR sky130_fd_sc_hd__fill_2
X_3053_ _2926_/X _3056_/A2 _3043_/Y _4972_/Q VGND VGND VPWR VPWR _4972_/D sky130_fd_sc_hd__a22o_2
XTAP_TAPCELL_ROW_85_1010 VGND VPWR sky130_fd_sc_hd__tapvpwrvgnd_1
XFILLER_82_237 VGND VGND VPWR VPWR sky130_fd_sc_hd__decap_3
XFILLER_35_142 VGND VGND VPWR VPWR sky130_fd_sc_hd__decap_3
XFILLER_23_315 VGND VGND VPWR VPWR sky130_fd_sc_hd__decap_3
XFILLER_23_337 VGND VGND VPWR VPWR sky130_fd_sc_hd__decap_3
XFILLER_35_197 VGND VGND VPWR VPWR sky130_fd_sc_hd__decap_3
XTAP_TAPCELL_ROW_18_373 VGND VPWR sky130_fd_sc_hd__tapvpwrvgnd_1
X_3955_ _4551_/A _4787_/S VGND VGND VPWR VPWR _3955_/Y sky130_fd_sc_hd__nand2b_2
XFILLER_50_178 VGND VGND VPWR VPWR sky130_fd_sc_hd__decap_3
X_2906_ _5193_/Q _2455_/X _3456_/B _5241_/Q _2905_/X VGND VGND VPWR VPWR _2906_/X
+ sky130_fd_sc_hd__a221o_2
X_3886_ _3934_/B _3886_/B VGND VGND VPWR VPWR _3886_/Y sky130_fd_sc_hd__nor2_2
X_2837_ _5121_/Q _5009_/Q _4993_/Q _4977_/Q _5131_/Q _5132_/Q VGND VGND VPWR VPWR
+ _2838_/B sky130_fd_sc_hd__mux4_2
X_2768_ _2831_/S _2767_/X _2437_/Y VGND VGND VPWR VPWR _2768_/X sky130_fd_sc_hd__o21a_2
X_4507_ _4567_/B _4507_/B VGND VGND VPWR VPWR _4510_/A sky130_fd_sc_hd__nor2_2
X_2699_ _4115_/A _2701_/B VGND VGND VPWR VPWR _2699_/Y sky130_fd_sc_hd__nor2_2
X_4438_ _4464_/B _4466_/A VGND VGND VPWR VPWR _4497_/B sky130_fd_sc_hd__or2_2
XFILLER_58_223 VGND VGND VPWR VPWR sky130_fd_sc_hd__fill_1
X_4369_ _4369_/A _4369_/B VGND VGND VPWR VPWR _4373_/C sky130_fd_sc_hd__nand2_2
XFILLER_39_470 VGND VGND VPWR VPWR sky130_fd_sc_hd__fill_1
XFILLER_73_215 VGND VGND VPWR VPWR sky130_fd_sc_hd__decap_3
XFILLER_73_237 VGND VGND VPWR VPWR sky130_fd_sc_hd__decap_3
XFILLER_73_259 VGND VGND VPWR VPWR sky130_fd_sc_hd__decap_3
XFILLER_14_304 VGND VGND VPWR VPWR sky130_fd_sc_hd__decap_3
XFILLER_26_164 VGND VGND VPWR VPWR sky130_fd_sc_hd__decap_3
XFILLER_54_451 VGND VGND VPWR VPWR sky130_fd_sc_hd__decap_3
XTAP_TAPCELL_ROW_44_619 VGND VPWR sky130_fd_sc_hd__tapvpwrvgnd_1
XFILLER_92_38 VGND VGND VPWR VPWR sky130_fd_sc_hd__decap_3
XFILLER_14_315 VGND VGND VPWR VPWR sky130_fd_sc_hd__fill_2
XFILLER_26_197 VGND VGND VPWR VPWR sky130_fd_sc_hd__fill_1
XFILLER_81_281 VGND VGND VPWR VPWR sky130_fd_sc_hd__decap_3
XFILLER_81_270 VGND VGND VPWR VPWR sky130_fd_sc_hd__decap_3
XFILLER_25_76 VGND VGND VPWR VPWR sky130_fd_sc_hd__fill_1
XFILLER_41_156 VGND VGND VPWR VPWR sky130_fd_sc_hd__fill_1
XTAP_TAPCELL_ROW_80_961 VGND VPWR sky130_fd_sc_hd__tapvpwrvgnd_1
XFILLER_41_189 VGND VGND VPWR VPWR sky130_fd_sc_hd__fill_1
XTAP_TAPCELL_ROW_52_696 VGND VPWR sky130_fd_sc_hd__tapvpwrvgnd_1
XFILLER_22_392 VGND VGND VPWR VPWR sky130_fd_sc_hd__decap_3
XFILLER_89_381 VGND VGND VPWR VPWR sky130_fd_sc_hd__decap_3
XFILLER_49_234 VGND VGND VPWR VPWR sky130_fd_sc_hd__fill_2
XFILLER_49_256 VGND VGND VPWR VPWR sky130_fd_sc_hd__decap_3
XFILLER_37_407 VGND VGND VPWR VPWR sky130_fd_sc_hd__decap_3
XFILLER_49_267 VGND VGND VPWR VPWR sky130_fd_sc_hd__decap_3
XFILLER_92_524 VGND VGND VPWR VPWR sky130_fd_sc_hd__decap_3
XFILLER_64_259 VGND VGND VPWR VPWR sky130_fd_sc_hd__fill_2
XFILLER_45_440 VGND VGND VPWR VPWR sky130_fd_sc_hd__decap_3
XFILLER_45_484 VGND VGND VPWR VPWR sky130_fd_sc_hd__decap_3
XFILLER_60_421 VGND VGND VPWR VPWR sky130_fd_sc_hd__decap_3
XFILLER_72_270 VGND VGND VPWR VPWR sky130_fd_sc_hd__decap_3
XFILLER_60_454 VGND VGND VPWR VPWR sky130_fd_sc_hd__decap_3
XTAP_TAPCELL_ROW_15_343 VGND VPWR sky130_fd_sc_hd__tapvpwrvgnd_1
XFILLER_32_167 VGND VGND VPWR VPWR sky130_fd_sc_hd__decap_3
X_3740_ _3734_/X _3736_/X _3739_/X _2432_/Y VGND VGND VPWR VPWR _3742_/B sky130_fd_sc_hd__a22o_2
X_3671_ _3670_/X _3669_/X _4077_/S VGND VGND VPWR VPWR _3671_/X sky130_fd_sc_hd__mux2_1
X_2622_ _5159_/Q _4464_/A VGND VGND VPWR VPWR _2622_/Y sky130_fd_sc_hd__nand2b_2
Xoutput104 _2770_/X VGND VGND VPWR VPWR MEM_STR_DATA[6] sky130_fd_sc_hd__clkdlybuf4s25_1
X_2553_ _5125_/Q _2550_/X _5126_/Q VGND VGND VPWR VPWR _2553_/X sky130_fd_sc_hd__o21a_2
X_2484_ _4961_/Q _4945_/Q _4929_/Q _4913_/Q _5123_/Q _2671_/S1 VGND VGND VPWR VPWR
+ _2484_/X sky130_fd_sc_hd__mux4_2
X_4223_ _4223_/A _4223_/B _4223_/C VGND VGND VPWR VPWR _4224_/C sky130_fd_sc_hd__nor3_2
XFILLER_87_329 VGND VGND VPWR VPWR sky130_fd_sc_hd__decap_3
X_4154_ _4046_/B _4153_/Y _4339_/A VGND VGND VPWR VPWR _4155_/B sky130_fd_sc_hd__mux2_1
XFILLER_28_418 VGND VGND VPWR VPWR sky130_fd_sc_hd__fill_2
X_4085_ _3876_/A _3930_/Y _4224_/A _4084_/X VGND VGND VPWR VPWR _4085_/X sky130_fd_sc_hd__o31a_2
X_3105_ _2913_/X _3099_/B _3099_/Y _5016_/Q VGND VGND VPWR VPWR _5016_/D sky130_fd_sc_hd__a22o_2
X_3036_ _2932_/X _3024_/B _3024_/Y _4958_/Q VGND VGND VPWR VPWR _4958_/D sky130_fd_sc_hd__a22o_2
XFILLER_83_546 VGND VGND VPWR VPWR sky130_fd_sc_hd__decap_3
XFILLER_36_440 VGND VGND VPWR VPWR sky130_fd_sc_hd__fill_1
XFILLER_23_101 VGND VGND VPWR VPWR sky130_fd_sc_hd__decap_3
XFILLER_51_410 VGND VGND VPWR VPWR sky130_fd_sc_hd__decap_3
XFILLER_63_281 VGND VGND VPWR VPWR sky130_fd_sc_hd__fill_1
XFILLER_11_307 VGND VGND VPWR VPWR sky130_fd_sc_hd__decap_3
XFILLER_23_178 VGND VGND VPWR VPWR sky130_fd_sc_hd__decap_3
XFILLER_51_476 VGND VGND VPWR VPWR sky130_fd_sc_hd__decap_3
X_4987_ _5121_/CLK _4987_/D VGND VGND VPWR VPWR _4987_/Q sky130_fd_sc_hd__dfxtp_2
X_3938_ _5158_/Q _3923_/B _3873_/B _2622_/Y VGND VGND VPWR VPWR _3940_/B sky130_fd_sc_hd__o31a_2
X_3869_ _5176_/Q _3999_/B VGND VGND VPWR VPWR _3869_/Y sky130_fd_sc_hd__nor2_2
XFILLER_11_45 VGND VGND VPWR VPWR sky130_fd_sc_hd__decap_3
XFILLER_11_89 VGND VGND VPWR VPWR sky130_fd_sc_hd__decap_3
XFILLER_87_49 VGND VGND VPWR VPWR sky130_fd_sc_hd__decap_3
XFILLER_87_27 VGND VGND VPWR VPWR sky130_fd_sc_hd__decap_3
XFILLER_78_318 VGND VGND VPWR VPWR sky130_fd_sc_hd__decap_3
XFILLER_78_307 VGND VGND VPWR VPWR sky130_fd_sc_hd__fill_1
XFILLER_19_418 VGND VGND VPWR VPWR sky130_fd_sc_hd__decap_3
XFILLER_46_215 VGND VGND VPWR VPWR sky130_fd_sc_hd__decap_3
XFILLER_86_351 VGND VGND VPWR VPWR sky130_fd_sc_hd__decap_3
XFILLER_46_248 VGND VGND VPWR VPWR sky130_fd_sc_hd__decap_3
XFILLER_74_546 VGND VGND VPWR VPWR sky130_fd_sc_hd__decap_3
XTAP_TAPCELL_ROW_57_744 VGND VPWR sky130_fd_sc_hd__tapvpwrvgnd_1
XFILLER_46_259 VGND VGND VPWR VPWR sky130_fd_sc_hd__decap_3
XFILLER_61_207 VGND VGND VPWR VPWR sky130_fd_sc_hd__decap_3
XTAP_TAPCELL_ROW_29_479 VGND VPWR sky130_fd_sc_hd__tapvpwrvgnd_1
XFILLER_27_484 VGND VGND VPWR VPWR sky130_fd_sc_hd__decap_3
XFILLER_42_421 VGND VGND VPWR VPWR sky130_fd_sc_hd__decap_3
XFILLER_54_292 VGND VGND VPWR VPWR sky130_fd_sc_hd__fill_2
XFILLER_42_487 VGND VGND VPWR VPWR sky130_fd_sc_hd__decap_3
XFILLER_52_41 VGND VGND VPWR VPWR sky130_fd_sc_hd__decap_3
XFILLER_52_63 VGND VGND VPWR VPWR sky130_fd_sc_hd__fill_1
XFILLER_52_85 VGND VGND VPWR VPWR sky130_fd_sc_hd__decap_3
XTAP_TAPCELL_ROW_12_313 VGND VPWR sky130_fd_sc_hd__tapvpwrvgnd_1
Xinput28 INSTR_STREAM[5] VGND VGND VPWR VPWR _3420_/C sky130_fd_sc_hd__clkdlybuf4s25_1
Xinput17 INSTR_STREAM[24] VGND VGND VPWR VPWR _3436_/C sky130_fd_sc_hd__clkdlybuf4s25_1
XFILLER_10_395 VGND VGND VPWR VPWR sky130_fd_sc_hd__decap_3
XFILLER_6_344 VGND VGND VPWR VPWR sky130_fd_sc_hd__decap_3
Xinput39 MEM_LD_DATA[15] VGND VGND VPWR VPWR input39/X sky130_fd_sc_hd__clkdlybuf4s25_1
XTAP_TAPCELL_ROW_20_390 VGND VPWR sky130_fd_sc_hd__tapvpwrvgnd_1
XFILLER_28_6 VGND VGND VPWR VPWR sky130_fd_sc_hd__fill_1
XFILLER_77_340 VGND VGND VPWR VPWR sky130_fd_sc_hd__decap_3
XFILLER_77_93 VGND VGND VPWR VPWR sky130_fd_sc_hd__decap_3
XFILLER_77_384 VGND VGND VPWR VPWR sky130_fd_sc_hd__decap_3
XFILLER_37_237 VGND VGND VPWR VPWR sky130_fd_sc_hd__decap_3
XFILLER_92_343 VGND VGND VPWR VPWR sky130_fd_sc_hd__decap_3
XFILLER_45_281 VGND VGND VPWR VPWR sky130_fd_sc_hd__decap_3
X_4910_ _5116_/CLK _4910_/D VGND VGND VPWR VPWR _4910_/Q sky130_fd_sc_hd__dfxtp_2
XFILLER_92_398 VGND VGND VPWR VPWR sky130_fd_sc_hd__decap_3
XFILLER_33_443 VGND VGND VPWR VPWR sky130_fd_sc_hd__decap_3
X_4841_ _5250_/Q _4847_/B VGND VGND VPWR VPWR _4841_/X sky130_fd_sc_hd__or2_2
XFILLER_60_251 VGND VGND VPWR VPWR sky130_fd_sc_hd__fill_1
XFILLER_33_498 VGND VGND VPWR VPWR sky130_fd_sc_hd__fill_1
X_4772_ _5235_/Q _4800_/B VGND VGND VPWR VPWR _4772_/Y sky130_fd_sc_hd__nand2_2
X_3723_ _3717_/X _3719_/X _3722_/X _2432_/Y VGND VGND VPWR VPWR _3882_/B sky130_fd_sc_hd__a22o_2
X_3654_ _5153_/Q _4405_/A _4547_/A VGND VGND VPWR VPWR _4077_/S sky130_fd_sc_hd__mux2_1
X_2605_ _5153_/Q _4449_/B VGND VGND VPWR VPWR _4547_/B sky130_fd_sc_hd__nor2_2
X_3585_ _3585_/A _3585_/B _3584_/X VGND VGND VPWR VPWR _3585_/X sky130_fd_sc_hd__or3b_2
X_2536_ _5158_/Q _4464_/B VGND VGND VPWR VPWR _2621_/A sky130_fd_sc_hd__nand2_2
X_5255_ clkload7/A _5255_/D VGND VGND VPWR VPWR _5255_/Q sky130_fd_sc_hd__dfxtp_2
X_2467_ _5262_/Q _3442_/B VGND VGND VPWR VPWR _5258_/D sky130_fd_sc_hd__and2_2
X_4206_ _3864_/B _4297_/A _4200_/Y _4205_/X _4155_/A VGND VGND VPWR VPWR _4712_/A
+ sky130_fd_sc_hd__o32a_2
XFILLER_87_159 VGND VGND VPWR VPWR sky130_fd_sc_hd__decap_3
XFILLER_56_513 VGND VGND VPWR VPWR sky130_fd_sc_hd__decap_3
X_5186_ clkload7/A _5186_/D VGND VGND VPWR VPWR _5186_/Q sky130_fd_sc_hd__dfxtp_2
XFILLER_28_248 VGND VGND VPWR VPWR sky130_fd_sc_hd__decap_3
X_4137_ _3934_/C _4000_/X _4135_/X _4850_/B VGND VGND VPWR VPWR _4137_/X sky130_fd_sc_hd__a211o_2
XFILLER_83_332 VGND VGND VPWR VPWR sky130_fd_sc_hd__decap_3
XFILLER_83_310 VGND VGND VPWR VPWR sky130_fd_sc_hd__decap_3
XFILLER_28_259 VGND VGND VPWR VPWR sky130_fd_sc_hd__decap_3
XFILLER_71_505 VGND VGND VPWR VPWR sky130_fd_sc_hd__decap_3
X_4068_ _4445_/A _4523_/S _4067_/Y VGND VGND VPWR VPWR _4068_/Y sky130_fd_sc_hd__o21ai_2
XFILLER_83_354 VGND VGND VPWR VPWR sky130_fd_sc_hd__fill_2
XFILLER_24_421 VGND VGND VPWR VPWR sky130_fd_sc_hd__decap_3
XFILLER_43_218 VGND VGND VPWR VPWR sky130_fd_sc_hd__decap_3
XFILLER_71_549 VGND VGND VPWR VPWR sky130_fd_sc_hd__decap_3
X_3019_ _2935_/X _3006_/B _3006_/Y _4943_/Q VGND VGND VPWR VPWR _4943_/D sky130_fd_sc_hd__a22o_2
XTAP_TAPCELL_ROW_54_714 VGND VPWR sky130_fd_sc_hd__tapvpwrvgnd_1
XFILLER_36_292 VGND VGND VPWR VPWR sky130_fd_sc_hd__decap_3
XTAP_TAPCELL_ROW_26_449 VGND VPWR sky130_fd_sc_hd__tapvpwrvgnd_1
XFILLER_51_284 VGND VGND VPWR VPWR sky130_fd_sc_hd__decap_3
XTAP_TAPCELL_ROW_62_791 VGND VPWR sky130_fd_sc_hd__tapvpwrvgnd_1
XFILLER_11_159 VGND VGND VPWR VPWR sky130_fd_sc_hd__decap_3
XFILLER_22_77 VGND VGND VPWR VPWR sky130_fd_sc_hd__decap_3
XFILLER_78_126 VGND VGND VPWR VPWR sky130_fd_sc_hd__decap_3
XFILLER_59_340 VGND VGND VPWR VPWR sky130_fd_sc_hd__decap_3
XFILLER_19_237 VGND VGND VPWR VPWR sky130_fd_sc_hd__decap_3
XFILLER_47_52 VGND VGND VPWR VPWR sky130_fd_sc_hd__decap_3
XFILLER_47_63 VGND VGND VPWR VPWR sky130_fd_sc_hd__decap_3
XFILLER_86_170 VGND VGND VPWR VPWR sky130_fd_sc_hd__fill_2
XFILLER_47_96 VGND VGND VPWR VPWR sky130_fd_sc_hd__decap_3
XFILLER_74_365 VGND VGND VPWR VPWR sky130_fd_sc_hd__decap_3
XFILLER_62_527 VGND VGND VPWR VPWR sky130_fd_sc_hd__decap_3
XFILLER_27_281 VGND VGND VPWR VPWR sky130_fd_sc_hd__fill_1
XFILLER_63_51 VGND VGND VPWR VPWR sky130_fd_sc_hd__decap_3
XFILLER_15_487 VGND VGND VPWR VPWR sky130_fd_sc_hd__decap_3
XFILLER_30_435 VGND VGND VPWR VPWR sky130_fd_sc_hd__fill_2
XFILLER_42_284 VGND VGND VPWR VPWR sky130_fd_sc_hd__decap_3
XFILLER_6_174 VGND VGND VPWR VPWR sky130_fd_sc_hd__decap_3
X_3370_ _5145_/Q _3380_/C VGND VGND VPWR VPWR _3370_/Y sky130_fd_sc_hd__nor2_2
X_5040_ _5134_/CLK _5040_/D VGND VGND VPWR VPWR _5040_/Q sky130_fd_sc_hd__dfxtp_2
XFILLER_26_3 VGND VGND VPWR VPWR sky130_fd_sc_hd__decap_3
XFILLER_38_513 VGND VGND VPWR VPWR sky130_fd_sc_hd__decap_3
XFILLER_53_505 VGND VGND VPWR VPWR sky130_fd_sc_hd__decap_3
XFILLER_65_343 VGND VGND VPWR VPWR sky130_fd_sc_hd__decap_3
XFILLER_53_538 VGND VGND VPWR VPWR sky130_fd_sc_hd__decap_3
XFILLER_80_368 VGND VGND VPWR VPWR sky130_fd_sc_hd__decap_3
XFILLER_80_357 VGND VGND VPWR VPWR sky130_fd_sc_hd__decap_3
XFILLER_33_251 VGND VGND VPWR VPWR sky130_fd_sc_hd__decap_3
XTAP_TAPCELL_ROW_23_419 VGND VPWR sky130_fd_sc_hd__tapvpwrvgnd_1
X_4824_ input42/X _4816_/Y _4823_/X _3448_/B VGND VGND VPWR VPWR _5241_/D sky130_fd_sc_hd__o211a_2
XFILLER_21_479 VGND VGND VPWR VPWR sky130_fd_sc_hd__fill_1
X_4755_ _5233_/Q _4800_/B VGND VGND VPWR VPWR _4755_/Y sky130_fd_sc_hd__nand2_2
X_3706_ _5129_/Q _3706_/B VGND VGND VPWR VPWR _3706_/X sky130_fd_sc_hd__or2_2
X_4686_ _4625_/Y _4618_/X _4686_/S VGND VGND VPWR VPWR _4687_/B sky130_fd_sc_hd__mux2_1
XTAP_TAPCELL_ROW_31_496 VGND VPWR sky130_fd_sc_hd__tapvpwrvgnd_1
X_3637_ _3631_/Y _4108_/A _4107_/B VGND VGND VPWR VPWR _4208_/A sky130_fd_sc_hd__mux2_1
X_3568_ _5165_/Q _5146_/Q VGND VGND VPWR VPWR _3569_/B sky130_fd_sc_hd__nand2_2
XFILLER_0_306 VGND VGND VPWR VPWR sky130_fd_sc_hd__fill_2
XFILLER_0_328 VGND VGND VPWR VPWR sky130_fd_sc_hd__decap_3
XFILLER_68_29 VGND VGND VPWR VPWR sky130_fd_sc_hd__decap_3
X_2519_ _5066_/Q _5050_/Q _5034_/Q _5018_/Q _2658_/S0 _2671_/S1 VGND VGND VPWR VPWR
+ _2519_/X sky130_fd_sc_hd__mux4_2
X_3499_ _5156_/Q _5137_/Q VGND VGND VPWR VPWR _3499_/X sky130_fd_sc_hd__and2_2
XFILLER_88_446 VGND VGND VPWR VPWR sky130_fd_sc_hd__decap_3
X_5238_ clkload7/A _5238_/D VGND VGND VPWR VPWR _5238_/Q sky130_fd_sc_hd__dfxtp_2
XFILLER_56_321 VGND VGND VPWR VPWR sky130_fd_sc_hd__decap_3
X_5169_ clkload4/A _5169_/D VGND VGND VPWR VPWR _5169_/Q sky130_fd_sc_hd__dfxtp_2
XFILLER_56_365 VGND VGND VPWR VPWR sky130_fd_sc_hd__decap_3
XFILLER_68_192 VGND VGND VPWR VPWR sky130_fd_sc_hd__decap_3
XFILLER_83_140 VGND VGND VPWR VPWR sky130_fd_sc_hd__decap_3
XFILLER_56_398 VGND VGND VPWR VPWR sky130_fd_sc_hd__decap_3
XTAP_TAPCELL_ROW_39_574 VGND VPWR sky130_fd_sc_hd__tapvpwrvgnd_1
XFILLER_83_184 VGND VGND VPWR VPWR sky130_fd_sc_hd__fill_1
XFILLER_17_88 VGND VGND VPWR VPWR sky130_fd_sc_hd__decap_3
XFILLER_44_549 VGND VGND VPWR VPWR sky130_fd_sc_hd__decap_3
XFILLER_71_346 VGND VGND VPWR VPWR sky130_fd_sc_hd__decap_3
XFILLER_71_379 VGND VGND VPWR VPWR sky130_fd_sc_hd__decap_3
XFILLER_24_273 VGND VGND VPWR VPWR sky130_fd_sc_hd__decap_3
XFILLER_79_402 VGND VGND VPWR VPWR sky130_fd_sc_hd__decap_3
XFILLER_59_181 VGND VGND VPWR VPWR sky130_fd_sc_hd__decap_3
XFILLER_35_505 VGND VGND VPWR VPWR sky130_fd_sc_hd__decap_3
XFILLER_47_354 VGND VGND VPWR VPWR sky130_fd_sc_hd__decap_3
XFILLER_47_387 VGND VGND VPWR VPWR sky130_fd_sc_hd__decap_3
XFILLER_74_173 VGND VGND VPWR VPWR sky130_fd_sc_hd__decap_3
XFILLER_62_346 VGND VGND VPWR VPWR sky130_fd_sc_hd__decap_3
XFILLER_50_508 VGND VGND VPWR VPWR sky130_fd_sc_hd__decap_3
XFILLER_62_368 VGND VGND VPWR VPWR sky130_fd_sc_hd__decap_3
XTAP_TAPCELL_ROW_73_897 VGND VPWR sky130_fd_sc_hd__tapvpwrvgnd_1
X_2870_ _2870_/A _3682_/B VGND VGND VPWR VPWR _2871_/B sky130_fd_sc_hd__xnor2_2
XFILLER_30_276 VGND VGND VPWR VPWR sky130_fd_sc_hd__decap_3
X_4540_ _4406_/Y _4407_/X _4542_/S VGND VGND VPWR VPWR _4802_/A sky130_fd_sc_hd__mux2_1
X_4471_ _4471_/A _4471_/B VGND VGND VPWR VPWR _4588_/A sky130_fd_sc_hd__or2_2
Xmax_cap114 _3154_/Y VGND VGND VPWR VPWR _3170_/B1 sky130_fd_sc_hd__buf_6
Xmax_cap125 _3116_/Y VGND VGND VPWR VPWR _3117_/B sky130_fd_sc_hd__buf_6
Xmax_cap136 _3043_/B VGND VGND VPWR VPWR _3056_/A2 sky130_fd_sc_hd__buf_6
Xmax_cap147 _5123_/Q VGND VGND VPWR VPWR _2658_/S0 sky130_fd_sc_hd__buf_12
X_3422_ _5260_/Q _3422_/B _3429_/C VGND VGND VPWR VPWR _3422_/X sky130_fd_sc_hd__and3_2
X_3353_ _3353_/A _3353_/B _3361_/D VGND VGND VPWR VPWR _3355_/B sky130_fd_sc_hd__or3_2
X_3284_ _3283_/A _3283_/B _5185_/Q VGND VGND VPWR VPWR _3284_/Y sky130_fd_sc_hd__o21ai_2
XFILLER_85_405 VGND VGND VPWR VPWR sky130_fd_sc_hd__decap_3
X_5023_ _5092_/CLK _5023_/D VGND VGND VPWR VPWR _5023_/Q sky130_fd_sc_hd__dfxtp_2
XFILLER_85_449 VGND VGND VPWR VPWR sky130_fd_sc_hd__decap_3
XFILLER_85_438 VGND VGND VPWR VPWR sky130_fd_sc_hd__decap_3
XFILLER_78_490 VGND VGND VPWR VPWR sky130_fd_sc_hd__fill_1
XFILLER_38_332 VGND VGND VPWR VPWR sky130_fd_sc_hd__decap_3
XFILLER_38_354 VGND VGND VPWR VPWR sky130_fd_sc_hd__decap_3
XTAP_TAPCELL_ROW_88_1041 VGND VPWR sky130_fd_sc_hd__tapvpwrvgnd_1
XFILLER_38_365 VGND VGND VPWR VPWR sky130_fd_sc_hd__decap_3
XFILLER_53_346 VGND VGND VPWR VPWR sky130_fd_sc_hd__decap_3
XFILLER_65_184 VGND VGND VPWR VPWR sky130_fd_sc_hd__decap_3
XTAP_TAPCELL_ROW_36_544 VGND VPWR sky130_fd_sc_hd__tapvpwrvgnd_1
XFILLER_0_91 VGND VGND VPWR VPWR sky130_fd_sc_hd__decap_3
XFILLER_41_519 VGND VGND VPWR VPWR sky130_fd_sc_hd__decap_3
XFILLER_61_390 VGND VGND VPWR VPWR sky130_fd_sc_hd__fill_2
X_4807_ _4115_/A _4614_/A _4224_/A VGND VGND VPWR VPWR _4807_/X sky130_fd_sc_hd__o21a_2
XPHY_EDGE_ROW_3_Right_3 VGND VGND VPWR VPWR sky130_fd_sc_hd__decap_3
X_2999_ _2932_/X _2987_/B _2987_/Y _4926_/Q VGND VGND VPWR VPWR _4926_/D sky130_fd_sc_hd__a22o_2
X_4738_ _4737_/X _4676_/X _4804_/A VGND VGND VPWR VPWR _4738_/X sky130_fd_sc_hd__mux2_1
X_4669_ _4653_/Y _4668_/X _4866_/A VGND VGND VPWR VPWR _5227_/D sky130_fd_sc_hd__a21oi_2
XFILLER_0_136 VGND VGND VPWR VPWR sky130_fd_sc_hd__decap_3
XFILLER_88_232 VGND VGND VPWR VPWR sky130_fd_sc_hd__decap_3
XFILLER_0_147 VGND VGND VPWR VPWR sky130_fd_sc_hd__decap_3
XFILLER_0_169 VGND VGND VPWR VPWR sky130_fd_sc_hd__decap_3
XFILLER_88_265 VGND VGND VPWR VPWR sky130_fd_sc_hd__fill_2
XFILLER_76_416 VGND VGND VPWR VPWR sky130_fd_sc_hd__decap_3
XFILLER_28_32 VGND VGND VPWR VPWR sky130_fd_sc_hd__decap_3
XFILLER_48_118 VGND VGND VPWR VPWR sky130_fd_sc_hd__fill_2
XFILLER_76_449 VGND VGND VPWR VPWR sky130_fd_sc_hd__fill_1
XFILLER_28_65 VGND VGND VPWR VPWR sky130_fd_sc_hd__decap_3
XFILLER_28_98 VGND VGND VPWR VPWR sky130_fd_sc_hd__decap_3
XFILLER_91_419 VGND VGND VPWR VPWR sky130_fd_sc_hd__decap_3
XFILLER_84_471 VGND VGND VPWR VPWR sky130_fd_sc_hd__decap_3
XFILLER_32_508 VGND VGND VPWR VPWR sky130_fd_sc_hd__decap_3
XFILLER_44_368 VGND VGND VPWR VPWR sky130_fd_sc_hd__decap_3
XFILLER_71_154 VGND VGND VPWR VPWR sky130_fd_sc_hd__decap_3
XFILLER_12_210 VGND VGND VPWR VPWR sky130_fd_sc_hd__decap_3
XFILLER_40_530 VGND VGND VPWR VPWR sky130_fd_sc_hd__fill_2
XTAP_TAPCELL_ROW_70_867 VGND VPWR sky130_fd_sc_hd__tapvpwrvgnd_1
XFILLER_60_41 VGND VGND VPWR VPWR sky130_fd_sc_hd__fill_2
XFILLER_60_74 VGND VGND VPWR VPWR sky130_fd_sc_hd__decap_3
XFILLER_60_96 VGND VGND VPWR VPWR sky130_fd_sc_hd__decap_3
XFILLER_4_442 VGND VGND VPWR VPWR sky130_fd_sc_hd__decap_3
XFILLER_4_486 VGND VGND VPWR VPWR sky130_fd_sc_hd__decap_3
XFILLER_69_72 VGND VGND VPWR VPWR sky130_fd_sc_hd__fill_1
XFILLER_79_221 VGND VGND VPWR VPWR sky130_fd_sc_hd__decap_3
XFILLER_67_405 VGND VGND VPWR VPWR sky130_fd_sc_hd__decap_3
XFILLER_67_438 VGND VGND VPWR VPWR sky130_fd_sc_hd__decap_3
XTAP_TAPCELL_ROW_78_945 VGND VPWR sky130_fd_sc_hd__tapvpwrvgnd_1
XFILLER_79_287 VGND VGND VPWR VPWR sky130_fd_sc_hd__decap_3
XFILLER_10_6 VGND VGND VPWR VPWR sky130_fd_sc_hd__decap_3
XFILLER_35_302 VGND VGND VPWR VPWR sky130_fd_sc_hd__decap_3
XFILLER_47_151 VGND VGND VPWR VPWR sky130_fd_sc_hd__decap_3
XFILLER_85_82 VGND VGND VPWR VPWR sky130_fd_sc_hd__decap_3
XFILLER_75_482 VGND VGND VPWR VPWR sky130_fd_sc_hd__decap_3
XFILLER_23_508 VGND VGND VPWR VPWR sky130_fd_sc_hd__decap_3
X_3971_ _4493_/A _3934_/B _4010_/S VGND VGND VPWR VPWR _3972_/A sky130_fd_sc_hd__mux2_1
XFILLER_50_327 VGND VGND VPWR VPWR sky130_fd_sc_hd__decap_3
XFILLER_50_349 VGND VGND VPWR VPWR sky130_fd_sc_hd__decap_3
X_2922_ _5198_/Q _2455_/X _3456_/B _5246_/Q _2921_/X VGND VGND VPWR VPWR _2922_/X
+ sky130_fd_sc_hd__a221o_2
XTAP_TAPCELL_ROW_33_514 VGND VPWR sky130_fd_sc_hd__tapvpwrvgnd_1
XFILLER_93_3 VGND VGND VPWR VPWR sky130_fd_sc_hd__decap_3
X_2853_ _2855_/A _2853_/B VGND VGND VPWR VPWR _3875_/B sky130_fd_sc_hd__nor2_2
X_2784_ _5133_/Q _2784_/B VGND VGND VPWR VPWR _2784_/X sky130_fd_sc_hd__or2_2
XTAP_TAPCELL_ROW_41_591 VGND VPWR sky130_fd_sc_hd__tapvpwrvgnd_1
X_4523_ _4445_/A _4466_/B _4523_/S VGND VGND VPWR VPWR _4622_/B sky130_fd_sc_hd__mux2_1
X_4454_ _4614_/A _4471_/B VGND VGND VPWR VPWR _4489_/A sky130_fd_sc_hd__nand2_2
X_4385_ _4477_/A _4384_/X _4249_/A VGND VGND VPWR VPWR _4385_/X sky130_fd_sc_hd__o21a_2
X_3405_ _3265_/Y _3403_/X _3404_/X _3448_/B VGND VGND VPWR VPWR _5149_/D sky130_fd_sc_hd__o211a_2
X_3336_ _5142_/Q _3347_/C VGND VGND VPWR VPWR _3337_/B sky130_fd_sc_hd__xnor2_2
X_5006_ _5118_/CLK _5006_/D VGND VGND VPWR VPWR _5006_/Q sky130_fd_sc_hd__dfxtp_2
X_3267_ _5135_/Q _3265_/B _3266_/Y _3448_/B VGND VGND VPWR VPWR _5135_/D sky130_fd_sc_hd__o211a_2
XFILLER_85_246 VGND VGND VPWR VPWR sky130_fd_sc_hd__decap_3
X_3198_ _2919_/X _3203_/A2 _3203_/B1 _5098_/Q VGND VGND VPWR VPWR _5098_/D sky130_fd_sc_hd__a22o_2
XFILLER_85_279 VGND VGND VPWR VPWR sky130_fd_sc_hd__fill_1
XFILLER_38_195 VGND VGND VPWR VPWR sky130_fd_sc_hd__fill_1
XFILLER_53_121 VGND VGND VPWR VPWR sky130_fd_sc_hd__fill_2
XFILLER_66_493 VGND VGND VPWR VPWR sky130_fd_sc_hd__fill_2
XFILLER_93_290 VGND VGND VPWR VPWR sky130_fd_sc_hd__decap_3
XFILLER_81_430 VGND VGND VPWR VPWR sky130_fd_sc_hd__decap_3
XFILLER_26_368 VGND VGND VPWR VPWR sky130_fd_sc_hd__fill_2
XFILLER_81_463 VGND VGND VPWR VPWR sky130_fd_sc_hd__decap_3
XFILLER_81_452 VGND VGND VPWR VPWR sky130_fd_sc_hd__decap_3
XFILLER_53_198 VGND VGND VPWR VPWR sky130_fd_sc_hd__decap_3
XFILLER_34_390 VGND VGND VPWR VPWR sky130_fd_sc_hd__decap_3
XFILLER_14_56 VGND VGND VPWR VPWR sky130_fd_sc_hd__decap_3
XFILLER_5_206 VGND VGND VPWR VPWR sky130_fd_sc_hd__decap_3
XFILLER_30_66 VGND VGND VPWR VPWR sky130_fd_sc_hd__fill_1
XFILLER_30_88 VGND VGND VPWR VPWR sky130_fd_sc_hd__decap_3
XFILLER_49_405 VGND VGND VPWR VPWR sky130_fd_sc_hd__decap_3
XFILLER_49_438 VGND VGND VPWR VPWR sky130_fd_sc_hd__decap_3
XFILLER_49_449 VGND VGND VPWR VPWR sky130_fd_sc_hd__decap_3
XFILLER_76_235 VGND VGND VPWR VPWR sky130_fd_sc_hd__decap_3
XTAP_TAPCELL_ROW_75_915 VGND VPWR sky130_fd_sc_hd__tapvpwrvgnd_1
XFILLER_29_195 VGND VGND VPWR VPWR sky130_fd_sc_hd__decap_3
XFILLER_55_52 VGND VGND VPWR VPWR sky130_fd_sc_hd__decap_3
XFILLER_17_379 VGND VGND VPWR VPWR sky130_fd_sc_hd__decap_3
XFILLER_55_63 VGND VGND VPWR VPWR sky130_fd_sc_hd__decap_3
XTAP_TAPCELL_ROW_83_992 VGND VPWR sky130_fd_sc_hd__tapvpwrvgnd_1
XFILLER_13_552 VGND VGND VPWR VPWR sky130_fd_sc_hd__fill_1
XFILLER_40_382 VGND VGND VPWR VPWR sky130_fd_sc_hd__decap_3
XTAP_TAPCELL_ROW_10_296 VGND VPWR sky130_fd_sc_hd__tapvpwrvgnd_1
X_4170_ _5213_/Q _4850_/B VGND VGND VPWR VPWR _4170_/Y sky130_fd_sc_hd__nand2_2
X_3121_ _2906_/X _3117_/B _3133_/B1 _5030_/Q VGND VGND VPWR VPWR _5030_/D sky130_fd_sc_hd__a22o_2
XFILLER_67_246 VGND VGND VPWR VPWR sky130_fd_sc_hd__decap_3
XFILLER_55_408 VGND VGND VPWR VPWR sky130_fd_sc_hd__decap_3
X_3052_ _2922_/X _3043_/B _3043_/Y _4971_/Q VGND VGND VPWR VPWR _4971_/D sky130_fd_sc_hd__a22o_2
XFILLER_75_290 VGND VGND VPWR VPWR sky130_fd_sc_hd__decap_3
XTAP_TAPCELL_ROW_85_1011 VGND VPWR sky130_fd_sc_hd__tapvpwrvgnd_1
XFILLER_82_249 VGND VGND VPWR VPWR sky130_fd_sc_hd__decap_3
XFILLER_23_327 VGND VGND VPWR VPWR sky130_fd_sc_hd__decap_3
XTAP_TAPCELL_ROW_18_374 VGND VPWR sky130_fd_sc_hd__tapvpwrvgnd_1
XFILLER_23_349 VGND VGND VPWR VPWR sky130_fd_sc_hd__decap_3
X_3954_ _3951_/X _3953_/Y _4063_/A VGND VGND VPWR VPWR _3954_/X sky130_fd_sc_hd__mux2_1
XFILLER_31_360 VGND VGND VPWR VPWR sky130_fd_sc_hd__decap_3
X_3885_ _3923_/B _3885_/B VGND VGND VPWR VPWR _3898_/A sky130_fd_sc_hd__nor2_2
X_2905_ _5225_/Q _4850_/A _3458_/B _5209_/Q VGND VGND VPWR VPWR _2905_/X sky130_fd_sc_hd__a22o_2
XFILLER_31_382 VGND VGND VPWR VPWR sky130_fd_sc_hd__decap_3
XFILLER_31_393 VGND VGND VPWR VPWR sky130_fd_sc_hd__decap_3
X_2836_ _2834_/X _2835_/X _5133_/Q VGND VGND VPWR VPWR _2836_/X sky130_fd_sc_hd__mux2_1
X_2767_ _4953_/Q _4937_/Q _4921_/Q _4905_/Q _5131_/Q _2848_/S1 VGND VGND VPWR VPWR
+ _2767_/X sky130_fd_sc_hd__mux4_2
X_4506_ _4506_/A _4506_/B VGND VGND VPWR VPWR _4507_/B sky130_fd_sc_hd__nor2_2
X_2698_ _4547_/A _2701_/B VGND VGND VPWR VPWR _2698_/Y sky130_fd_sc_hd__nor2_2
X_4437_ _4435_/Y _4498_/A VGND VGND VPWR VPWR _4441_/A sky130_fd_sc_hd__and2b_2
XFILLER_58_202 VGND VGND VPWR VPWR sky130_fd_sc_hd__decap_3
X_4368_ _4178_/X _4200_/Y _4367_/Y _4155_/A VGND VGND VPWR VPWR _4373_/B sky130_fd_sc_hd__o22a_2
XFILLER_86_522 VGND VGND VPWR VPWR sky130_fd_sc_hd__fill_2
XFILLER_76_29 VGND VGND VPWR VPWR sky130_fd_sc_hd__decap_3
XFILLER_76_18 VGND VGND VPWR VPWR sky130_fd_sc_hd__decap_3
XFILLER_58_246 VGND VGND VPWR VPWR sky130_fd_sc_hd__decap_3
X_4299_ _3668_/B _4105_/X _4172_/X VGND VGND VPWR VPWR _4299_/X sky130_fd_sc_hd__o21a_2
X_3319_ _3327_/B _3318_/Y _3265_/B VGND VGND VPWR VPWR _3319_/Y sky130_fd_sc_hd__o21ai_2
XFILLER_39_482 VGND VGND VPWR VPWR sky130_fd_sc_hd__decap_3
XFILLER_54_430 VGND VGND VPWR VPWR sky130_fd_sc_hd__decap_3
XFILLER_41_113 VGND VGND VPWR VPWR sky130_fd_sc_hd__decap_3
XTAP_TAPCELL_ROW_80_962 VGND VPWR sky130_fd_sc_hd__tapvpwrvgnd_1
XFILLER_81_293 VGND VGND VPWR VPWR sky130_fd_sc_hd__decap_3
XFILLER_10_533 VGND VGND VPWR VPWR sky130_fd_sc_hd__fill_2
XTAP_TAPCELL_ROW_52_697 VGND VPWR sky130_fd_sc_hd__tapvpwrvgnd_1
XFILLER_41_98 VGND VGND VPWR VPWR sky130_fd_sc_hd__fill_1
XFILLER_1_231 VGND VGND VPWR VPWR sky130_fd_sc_hd__decap_3
XFILLER_77_511 VGND VGND VPWR VPWR sky130_fd_sc_hd__decap_3
XFILLER_37_419 VGND VGND VPWR VPWR sky130_fd_sc_hd__fill_2
XFILLER_49_279 VGND VGND VPWR VPWR sky130_fd_sc_hd__fill_1
XFILLER_57_290 VGND VGND VPWR VPWR sky130_fd_sc_hd__fill_2
XFILLER_92_547 VGND VGND VPWR VPWR sky130_fd_sc_hd__decap_3
XFILLER_45_452 VGND VGND VPWR VPWR sky130_fd_sc_hd__decap_3
XFILLER_17_165 VGND VGND VPWR VPWR sky130_fd_sc_hd__decap_3
XFILLER_45_496 VGND VGND VPWR VPWR sky130_fd_sc_hd__decap_3
XFILLER_60_400 VGND VGND VPWR VPWR sky130_fd_sc_hd__decap_3
XFILLER_72_282 VGND VGND VPWR VPWR sky130_fd_sc_hd__decap_3
XFILLER_82_50 VGND VGND VPWR VPWR sky130_fd_sc_hd__decap_3
XFILLER_60_433 VGND VGND VPWR VPWR sky130_fd_sc_hd__decap_3
XTAP_TAPCELL_ROW_15_344 VGND VPWR sky130_fd_sc_hd__tapvpwrvgnd_1
XFILLER_82_72 VGND VGND VPWR VPWR sky130_fd_sc_hd__decap_3
XFILLER_32_179 VGND VGND VPWR VPWR sky130_fd_sc_hd__fill_1
XFILLER_60_466 VGND VGND VPWR VPWR sky130_fd_sc_hd__fill_2
XFILLER_60_477 VGND VGND VPWR VPWR sky130_fd_sc_hd__decap_3
XFILLER_82_94 VGND VGND VPWR VPWR sky130_fd_sc_hd__decap_3
XFILLER_40_190 VGND VGND VPWR VPWR sky130_fd_sc_hd__fill_1
X_3670_ _4471_/B _4471_/A _4010_/S VGND VGND VPWR VPWR _3670_/X sky130_fd_sc_hd__mux2_1
XFILLER_9_386 VGND VGND VPWR VPWR sky130_fd_sc_hd__decap_3
XFILLER_9_353 VGND VGND VPWR VPWR sky130_fd_sc_hd__decap_3
X_2621_ _2621_/A _2621_/B VGND VGND VPWR VPWR _4164_/A sky130_fd_sc_hd__and2_2
Xoutput105 _2779_/X VGND VGND VPWR VPWR MEM_STR_DATA[7] sky130_fd_sc_hd__clkdlybuf4s25_1
X_2552_ _2667_/A _2552_/B VGND VGND VPWR VPWR _2552_/X sky130_fd_sc_hd__or2_2
X_4222_ _4223_/A _4223_/C VGND VGND VPWR VPWR _4222_/Y sky130_fd_sc_hd__nand2_2
X_2483_ _5125_/Q _2482_/X _5126_/Q VGND VGND VPWR VPWR _2483_/X sky130_fd_sc_hd__o21a_2
XFILLER_87_308 VGND VGND VPWR VPWR sky130_fd_sc_hd__decap_3
XFILLER_68_500 VGND VGND VPWR VPWR sky130_fd_sc_hd__decap_3
XFILLER_68_522 VGND VGND VPWR VPWR sky130_fd_sc_hd__decap_3
XTAP_TAPCELL_ROW_91_1070 VGND VPWR sky130_fd_sc_hd__tapvpwrvgnd_1
XFILLER_68_533 VGND VGND VPWR VPWR sky130_fd_sc_hd__decap_3
X_4153_ _4248_/B VGND VGND VPWR VPWR _4153_/Y sky130_fd_sc_hd__inv_2
XFILLER_55_216 VGND VGND VPWR VPWR sky130_fd_sc_hd__decap_3
X_4084_ _2573_/Y _4002_/Y _4608_/B _4371_/B VGND VGND VPWR VPWR _4084_/X sky130_fd_sc_hd__o2bb2a_2
X_3104_ _2910_/X _3099_/B _3099_/Y _5015_/Q VGND VGND VPWR VPWR _5015_/D sky130_fd_sc_hd__a22o_2
XFILLER_83_514 VGND VGND VPWR VPWR sky130_fd_sc_hd__decap_3
X_3035_ _2929_/X _3024_/B _3024_/Y _4957_/Q VGND VGND VPWR VPWR _4957_/D sky130_fd_sc_hd__a22o_2
XFILLER_23_113 VGND VGND VPWR VPWR sky130_fd_sc_hd__decap_3
XFILLER_63_271 VGND VGND VPWR VPWR sky130_fd_sc_hd__fill_2
X_4986_ _5119_/CLK _4986_/D VGND VGND VPWR VPWR _4986_/Q sky130_fd_sc_hd__dfxtp_2
XFILLER_11_319 VGND VGND VPWR VPWR sky130_fd_sc_hd__decap_3
XFILLER_51_488 VGND VGND VPWR VPWR sky130_fd_sc_hd__decap_3
X_3937_ _4164_/A _4164_/B _3923_/X VGND VGND VPWR VPWR _3937_/X sky130_fd_sc_hd__o21a_2
X_3868_ _5178_/Q _3868_/B VGND VGND VPWR VPWR _3999_/B sky130_fd_sc_hd__nand2_2
XFILLER_11_24 VGND VGND VPWR VPWR sky130_fd_sc_hd__decap_3
X_3799_ _5114_/Q _5002_/Q _4986_/Q _4970_/Q _3834_/S0 _3834_/S1 VGND VGND VPWR VPWR
+ _3799_/X sky130_fd_sc_hd__mux4_2
X_2819_ _5119_/Q _5007_/Q _4991_/Q _4975_/Q _5131_/Q _2848_/S1 VGND VGND VPWR VPWR
+ _2820_/B sky130_fd_sc_hd__mux4_2
XFILLER_11_57 VGND VGND VPWR VPWR sky130_fd_sc_hd__decap_3
XFILLER_3_529 VGND VGND VPWR VPWR sky130_fd_sc_hd__decap_3
XFILLER_59_500 VGND VGND VPWR VPWR sky130_fd_sc_hd__decap_3
XFILLER_59_511 VGND VGND VPWR VPWR sky130_fd_sc_hd__decap_3
XFILLER_59_533 VGND VGND VPWR VPWR sky130_fd_sc_hd__decap_3
XFILLER_86_330 VGND VGND VPWR VPWR sky130_fd_sc_hd__decap_3
XFILLER_74_503 VGND VGND VPWR VPWR sky130_fd_sc_hd__decap_3
XFILLER_46_227 VGND VGND VPWR VPWR sky130_fd_sc_hd__decap_3
XTAP_TAPCELL_ROW_57_745 VGND VPWR sky130_fd_sc_hd__tapvpwrvgnd_1
XFILLER_86_385 VGND VGND VPWR VPWR sky130_fd_sc_hd__decap_3
XFILLER_27_430 VGND VGND VPWR VPWR sky130_fd_sc_hd__fill_1
XFILLER_39_290 VGND VGND VPWR VPWR sky130_fd_sc_hd__decap_3
XFILLER_27_496 VGND VGND VPWR VPWR sky130_fd_sc_hd__decap_3
XFILLER_36_76 VGND VGND VPWR VPWR sky130_fd_sc_hd__fill_2
XFILLER_42_400 VGND VGND VPWR VPWR sky130_fd_sc_hd__decap_3
XFILLER_42_433 VGND VGND VPWR VPWR sky130_fd_sc_hd__fill_1
XFILLER_42_444 VGND VGND VPWR VPWR sky130_fd_sc_hd__decap_3
XFILLER_14_168 VGND VGND VPWR VPWR sky130_fd_sc_hd__fill_1
XFILLER_52_53 VGND VGND VPWR VPWR sky130_fd_sc_hd__decap_3
XFILLER_52_75 VGND VGND VPWR VPWR sky130_fd_sc_hd__decap_3
XTAP_TAPCELL_ROW_12_314 VGND VPWR sky130_fd_sc_hd__tapvpwrvgnd_1
XFILLER_52_97 VGND VGND VPWR VPWR sky130_fd_sc_hd__decap_3
Xinput18 INSTR_STREAM[25] VGND VGND VPWR VPWR _3438_/C sky130_fd_sc_hd__clkdlybuf4s25_1
Xinput29 INSTR_STREAM[6] VGND VGND VPWR VPWR _3422_/B sky130_fd_sc_hd__clkdlybuf4s25_1
XFILLER_6_356 VGND VGND VPWR VPWR sky130_fd_sc_hd__decap_3
XTAP_TAPCELL_ROW_20_391 VGND VPWR sky130_fd_sc_hd__tapvpwrvgnd_1
XFILLER_6_389 VGND VGND VPWR VPWR sky130_fd_sc_hd__decap_3
XFILLER_2_551 VGND VGND VPWR VPWR sky130_fd_sc_hd__fill_2
XFILLER_37_205 VGND VGND VPWR VPWR sky130_fd_sc_hd__fill_1
XFILLER_65_503 VGND VGND VPWR VPWR sky130_fd_sc_hd__fill_1
XFILLER_77_352 VGND VGND VPWR VPWR sky130_fd_sc_hd__decap_3
XFILLER_77_396 VGND VGND VPWR VPWR sky130_fd_sc_hd__decap_3
XFILLER_18_430 VGND VGND VPWR VPWR sky130_fd_sc_hd__decap_3
XFILLER_37_249 VGND VGND VPWR VPWR sky130_fd_sc_hd__decap_3
XFILLER_93_60 VGND VGND VPWR VPWR sky130_fd_sc_hd__fill_1
XFILLER_92_355 VGND VGND VPWR VPWR sky130_fd_sc_hd__decap_3
XFILLER_80_517 VGND VGND VPWR VPWR sky130_fd_sc_hd__decap_3
XFILLER_18_463 VGND VGND VPWR VPWR sky130_fd_sc_hd__fill_1
XFILLER_33_411 VGND VGND VPWR VPWR sky130_fd_sc_hd__decap_3
XFILLER_45_260 VGND VGND VPWR VPWR sky130_fd_sc_hd__decap_3
XFILLER_52_219 VGND VGND VPWR VPWR sky130_fd_sc_hd__decap_3
XFILLER_92_377 VGND VGND VPWR VPWR sky130_fd_sc_hd__decap_3
XFILLER_33_455 VGND VGND VPWR VPWR sky130_fd_sc_hd__fill_2
XFILLER_45_293 VGND VGND VPWR VPWR sky130_fd_sc_hd__decap_3
X_4840_ input35/X _4816_/Y _4839_/X _3442_/B VGND VGND VPWR VPWR _5249_/D sky130_fd_sc_hd__o211a_2
XFILLER_60_263 VGND VGND VPWR VPWR sky130_fd_sc_hd__decap_3
X_4771_ _4757_/Y _4770_/X _4866_/A VGND VGND VPWR VPWR _5234_/D sky130_fd_sc_hd__a21oi_2
X_3722_ _3720_/X _3721_/X _5129_/Q VGND VGND VPWR VPWR _3722_/X sky130_fd_sc_hd__mux2_1
X_3653_ _4806_/A _3643_/B _4208_/A _3652_/Y VGND VGND VPWR VPWR _3653_/X sky130_fd_sc_hd__a31o_2
X_2604_ _5152_/Q _4445_/B VGND VGND VPWR VPWR _2855_/A sky130_fd_sc_hd__and2_2
X_3584_ _3581_/X _3582_/Y _3577_/A _3577_/Y VGND VGND VPWR VPWR _3584_/X sky130_fd_sc_hd__a211o_2
X_2535_ _4464_/B VGND VGND VPWR VPWR _3923_/B sky130_fd_sc_hd__inv_2
X_5254_ _5254_/CLK _5254_/D VGND VGND VPWR VPWR _5254_/Q sky130_fd_sc_hd__dfxtp_2
X_2466_ _2887_/B _4168_/A _3442_/B VGND VGND VPWR VPWR _5259_/D sky130_fd_sc_hd__and3b_2
XFILLER_87_116 VGND VGND VPWR VPWR sky130_fd_sc_hd__decap_3
X_4205_ _4098_/X _4204_/Y _4339_/A VGND VGND VPWR VPWR _4205_/X sky130_fd_sc_hd__mux2_1
X_5185_ clkload5/A _5185_/D VGND VGND VPWR VPWR _5185_/Q sky130_fd_sc_hd__dfxtp_2
X_4136_ _4700_/S _4136_/B VGND VGND VPWR VPWR _4136_/Y sky130_fd_sc_hd__nand2_2
X_4067_ _4067_/A _4523_/S VGND VGND VPWR VPWR _4067_/Y sky130_fd_sc_hd__nand2_2
XFILLER_36_271 VGND VGND VPWR VPWR sky130_fd_sc_hd__decap_3
XFILLER_71_517 VGND VGND VPWR VPWR sky130_fd_sc_hd__decap_3
X_3018_ _2932_/X _3006_/B _3006_/Y _4942_/Q VGND VGND VPWR VPWR _4942_/D sky130_fd_sc_hd__a22o_2
XTAP_TAPCELL_ROW_54_715 VGND VPWR sky130_fd_sc_hd__tapvpwrvgnd_1
XFILLER_83_399 VGND VGND VPWR VPWR sky130_fd_sc_hd__fill_1
XFILLER_83_377 VGND VGND VPWR VPWR sky130_fd_sc_hd__decap_3
XFILLER_24_433 VGND VGND VPWR VPWR sky130_fd_sc_hd__decap_3
XFILLER_24_477 VGND VGND VPWR VPWR sky130_fd_sc_hd__fill_1
XFILLER_51_252 VGND VGND VPWR VPWR sky130_fd_sc_hd__decap_3
XFILLER_51_296 VGND VGND VPWR VPWR sky130_fd_sc_hd__decap_3
X_4969_ clkload9/A _4969_/D VGND VGND VPWR VPWR _4969_/Q sky130_fd_sc_hd__dfxtp_2
XTAP_TAPCELL_ROW_62_792 VGND VPWR sky130_fd_sc_hd__tapvpwrvgnd_1
XFILLER_78_138 VGND VGND VPWR VPWR sky130_fd_sc_hd__fill_2
XFILLER_47_31 VGND VGND VPWR VPWR sky130_fd_sc_hd__fill_1
XFILLER_59_352 VGND VGND VPWR VPWR sky130_fd_sc_hd__decap_3
XFILLER_59_396 VGND VGND VPWR VPWR sky130_fd_sc_hd__decap_3
XFILLER_19_249 VGND VGND VPWR VPWR sky130_fd_sc_hd__decap_3
XFILLER_47_75 VGND VGND VPWR VPWR sky130_fd_sc_hd__fill_1
XFILLER_62_506 VGND VGND VPWR VPWR sky130_fd_sc_hd__decap_3
XFILLER_74_344 VGND VGND VPWR VPWR sky130_fd_sc_hd__decap_3
XFILLER_74_355 VGND VGND VPWR VPWR sky130_fd_sc_hd__decap_3
XFILLER_74_377 VGND VGND VPWR VPWR sky130_fd_sc_hd__decap_3
XFILLER_42_230 VGND VGND VPWR VPWR sky130_fd_sc_hd__decap_3
XFILLER_63_30 VGND VGND VPWR VPWR sky130_fd_sc_hd__decap_3
XFILLER_63_41 VGND VGND VPWR VPWR sky130_fd_sc_hd__fill_2
XFILLER_42_241 VGND VGND VPWR VPWR sky130_fd_sc_hd__fill_1
XFILLER_42_263 VGND VGND VPWR VPWR sky130_fd_sc_hd__fill_2
XFILLER_63_63 VGND VGND VPWR VPWR sky130_fd_sc_hd__decap_3
XFILLER_63_85 VGND VGND VPWR VPWR sky130_fd_sc_hd__decap_3
XFILLER_15_499 VGND VGND VPWR VPWR sky130_fd_sc_hd__decap_3
XFILLER_30_458 VGND VGND VPWR VPWR sky130_fd_sc_hd__decap_3
XFILLER_6_153 VGND VGND VPWR VPWR sky130_fd_sc_hd__decap_3
XFILLER_6_186 VGND VGND VPWR VPWR sky130_fd_sc_hd__fill_2
XFILLER_6_197 VGND VGND VPWR VPWR sky130_fd_sc_hd__decap_3
XFILLER_19_3 VGND VGND VPWR VPWR sky130_fd_sc_hd__decap_3
XFILLER_38_547 VGND VGND VPWR VPWR sky130_fd_sc_hd__decap_3
XFILLER_65_300 VGND VGND VPWR VPWR sky130_fd_sc_hd__decap_3
XFILLER_65_333 VGND VGND VPWR VPWR sky130_fd_sc_hd__decap_3
XFILLER_65_355 VGND VGND VPWR VPWR sky130_fd_sc_hd__decap_3
XFILLER_92_141 VGND VGND VPWR VPWR sky130_fd_sc_hd__decap_3
XFILLER_25_208 VGND VGND VPWR VPWR sky130_fd_sc_hd__decap_3
XFILLER_53_517 VGND VGND VPWR VPWR sky130_fd_sc_hd__decap_3
XFILLER_65_399 VGND VGND VPWR VPWR sky130_fd_sc_hd__decap_3
XFILLER_92_174 VGND VGND VPWR VPWR sky130_fd_sc_hd__decap_3
XFILLER_80_336 VGND VGND VPWR VPWR sky130_fd_sc_hd__decap_3
X_4823_ _5241_/Q _4847_/B VGND VGND VPWR VPWR _4823_/X sky130_fd_sc_hd__or2_2
XFILLER_21_447 VGND VGND VPWR VPWR sky130_fd_sc_hd__fill_1
X_4754_ _4270_/X _4748_/X _4753_/X _4136_/Y VGND VGND VPWR VPWR _4754_/X sky130_fd_sc_hd__a31o_2
X_3705_ _4894_/Q _4878_/Q _5102_/Q _5086_/Q _3834_/S0 _3834_/S1 VGND VGND VPWR VPWR
+ _3706_/B sky130_fd_sc_hd__mux4_2
X_4685_ _4687_/A _4686_/S _4619_/Y VGND VGND VPWR VPWR _4685_/X sky130_fd_sc_hd__or3b_2
XTAP_TAPCELL_ROW_31_497 VGND VPWR sky130_fd_sc_hd__tapvpwrvgnd_1
X_3636_ _4108_/A VGND VGND VPWR VPWR _3636_/Y sky130_fd_sc_hd__inv_2
X_3567_ _5165_/Q _5146_/Q VGND VGND VPWR VPWR _3567_/Y sky130_fd_sc_hd__nor2_2
X_2518_ _5125_/Q _2518_/B VGND VGND VPWR VPWR _2518_/X sky130_fd_sc_hd__or2_2
XFILLER_88_403 VGND VGND VPWR VPWR sky130_fd_sc_hd__decap_3
X_5237_ _5263_/CLK _5237_/D VGND VGND VPWR VPWR _5237_/Q sky130_fd_sc_hd__dfxtp_2
X_3498_ _3491_/Y _3497_/X _4866_/A VGND VGND VPWR VPWR _5193_/D sky130_fd_sc_hd__a21oi_2
XFILLER_29_503 VGND VGND VPWR VPWR sky130_fd_sc_hd__fill_1
X_2449_ _5179_/Q _4171_/A VGND VGND VPWR VPWR _2449_/Y sky130_fd_sc_hd__nor2_2
XFILLER_68_160 VGND VGND VPWR VPWR sky130_fd_sc_hd__decap_3
XFILLER_75_119 VGND VGND VPWR VPWR sky130_fd_sc_hd__decap_3
X_5168_ clkload4/A _5168_/D VGND VGND VPWR VPWR _5168_/Q sky130_fd_sc_hd__dfxtp_2
XFILLER_84_29 VGND VGND VPWR VPWR sky130_fd_sc_hd__decap_3
XFILLER_44_506 VGND VGND VPWR VPWR sky130_fd_sc_hd__decap_3
XFILLER_56_344 VGND VGND VPWR VPWR sky130_fd_sc_hd__decap_3
XFILLER_56_355 VGND VGND VPWR VPWR sky130_fd_sc_hd__decap_3
X_4119_ _4850_/B _4117_/X _4118_/X _3448_/B VGND VGND VPWR VPWR _5210_/D sky130_fd_sc_hd__o211a_2
X_5099_ _5121_/CLK _5099_/D VGND VGND VPWR VPWR _5099_/Q sky130_fd_sc_hd__dfxtp_2
XTAP_TAPCELL_ROW_67_840 VGND VPWR sky130_fd_sc_hd__tapvpwrvgnd_1
XFILLER_56_377 VGND VGND VPWR VPWR sky130_fd_sc_hd__decap_3
XFILLER_71_303 VGND VGND VPWR VPWR sky130_fd_sc_hd__decap_3
XTAP_TAPCELL_ROW_39_575 VGND VPWR sky130_fd_sc_hd__tapvpwrvgnd_1
XFILLER_83_163 VGND VGND VPWR VPWR sky130_fd_sc_hd__decap_3
XFILLER_71_358 VGND VGND VPWR VPWR sky130_fd_sc_hd__decap_3
XFILLER_12_403 VGND VGND VPWR VPWR sky130_fd_sc_hd__fill_2
XFILLER_24_241 VGND VGND VPWR VPWR sky130_fd_sc_hd__decap_3
XFILLER_24_285 VGND VGND VPWR VPWR sky130_fd_sc_hd__decap_3
XFILLER_12_469 VGND VGND VPWR VPWR sky130_fd_sc_hd__decap_3
XFILLER_33_44 VGND VGND VPWR VPWR sky130_fd_sc_hd__decap_3
XFILLER_33_77 VGND VGND VPWR VPWR sky130_fd_sc_hd__fill_1
XPHY_EDGE_ROW_49_Left_143 VGND VGND VPWR VPWR sky130_fd_sc_hd__decap_3
XFILLER_79_425 VGND VGND VPWR VPWR sky130_fd_sc_hd__decap_3
XPHY_EDGE_ROW_58_Left_152 VGND VGND VPWR VPWR sky130_fd_sc_hd__decap_3
XFILLER_58_85 VGND VGND VPWR VPWR sky130_fd_sc_hd__decap_3
XFILLER_58_96 VGND VGND VPWR VPWR sky130_fd_sc_hd__decap_3
XFILLER_66_119 VGND VGND VPWR VPWR sky130_fd_sc_hd__fill_2
XFILLER_87_480 VGND VGND VPWR VPWR sky130_fd_sc_hd__decap_3
XFILLER_47_333 VGND VGND VPWR VPWR sky130_fd_sc_hd__decap_3
XFILLER_35_517 VGND VGND VPWR VPWR sky130_fd_sc_hd__decap_3
XFILLER_35_539 VGND VGND VPWR VPWR sky130_fd_sc_hd__decap_3
XFILLER_74_152 VGND VGND VPWR VPWR sky130_fd_sc_hd__decap_3
XFILLER_74_40 VGND VGND VPWR VPWR sky130_fd_sc_hd__decap_3
XFILLER_62_358 VGND VGND VPWR VPWR sky130_fd_sc_hd__decap_3
XFILLER_74_185 VGND VGND VPWR VPWR sky130_fd_sc_hd__decap_3
XFILLER_15_274 VGND VGND VPWR VPWR sky130_fd_sc_hd__decap_3
XFILLER_30_200 VGND VGND VPWR VPWR sky130_fd_sc_hd__decap_3
XFILLER_70_380 VGND VGND VPWR VPWR sky130_fd_sc_hd__decap_3
XTAP_TAPCELL_ROW_73_898 VGND VPWR sky130_fd_sc_hd__tapvpwrvgnd_1
XPHY_EDGE_ROW_67_Left_161 VGND VGND VPWR VPWR sky130_fd_sc_hd__decap_3
XFILLER_88_6 VGND VGND VPWR VPWR sky130_fd_sc_hd__fill_2
XFILLER_30_288 VGND VGND VPWR VPWR sky130_fd_sc_hd__fill_1
XFILLER_11_491 VGND VGND VPWR VPWR sky130_fd_sc_hd__decap_3
X_4470_ _4470_/A _4470_/B VGND VGND VPWR VPWR _4532_/A sky130_fd_sc_hd__nand2_2
Xmax_cap115 _3117_/Y VGND VGND VPWR VPWR _3133_/B1 sky130_fd_sc_hd__clkbuf_8
Xmax_cap126 _3080_/B VGND VGND VPWR VPWR _3093_/A2 sky130_fd_sc_hd__buf_6
Xmax_cap137 _2968_/B VGND VGND VPWR VPWR _2984_/A2 sky130_fd_sc_hd__clkbuf_8
Xmax_cap148 _3442_/B VGND VGND VPWR VPWR _3448_/B sky130_fd_sc_hd__buf_12
X_3421_ _5157_/Q _3450_/C _3228_/Y _3420_/X VGND VGND VPWR VPWR _5157_/D sky130_fd_sc_hd__o22a_2
X_3352_ _3352_/A _3352_/B VGND VGND VPWR VPWR _3361_/D sky130_fd_sc_hd__xnor2_2
XPHY_EDGE_ROW_76_Left_170 VGND VGND VPWR VPWR sky130_fd_sc_hd__decap_3
XFILLER_57_108 VGND VGND VPWR VPWR sky130_fd_sc_hd__decap_3
X_3283_ _3283_/A _3283_/B VGND VGND VPWR VPWR _3294_/B sky130_fd_sc_hd__and2_2
XFILLER_85_417 VGND VGND VPWR VPWR sky130_fd_sc_hd__decap_3
XFILLER_38_300 VGND VGND VPWR VPWR sky130_fd_sc_hd__fill_2
XFILLER_57_119 VGND VGND VPWR VPWR sky130_fd_sc_hd__decap_3
X_5022_ _5100_/CLK _5022_/D VGND VGND VPWR VPWR _5022_/Q sky130_fd_sc_hd__dfxtp_2
XFILLER_65_141 VGND VGND VPWR VPWR sky130_fd_sc_hd__fill_1
XTAP_TAPCELL_ROW_88_1042 VGND VPWR sky130_fd_sc_hd__tapvpwrvgnd_1
XFILLER_38_377 VGND VGND VPWR VPWR sky130_fd_sc_hd__decap_3
XFILLER_53_314 VGND VGND VPWR VPWR sky130_fd_sc_hd__fill_2
XTAP_TAPCELL_ROW_64_810 VGND VPWR sky130_fd_sc_hd__tapvpwrvgnd_1
XFILLER_93_483 VGND VGND VPWR VPWR sky130_fd_sc_hd__decap_3
XFILLER_93_461 VGND VGND VPWR VPWR sky130_fd_sc_hd__decap_3
XFILLER_34_550 VGND VGND VPWR VPWR sky130_fd_sc_hd__decap_3
XFILLER_53_358 VGND VGND VPWR VPWR sky130_fd_sc_hd__decap_3
XTAP_TAPCELL_ROW_36_545 VGND VPWR sky130_fd_sc_hd__tapvpwrvgnd_1
XFILLER_61_380 VGND VGND VPWR VPWR sky130_fd_sc_hd__fill_1
XFILLER_21_222 VGND VGND VPWR VPWR sky130_fd_sc_hd__fill_2
X_4806_ _4806_/A _4806_/B VGND VGND VPWR VPWR _4806_/Y sky130_fd_sc_hd__nand2_2
X_2998_ _2929_/X _2987_/B _2987_/Y _4925_/Q VGND VGND VPWR VPWR _4925_/D sky130_fd_sc_hd__a22o_2
X_4737_ _4736_/Y _4707_/Y _4802_/A VGND VGND VPWR VPWR _4737_/X sky130_fd_sc_hd__mux2_1
X_4668_ _4142_/B _4142_/C _4667_/X _4136_/Y VGND VGND VPWR VPWR _4668_/X sky130_fd_sc_hd__a31o_2
X_3619_ _5059_/Q _5043_/Q _5027_/Q _5011_/Q _3834_/S0 _3834_/S1 VGND VGND VPWR VPWR
+ _3620_/B sky130_fd_sc_hd__mux4_2
XFILLER_79_29 VGND VGND VPWR VPWR sky130_fd_sc_hd__decap_3
X_4599_ _4562_/Y _4598_/X _4866_/A VGND VGND VPWR VPWR _5224_/D sky130_fd_sc_hd__a21oi_2
XFILLER_88_222 VGND VGND VPWR VPWR sky130_fd_sc_hd__fill_2
XFILLER_0_159 VGND VGND VPWR VPWR sky130_fd_sc_hd__decap_3
XFILLER_88_288 VGND VGND VPWR VPWR sky130_fd_sc_hd__decap_3
XFILLER_28_44 VGND VGND VPWR VPWR sky130_fd_sc_hd__decap_3
XFILLER_29_333 VGND VGND VPWR VPWR sky130_fd_sc_hd__decap_3
XFILLER_28_77 VGND VGND VPWR VPWR sky130_fd_sc_hd__decap_3
XFILLER_28_88 VGND VGND VPWR VPWR sky130_fd_sc_hd__fill_2
XFILLER_29_377 VGND VGND VPWR VPWR sky130_fd_sc_hd__decap_3
XFILLER_56_141 VGND VGND VPWR VPWR sky130_fd_sc_hd__decap_3
XFILLER_84_483 VGND VGND VPWR VPWR sky130_fd_sc_hd__decap_3
XFILLER_29_399 VGND VGND VPWR VPWR sky130_fd_sc_hd__decap_3
XFILLER_71_122 VGND VGND VPWR VPWR sky130_fd_sc_hd__decap_3
XFILLER_12_200 VGND VGND VPWR VPWR sky130_fd_sc_hd__decap_3
XFILLER_40_520 VGND VGND VPWR VPWR sky130_fd_sc_hd__fill_2
XFILLER_44_76 VGND VGND VPWR VPWR sky130_fd_sc_hd__decap_3
XFILLER_71_177 VGND VGND VPWR VPWR sky130_fd_sc_hd__decap_3
XFILLER_52_391 VGND VGND VPWR VPWR sky130_fd_sc_hd__decap_3
XTAP_TAPCELL_ROW_70_868 VGND VPWR sky130_fd_sc_hd__tapvpwrvgnd_1
XFILLER_4_421 VGND VGND VPWR VPWR sky130_fd_sc_hd__decap_3
XFILLER_4_454 VGND VGND VPWR VPWR sky130_fd_sc_hd__decap_3
XFILLER_5_48 VGND VGND VPWR VPWR sky130_fd_sc_hd__decap_3
XFILLER_67_428 VGND VGND VPWR VPWR sky130_fd_sc_hd__fill_2
XTAP_TAPCELL_ROW_7_270 VGND VPWR sky130_fd_sc_hd__tapvpwrvgnd_1
XTAP_TAPCELL_ROW_78_946 VGND VPWR sky130_fd_sc_hd__tapvpwrvgnd_1
XPHY_EDGE_ROW_13_Right_13 VGND VGND VPWR VPWR sky130_fd_sc_hd__decap_3
XFILLER_35_314 VGND VGND VPWR VPWR sky130_fd_sc_hd__fill_2
XFILLER_75_461 VGND VGND VPWR VPWR sky130_fd_sc_hd__decap_3
XFILLER_47_174 VGND VGND VPWR VPWR sky130_fd_sc_hd__decap_3
XFILLER_35_358 VGND VGND VPWR VPWR sky130_fd_sc_hd__fill_1
XFILLER_50_306 VGND VGND VPWR VPWR sky130_fd_sc_hd__fill_2
X_3970_ _4107_/A _3959_/X _3963_/X _3651_/Y _3969_/X VGND VGND VPWR VPWR _4558_/A
+ sky130_fd_sc_hd__o221a_2
XFILLER_90_442 VGND VGND VPWR VPWR sky130_fd_sc_hd__decap_3
X_2921_ _5230_/Q _4850_/A _3458_/B _5214_/Q VGND VGND VPWR VPWR _2921_/X sky130_fd_sc_hd__a22o_2
XTAP_TAPCELL_ROW_33_515 VGND VPWR sky130_fd_sc_hd__tapvpwrvgnd_1
X_2852_ _5152_/Q _4445_/B VGND VGND VPWR VPWR _2853_/B sky130_fd_sc_hd__nor2_2
XFILLER_86_3 VGND VGND VPWR VPWR sky130_fd_sc_hd__decap_3
X_2783_ _5115_/Q _5003_/Q _4987_/Q _4971_/Q _5131_/Q _5132_/Q VGND VGND VPWR VPWR
+ _2784_/B sky130_fd_sc_hd__mux4_2
XTAP_TAPCELL_ROW_41_592 VGND VPWR sky130_fd_sc_hd__tapvpwrvgnd_1
XPHY_EDGE_ROW_22_Right_22 VGND VGND VPWR VPWR sky130_fd_sc_hd__decap_3
X_4522_ _4520_/X _4521_/Y _4624_/A VGND VGND VPWR VPWR _4656_/B sky130_fd_sc_hd__mux2_1
X_4453_ _4473_/A _4453_/B VGND VGND VPWR VPWR _4456_/A sky130_fd_sc_hd__nor2_2
X_3404_ _5185_/Q _3265_/B _5149_/Q VGND VGND VPWR VPWR _3404_/X sky130_fd_sc_hd__a21o_2
X_4384_ _4464_/A _3923_/B _4382_/X _4475_/A VGND VGND VPWR VPWR _4384_/X sky130_fd_sc_hd__a2bb2o_2
X_3335_ _3335_/A _3335_/B VGND VGND VPWR VPWR _3335_/Y sky130_fd_sc_hd__xnor2_2
X_3266_ _5185_/Q _5135_/Q _3262_/Y _3263_/X _3265_/B VGND VGND VPWR VPWR _3266_/Y
+ sky130_fd_sc_hd__o221ai_2
XPHY_EDGE_ROW_31_Right_31 VGND VGND VPWR VPWR sky130_fd_sc_hd__decap_3
XFILLER_85_225 VGND VGND VPWR VPWR sky130_fd_sc_hd__decap_3
X_5005_ _5119_/CLK _5005_/D VGND VGND VPWR VPWR _5005_/Q sky130_fd_sc_hd__dfxtp_2
X_3197_ _2916_/X _3203_/A2 _3203_/B1 _5097_/Q VGND VGND VPWR VPWR _5097_/D sky130_fd_sc_hd__a22o_2
XFILLER_26_347 VGND VGND VPWR VPWR sky130_fd_sc_hd__fill_2
XFILLER_53_100 VGND VGND VPWR VPWR sky130_fd_sc_hd__fill_1
XFILLER_53_111 VGND VGND VPWR VPWR sky130_fd_sc_hd__fill_1
XTAP_TAPCELL_ROW_49_670 VGND VPWR sky130_fd_sc_hd__tapvpwrvgnd_1
XFILLER_53_133 VGND VGND VPWR VPWR sky130_fd_sc_hd__decap_3
XFILLER_81_475 VGND VGND VPWR VPWR sky130_fd_sc_hd__decap_3
Xclkbuf_leaf_39_CLK clkbuf_leaf_8_CLK/A VGND VGND VPWR VPWR _5103_/CLK sky130_fd_sc_hd__clkbuf_8
XPHY_EDGE_ROW_40_Right_40 VGND VGND VPWR VPWR sky130_fd_sc_hd__decap_3
XFILLER_89_520 VGND VGND VPWR VPWR sky130_fd_sc_hd__decap_3
XFILLER_39_54 VGND VGND VPWR VPWR sky130_fd_sc_hd__fill_2
XFILLER_49_417 VGND VGND VPWR VPWR sky130_fd_sc_hd__decap_3
XFILLER_76_214 VGND VGND VPWR VPWR sky130_fd_sc_hd__decap_3
XTAP_TAPCELL_ROW_4_240 VGND VPWR sky130_fd_sc_hd__tapvpwrvgnd_1
XFILLER_64_409 VGND VGND VPWR VPWR sky130_fd_sc_hd__decap_3
XTAP_TAPCELL_ROW_75_916 VGND VPWR sky130_fd_sc_hd__tapvpwrvgnd_1
XFILLER_55_31 VGND VGND VPWR VPWR sky130_fd_sc_hd__decap_3
XFILLER_84_280 VGND VGND VPWR VPWR sky130_fd_sc_hd__decap_3
XFILLER_17_358 VGND VGND VPWR VPWR sky130_fd_sc_hd__decap_3
XFILLER_44_144 VGND VGND VPWR VPWR sky130_fd_sc_hd__decap_3
XFILLER_55_75 VGND VGND VPWR VPWR sky130_fd_sc_hd__decap_3
XFILLER_32_306 VGND VGND VPWR VPWR sky130_fd_sc_hd__fill_2
XFILLER_72_486 VGND VGND VPWR VPWR sky130_fd_sc_hd__decap_3
XTAP_TAPCELL_ROW_83_993 VGND VPWR sky130_fd_sc_hd__tapvpwrvgnd_1
XFILLER_13_531 VGND VGND VPWR VPWR sky130_fd_sc_hd__decap_3
XFILLER_40_361 VGND VGND VPWR VPWR sky130_fd_sc_hd__decap_3
XFILLER_71_41 VGND VGND VPWR VPWR sky130_fd_sc_hd__decap_3
XFILLER_71_96 VGND VGND VPWR VPWR sky130_fd_sc_hd__decap_3
XTAP_TAPCELL_ROW_10_297 VGND VPWR sky130_fd_sc_hd__tapvpwrvgnd_1
XFILLER_67_214 VGND VGND VPWR VPWR sky130_fd_sc_hd__decap_3
XFILLER_67_225 VGND VGND VPWR VPWR sky130_fd_sc_hd__decap_3
X_3120_ _2903_/X _3117_/B _3133_/B1 _5029_/Q VGND VGND VPWR VPWR _5029_/D sky130_fd_sc_hd__a22o_2
XFILLER_67_269 VGND VGND VPWR VPWR sky130_fd_sc_hd__decap_3
X_3051_ _2919_/X _3056_/A2 _3043_/Y _4970_/Q VGND VGND VPWR VPWR _4970_/D sky130_fd_sc_hd__a22o_2
XFILLER_82_206 VGND VGND VPWR VPWR sky130_fd_sc_hd__decap_3
XTAP_TAPCELL_ROW_85_1012 VGND VPWR sky130_fd_sc_hd__tapvpwrvgnd_1
XFILLER_82_228 VGND VGND VPWR VPWR sky130_fd_sc_hd__decap_3
XFILLER_63_442 VGND VGND VPWR VPWR sky130_fd_sc_hd__decap_3
XTAP_TAPCELL_ROW_46_640 VGND VPWR sky130_fd_sc_hd__tapvpwrvgnd_1
XFILLER_23_306 VGND VGND VPWR VPWR sky130_fd_sc_hd__fill_1
XTAP_TAPCELL_ROW_18_375 VGND VPWR sky130_fd_sc_hd__tapvpwrvgnd_1
X_3953_ _4429_/B _4787_/S _3952_/Y VGND VGND VPWR VPWR _3953_/Y sky130_fd_sc_hd__o21ai_2
XFILLER_50_169 VGND VGND VPWR VPWR sky130_fd_sc_hd__decap_3
X_3884_ _3804_/B _4464_/A VGND VGND VPWR VPWR _3884_/X sky130_fd_sc_hd__and2b_2
X_2904_ _4869_/Q _2936_/A2 _2903_/X _2936_/B2 VGND VGND VPWR VPWR _4869_/D sky130_fd_sc_hd__a22o_2
X_2835_ _5073_/Q _5057_/Q _5041_/Q _5025_/Q _5131_/Q _2848_/S1 VGND VGND VPWR VPWR
+ _2835_/X sky130_fd_sc_hd__mux4_2
X_2766_ _5133_/Q _2766_/B VGND VGND VPWR VPWR _2766_/X sky130_fd_sc_hd__or2_2
X_4505_ _4506_/A _4506_/B VGND VGND VPWR VPWR _4567_/B sky130_fd_sc_hd__and2_2
X_2697_ _2701_/B VGND VGND VPWR VPWR _2697_/Y sky130_fd_sc_hd__inv_2
XFILLER_6_91 VGND VGND VPWR VPWR sky130_fd_sc_hd__decap_3
X_4436_ _4464_/A _4466_/B VGND VGND VPWR VPWR _4498_/A sky130_fd_sc_hd__nand2_2
X_4367_ _4297_/A _4267_/B _4366_/X VGND VGND VPWR VPWR _4367_/Y sky130_fd_sc_hd__a21boi_2
XFILLER_58_214 VGND VGND VPWR VPWR sky130_fd_sc_hd__decap_3
X_3318_ _5139_/Q _3317_/C _5140_/Q VGND VGND VPWR VPWR _3318_/Y sky130_fd_sc_hd__a21oi_2
X_4298_ _4155_/A _4294_/Y _4297_/Y _4100_/B _4200_/Y VGND VGND VPWR VPWR _4298_/X
+ sky130_fd_sc_hd__o32a_2
XFILLER_86_545 VGND VGND VPWR VPWR sky130_fd_sc_hd__decap_3
XFILLER_39_461 VGND VGND VPWR VPWR sky130_fd_sc_hd__decap_3
XFILLER_46_409 VGND VGND VPWR VPWR sky130_fd_sc_hd__fill_2
XFILLER_73_206 VGND VGND VPWR VPWR sky130_fd_sc_hd__decap_3
X_3249_ _4866_/A _4864_/B VGND VGND VPWR VPWR _5132_/D sky130_fd_sc_hd__nor2_2
XFILLER_39_494 VGND VGND VPWR VPWR sky130_fd_sc_hd__decap_3
XFILLER_66_280 VGND VGND VPWR VPWR sky130_fd_sc_hd__decap_3
XFILLER_73_228 VGND VGND VPWR VPWR sky130_fd_sc_hd__decap_3
XTAP_TAPCELL_ROW_1_210 VGND VPWR sky130_fd_sc_hd__tapvpwrvgnd_1
XFILLER_54_442 VGND VGND VPWR VPWR sky130_fd_sc_hd__decap_3
XFILLER_92_29 VGND VGND VPWR VPWR sky130_fd_sc_hd__decap_3
XFILLER_81_261 VGND VGND VPWR VPWR sky130_fd_sc_hd__decap_3
XFILLER_41_147 VGND VGND VPWR VPWR sky130_fd_sc_hd__decap_3
XTAP_TAPCELL_ROW_80_963 VGND VPWR sky130_fd_sc_hd__tapvpwrvgnd_1
XFILLER_22_383 VGND VGND VPWR VPWR sky130_fd_sc_hd__decap_3
XTAP_TAPCELL_ROW_52_698 VGND VPWR sky130_fd_sc_hd__tapvpwrvgnd_1
XFILLER_41_55 VGND VGND VPWR VPWR sky130_fd_sc_hd__fill_1
XFILLER_49_214 VGND VGND VPWR VPWR sky130_fd_sc_hd__decap_3
XFILLER_77_523 VGND VGND VPWR VPWR sky130_fd_sc_hd__decap_3
XFILLER_77_501 VGND VGND VPWR VPWR sky130_fd_sc_hd__decap_3
XFILLER_49_225 VGND VGND VPWR VPWR sky130_fd_sc_hd__decap_3
XFILLER_92_515 VGND VGND VPWR VPWR sky130_fd_sc_hd__decap_3
XFILLER_17_100 VGND VGND VPWR VPWR sky130_fd_sc_hd__decap_3
XFILLER_17_111 VGND VGND VPWR VPWR sky130_fd_sc_hd__fill_1
XFILLER_17_122 VGND VGND VPWR VPWR sky130_fd_sc_hd__decap_3
XFILLER_45_431 VGND VGND VPWR VPWR sky130_fd_sc_hd__decap_3
XFILLER_45_464 VGND VGND VPWR VPWR sky130_fd_sc_hd__decap_3
XFILLER_45_475 VGND VGND VPWR VPWR sky130_fd_sc_hd__decap_3
XFILLER_60_412 VGND VGND VPWR VPWR sky130_fd_sc_hd__decap_3
XFILLER_72_250 VGND VGND VPWR VPWR sky130_fd_sc_hd__fill_2
XFILLER_72_261 VGND VGND VPWR VPWR sky130_fd_sc_hd__decap_3
XTAP_TAPCELL_ROW_43_610 VGND VPWR sky130_fd_sc_hd__tapvpwrvgnd_1
XFILLER_17_199 VGND VGND VPWR VPWR sky130_fd_sc_hd__decap_3
XFILLER_60_445 VGND VGND VPWR VPWR sky130_fd_sc_hd__decap_3
XFILLER_72_294 VGND VGND VPWR VPWR sky130_fd_sc_hd__decap_3
XFILLER_13_361 VGND VGND VPWR VPWR sky130_fd_sc_hd__decap_3
XFILLER_32_158 VGND VGND VPWR VPWR sky130_fd_sc_hd__decap_3
XTAP_TAPCELL_ROW_15_345 VGND VPWR sky130_fd_sc_hd__tapvpwrvgnd_1
XFILLER_13_383 VGND VGND VPWR VPWR sky130_fd_sc_hd__decap_3
XFILLER_9_343 VGND VGND VPWR VPWR sky130_fd_sc_hd__fill_2
X_2620_ _5158_/Q _4464_/B VGND VGND VPWR VPWR _2621_/B sky130_fd_sc_hd__or2_2
Xoutput106 _2788_/X VGND VGND VPWR VPWR MEM_STR_DATA[8] sky130_fd_sc_hd__clkdlybuf4s25_1
X_2551_ _5063_/Q _5047_/Q _5031_/Q _5015_/Q _2658_/S0 _2671_/S1 VGND VGND VPWR VPWR
+ _2552_/B sky130_fd_sc_hd__mux4_2
X_2482_ _4897_/Q _4881_/Q _5105_/Q _5089_/Q _5123_/Q _5124_/Q VGND VGND VPWR VPWR
+ _2482_/X sky130_fd_sc_hd__mux4_2
X_4221_ _4223_/A _4223_/C VGND VGND VPWR VPWR _4242_/B sky130_fd_sc_hd__and2_2
XFILLER_68_545 VGND VGND VPWR VPWR sky130_fd_sc_hd__decap_3
X_4152_ _4151_/X _4097_/Y _4340_/A VGND VGND VPWR VPWR _4248_/B sky130_fd_sc_hd__mux2_1
XFILLER_28_409 VGND VGND VPWR VPWR sky130_fd_sc_hd__decap_3
X_4083_ _4091_/A _4246_/A VGND VGND VPWR VPWR _4083_/X sky130_fd_sc_hd__or2_2
X_3103_ _2906_/X _3099_/B _3099_/Y _5014_/Q VGND VGND VPWR VPWR _5014_/D sky130_fd_sc_hd__a22o_2
X_3034_ _2926_/X _3024_/B _3024_/Y _4956_/Q VGND VGND VPWR VPWR _4956_/D sky130_fd_sc_hd__a22o_2
XFILLER_83_526 VGND VGND VPWR VPWR sky130_fd_sc_hd__decap_3
XFILLER_36_431 VGND VGND VPWR VPWR sky130_fd_sc_hd__decap_3
XFILLER_48_291 VGND VGND VPWR VPWR sky130_fd_sc_hd__fill_2
XFILLER_36_475 VGND VGND VPWR VPWR sky130_fd_sc_hd__fill_1
XFILLER_36_486 VGND VGND VPWR VPWR sky130_fd_sc_hd__decap_3
XFILLER_23_125 VGND VGND VPWR VPWR sky130_fd_sc_hd__decap_3
XFILLER_51_423 VGND VGND VPWR VPWR sky130_fd_sc_hd__decap_3
XFILLER_63_294 VGND VGND VPWR VPWR sky130_fd_sc_hd__decap_3
X_4985_ clkload9/A _4985_/D VGND VGND VPWR VPWR _4985_/Q sky130_fd_sc_hd__dfxtp_2
XFILLER_23_169 VGND VGND VPWR VPWR sky130_fd_sc_hd__decap_3
XFILLER_51_467 VGND VGND VPWR VPWR sky130_fd_sc_hd__decap_3
X_3936_ _3936_/A _3936_/B VGND VGND VPWR VPWR _4164_/B sky130_fd_sc_hd__nor2_2
X_3867_ _3867_/A _5177_/Q VGND VGND VPWR VPWR _3868_/B sky130_fd_sc_hd__and2_2
XPHY_EDGE_ROW_12_Left_106 VGND VGND VPWR VPWR sky130_fd_sc_hd__decap_3
X_3798_ _3831_/A _3797_/X _5130_/Q VGND VGND VPWR VPWR _3798_/X sky130_fd_sc_hd__o21a_2
X_2818_ _2816_/X _2817_/X _5133_/Q VGND VGND VPWR VPWR _2818_/X sky130_fd_sc_hd__mux2_1
XFILLER_11_36 VGND VGND VPWR VPWR sky130_fd_sc_hd__decap_3
X_2749_ _5111_/Q _4999_/Q _4983_/Q _4967_/Q _2812_/S0 _2848_/S1 VGND VGND VPWR VPWR
+ _2749_/X sky130_fd_sc_hd__mux4_2
XFILLER_78_309 VGND VGND VPWR VPWR sky130_fd_sc_hd__decap_3
X_4419_ _4419_/A _4642_/C VGND VGND VPWR VPWR _4641_/B sky130_fd_sc_hd__or2_2
XFILLER_59_545 VGND VGND VPWR VPWR sky130_fd_sc_hd__decap_3
XPHY_EDGE_ROW_21_Left_115 VGND VGND VPWR VPWR sky130_fd_sc_hd__decap_3
XFILLER_74_515 VGND VGND VPWR VPWR sky130_fd_sc_hd__decap_3
XFILLER_86_375 VGND VGND VPWR VPWR sky130_fd_sc_hd__fill_2
XFILLER_86_342 VGND VGND VPWR VPWR sky130_fd_sc_hd__decap_3
XFILLER_46_239 VGND VGND VPWR VPWR sky130_fd_sc_hd__decap_3
XFILLER_74_526 VGND VGND VPWR VPWR sky130_fd_sc_hd__decap_3
XFILLER_86_397 VGND VGND VPWR VPWR sky130_fd_sc_hd__decap_3
XFILLER_27_442 VGND VGND VPWR VPWR sky130_fd_sc_hd__decap_3
XFILLER_36_55 VGND VGND VPWR VPWR sky130_fd_sc_hd__decap_3
XTAP_TAPCELL_ROW_57_746 VGND VPWR sky130_fd_sc_hd__tapvpwrvgnd_1
XFILLER_27_475 VGND VGND VPWR VPWR sky130_fd_sc_hd__fill_1
XFILLER_36_88 VGND VGND VPWR VPWR sky130_fd_sc_hd__decap_3
XFILLER_42_412 VGND VGND VPWR VPWR sky130_fd_sc_hd__decap_3
XFILLER_14_147 VGND VGND VPWR VPWR sky130_fd_sc_hd__fill_2
XFILLER_42_456 VGND VGND VPWR VPWR sky130_fd_sc_hd__decap_3
XFILLER_52_32 VGND VGND VPWR VPWR sky130_fd_sc_hd__decap_3
XPHY_EDGE_ROW_30_Left_124 VGND VGND VPWR VPWR sky130_fd_sc_hd__decap_3
XTAP_TAPCELL_ROW_12_315 VGND VPWR sky130_fd_sc_hd__tapvpwrvgnd_1
XFILLER_10_342 VGND VGND VPWR VPWR sky130_fd_sc_hd__fill_2
XFILLER_6_302 VGND VGND VPWR VPWR sky130_fd_sc_hd__decap_3
Xinput19 INSTR_STREAM[26] VGND VGND VPWR VPWR _3440_/C sky130_fd_sc_hd__clkdlybuf4s25_1
XFILLER_6_335 VGND VGND VPWR VPWR sky130_fd_sc_hd__decap_3
XTAP_TAPCELL_ROW_20_392 VGND VPWR sky130_fd_sc_hd__tapvpwrvgnd_1
XFILLER_69_309 VGND VGND VPWR VPWR sky130_fd_sc_hd__decap_3
XFILLER_77_73 VGND VGND VPWR VPWR sky130_fd_sc_hd__decap_3
XFILLER_77_320 VGND VGND VPWR VPWR sky130_fd_sc_hd__decap_3
XFILLER_77_84 VGND VGND VPWR VPWR sky130_fd_sc_hd__decap_3
XFILLER_37_217 VGND VGND VPWR VPWR sky130_fd_sc_hd__decap_3
XFILLER_37_228 VGND VGND VPWR VPWR sky130_fd_sc_hd__decap_3
XFILLER_65_548 VGND VGND VPWR VPWR sky130_fd_sc_hd__decap_3
XFILLER_92_334 VGND VGND VPWR VPWR sky130_fd_sc_hd__decap_3
XFILLER_92_301 VGND VGND VPWR VPWR sky130_fd_sc_hd__decap_3
XFILLER_77_375 VGND VGND VPWR VPWR sky130_fd_sc_hd__decap_3
XFILLER_18_475 VGND VGND VPWR VPWR sky130_fd_sc_hd__fill_1
XFILLER_18_486 VGND VGND VPWR VPWR sky130_fd_sc_hd__decap_3
XFILLER_93_83 VGND VGND VPWR VPWR sky130_fd_sc_hd__fill_1
XFILLER_92_389 VGND VGND VPWR VPWR sky130_fd_sc_hd__decap_3
XFILLER_80_529 VGND VGND VPWR VPWR sky130_fd_sc_hd__decap_3
XTAP_TAPCELL_ROW_28_470 VGND VPWR sky130_fd_sc_hd__tapvpwrvgnd_1
XFILLER_60_242 VGND VGND VPWR VPWR sky130_fd_sc_hd__decap_3
XFILLER_60_253 VGND VGND VPWR VPWR sky130_fd_sc_hd__decap_3
X_4770_ _4763_/X _4769_/X _4136_/Y VGND VGND VPWR VPWR _4770_/X sky130_fd_sc_hd__a21o_2
XFILLER_13_191 VGND VGND VPWR VPWR sky130_fd_sc_hd__decap_3
X_3721_ _4957_/Q _4941_/Q _4925_/Q _4909_/Q _5127_/Q _3834_/S1 VGND VGND VPWR VPWR
+ _3721_/X sky130_fd_sc_hd__mux4_2
X_3652_ _3650_/X _3651_/Y _3646_/X VGND VGND VPWR VPWR _3652_/Y sky130_fd_sc_hd__o21ai_2
X_3583_ _3577_/A _3577_/Y _3581_/X _3582_/Y VGND VGND VPWR VPWR _3585_/B sky130_fd_sc_hd__o211a_2
X_2603_ _2596_/X _2598_/X _2601_/X _2435_/Y VGND VGND VPWR VPWR _4445_/B sky130_fd_sc_hd__a22o_2
X_2534_ _2529_/X _2530_/X _2533_/X _2435_/Y VGND VGND VPWR VPWR _4464_/B sky130_fd_sc_hd__a22o_2
X_5253_ _5253_/CLK _5253_/D VGND VGND VPWR VPWR _5253_/Q sky130_fd_sc_hd__dfxtp_2
X_2465_ _5263_/Q _2465_/B VGND VGND VPWR VPWR _4800_/B sky130_fd_sc_hd__nand2_2
XFILLER_87_106 VGND VGND VPWR VPWR sky130_fd_sc_hd__decap_3
X_4204_ _4294_/B VGND VGND VPWR VPWR _4204_/Y sky130_fd_sc_hd__inv_2
X_5184_ clkload5/A _5184_/D VGND VGND VPWR VPWR _5184_/Q sky130_fd_sc_hd__dfxtp_2
XFILLER_68_353 VGND VGND VPWR VPWR sky130_fd_sc_hd__decap_3
X_4135_ _3847_/B _3998_/Y _4002_/Y _2617_/A _4134_/Y VGND VGND VPWR VPWR _4135_/X
+ sky130_fd_sc_hd__a221o_2
XFILLER_83_301 VGND VGND VPWR VPWR sky130_fd_sc_hd__decap_3
X_4066_ _4107_/A _4066_/B VGND VGND VPWR VPWR _4088_/B sky130_fd_sc_hd__nor2_2
XFILLER_83_345 VGND VGND VPWR VPWR sky130_fd_sc_hd__decap_3
XFILLER_43_209 VGND VGND VPWR VPWR sky130_fd_sc_hd__decap_3
X_3017_ _2929_/X _3006_/B _3006_/Y _4941_/Q VGND VGND VPWR VPWR _4941_/D sky130_fd_sc_hd__a22o_2
XTAP_TAPCELL_ROW_54_716 VGND VPWR sky130_fd_sc_hd__tapvpwrvgnd_1
XFILLER_83_389 VGND VGND VPWR VPWR sky130_fd_sc_hd__decap_3
XFILLER_36_283 VGND VGND VPWR VPWR sky130_fd_sc_hd__decap_3
XFILLER_51_264 VGND VGND VPWR VPWR sky130_fd_sc_hd__fill_1
X_4968_ _5112_/CLK _4968_/D VGND VGND VPWR VPWR _4968_/Q sky130_fd_sc_hd__dfxtp_2
XTAP_TAPCELL_ROW_62_793 VGND VPWR sky130_fd_sc_hd__tapvpwrvgnd_1
X_4899_ _4982_/CLK _4899_/D VGND VGND VPWR VPWR _4899_/Q sky130_fd_sc_hd__dfxtp_2
X_3919_ _4223_/A _4223_/B VGND VGND VPWR VPWR _3919_/Y sky130_fd_sc_hd__nand2_2
XFILLER_0_6 VGND VGND VPWR VPWR sky130_fd_sc_hd__decap_3
XFILLER_19_228 VGND VGND VPWR VPWR sky130_fd_sc_hd__decap_3
XFILLER_47_43 VGND VGND VPWR VPWR sky130_fd_sc_hd__decap_3
XFILLER_47_526 VGND VGND VPWR VPWR sky130_fd_sc_hd__fill_2
XFILLER_86_161 VGND VGND VPWR VPWR sky130_fd_sc_hd__decap_3
XFILLER_86_194 VGND VGND VPWR VPWR sky130_fd_sc_hd__fill_2
XFILLER_34_209 VGND VGND VPWR VPWR sky130_fd_sc_hd__decap_3
XFILLER_62_518 VGND VGND VPWR VPWR sky130_fd_sc_hd__decap_3
XFILLER_42_253 VGND VGND VPWR VPWR sky130_fd_sc_hd__fill_1
XFILLER_70_551 VGND VGND VPWR VPWR sky130_fd_sc_hd__fill_2
XTAP_TAPCELL_ROW_25_440 VGND VPWR sky130_fd_sc_hd__tapvpwrvgnd_1
XPHY_EDGE_ROW_69_Right_69 VGND VGND VPWR VPWR sky130_fd_sc_hd__decap_3
XFILLER_42_275 VGND VGND VPWR VPWR sky130_fd_sc_hd__decap_3
XFILLER_63_97 VGND VGND VPWR VPWR sky130_fd_sc_hd__decap_3
XFILLER_8_37 VGND VGND VPWR VPWR sky130_fd_sc_hd__fill_1
XFILLER_8_59 VGND VGND VPWR VPWR sky130_fd_sc_hd__decap_3
XFILLER_10_194 VGND VGND VPWR VPWR sky130_fd_sc_hd__fill_2
XPHY_EDGE_ROW_78_Right_78 VGND VGND VPWR VPWR sky130_fd_sc_hd__decap_3
XFILLER_88_72 VGND VGND VPWR VPWR sky130_fd_sc_hd__fill_1
XFILLER_88_61 VGND VGND VPWR VPWR sky130_fd_sc_hd__decap_3
XFILLER_2_382 VGND VGND VPWR VPWR sky130_fd_sc_hd__fill_1
XFILLER_88_83 VGND VGND VPWR VPWR sky130_fd_sc_hd__fill_1
XFILLER_65_312 VGND VGND VPWR VPWR sky130_fd_sc_hd__decap_3
XFILLER_77_183 VGND VGND VPWR VPWR sky130_fd_sc_hd__decap_3
XFILLER_18_250 VGND VGND VPWR VPWR sky130_fd_sc_hd__fill_2
XFILLER_53_529 VGND VGND VPWR VPWR sky130_fd_sc_hd__decap_3
XFILLER_65_367 VGND VGND VPWR VPWR sky130_fd_sc_hd__decap_3
XFILLER_80_315 VGND VGND VPWR VPWR sky130_fd_sc_hd__decap_3
XPHY_EDGE_ROW_87_Right_87 VGND VGND VPWR VPWR sky130_fd_sc_hd__decap_3
XFILLER_92_197 VGND VGND VPWR VPWR sky130_fd_sc_hd__decap_3
XFILLER_33_242 VGND VGND VPWR VPWR sky130_fd_sc_hd__decap_3
XFILLER_61_551 VGND VGND VPWR VPWR sky130_fd_sc_hd__fill_2
X_4822_ input41/X _4816_/Y _4821_/X _3442_/B VGND VGND VPWR VPWR _5240_/D sky130_fd_sc_hd__o211a_2
X_4753_ _4621_/Y _4641_/X _4749_/X _4752_/Y VGND VGND VPWR VPWR _4753_/X sky130_fd_sc_hd__o211a_2
X_3704_ _4717_/S _4716_/A VGND VGND VPWR VPWR _4218_/A sky130_fd_sc_hd__nor2_2
X_4684_ _4670_/Y _4683_/X _4866_/A VGND VGND VPWR VPWR _5228_/D sky130_fd_sc_hd__a21oi_2
XTAP_TAPCELL_ROW_31_498 VGND VPWR sky130_fd_sc_hd__tapvpwrvgnd_1
X_3635_ _3633_/A _4025_/B _4063_/A VGND VGND VPWR VPWR _4108_/A sky130_fd_sc_hd__mux2_1
X_3566_ _3563_/A _3563_/B _3561_/A VGND VGND VPWR VPWR _3570_/A sky130_fd_sc_hd__o21a_2
X_3497_ _3497_/A _3585_/A _3495_/X VGND VGND VPWR VPWR _3497_/X sky130_fd_sc_hd__or3b_2
X_2517_ _4890_/Q _4874_/Q _5098_/Q _5082_/Q _2658_/S0 _2671_/S1 VGND VGND VPWR VPWR
+ _2518_/B sky130_fd_sc_hd__mux4_2
XFILLER_88_415 VGND VGND VPWR VPWR sky130_fd_sc_hd__decap_3
X_5236_ _5252_/CLK _5236_/D VGND VGND VPWR VPWR _5236_/Q sky130_fd_sc_hd__dfxtp_2
X_2448_ _2889_/A _5180_/Q _2889_/C VGND VGND VPWR VPWR _2887_/B sky130_fd_sc_hd__or3b_2
XFILLER_56_301 VGND VGND VPWR VPWR sky130_fd_sc_hd__decap_3
XFILLER_56_312 VGND VGND VPWR VPWR sky130_fd_sc_hd__decap_3
XFILLER_68_172 VGND VGND VPWR VPWR sky130_fd_sc_hd__decap_3
X_5167_ _5252_/CLK _5167_/D VGND VGND VPWR VPWR _5167_/Q sky130_fd_sc_hd__dfxtp_2
XFILLER_29_548 VGND VGND VPWR VPWR sky130_fd_sc_hd__decap_3
X_4118_ _5210_/Q _4168_/A VGND VGND VPWR VPWR _4118_/X sky130_fd_sc_hd__or2_2
X_5098_ _5098_/CLK _5098_/D VGND VGND VPWR VPWR _5098_/Q sky130_fd_sc_hd__dfxtp_2
XTAP_TAPCELL_ROW_67_841 VGND VPWR sky130_fd_sc_hd__tapvpwrvgnd_1
XFILLER_83_131 VGND VGND VPWR VPWR sky130_fd_sc_hd__decap_3
XFILLER_16_209 VGND VGND VPWR VPWR sky130_fd_sc_hd__decap_3
XFILLER_44_529 VGND VGND VPWR VPWR sky130_fd_sc_hd__decap_3
XFILLER_56_389 VGND VGND VPWR VPWR sky130_fd_sc_hd__decap_3
XFILLER_71_315 VGND VGND VPWR VPWR sky130_fd_sc_hd__decap_3
X_4049_ _3809_/B _4371_/B _4632_/A _2585_/A _3847_/A VGND VGND VPWR VPWR _4049_/Y
+ sky130_fd_sc_hd__o221ai_2
XTAP_TAPCELL_ROW_39_576 VGND VPWR sky130_fd_sc_hd__tapvpwrvgnd_1
XFILLER_83_175 VGND VGND VPWR VPWR sky130_fd_sc_hd__decap_3
XFILLER_17_57 VGND VGND VPWR VPWR sky130_fd_sc_hd__fill_2
XFILLER_17_79 VGND VGND VPWR VPWR sky130_fd_sc_hd__decap_3
XFILLER_71_337 VGND VGND VPWR VPWR sky130_fd_sc_hd__decap_3
XFILLER_83_197 VGND VGND VPWR VPWR sky130_fd_sc_hd__decap_3
XTAP_TAPCELL_ROW_22_410 VGND VPWR sky130_fd_sc_hd__tapvpwrvgnd_1
XFILLER_8_419 VGND VGND VPWR VPWR sky130_fd_sc_hd__fill_1
XFILLER_59_172 VGND VGND VPWR VPWR sky130_fd_sc_hd__decap_3
XFILLER_87_492 VGND VGND VPWR VPWR sky130_fd_sc_hd__decap_3
XFILLER_47_378 VGND VGND VPWR VPWR sky130_fd_sc_hd__decap_3
XFILLER_62_315 VGND VGND VPWR VPWR sky130_fd_sc_hd__decap_3
XFILLER_74_164 VGND VGND VPWR VPWR sky130_fd_sc_hd__decap_3
XFILLER_62_337 VGND VGND VPWR VPWR sky130_fd_sc_hd__decap_3
XFILLER_74_197 VGND VGND VPWR VPWR sky130_fd_sc_hd__fill_2
XFILLER_74_85 VGND VGND VPWR VPWR sky130_fd_sc_hd__decap_3
XFILLER_15_231 VGND VGND VPWR VPWR sky130_fd_sc_hd__decap_3
XFILLER_30_212 VGND VGND VPWR VPWR sky130_fd_sc_hd__decap_3
XTAP_TAPCELL_ROW_73_899 VGND VPWR sky130_fd_sc_hd__tapvpwrvgnd_1
XFILLER_70_392 VGND VGND VPWR VPWR sky130_fd_sc_hd__decap_3
Xmax_cap116 _3080_/Y VGND VGND VPWR VPWR _3096_/B1 sky130_fd_sc_hd__clkbuf_8
XFILLER_7_452 VGND VGND VPWR VPWR sky130_fd_sc_hd__decap_3
Xmax_cap127 _3061_/B VGND VGND VPWR VPWR _3074_/A2 sky130_fd_sc_hd__buf_6
Xmax_cap138 _4279_/B VGND VGND VPWR VPWR _4360_/B sky130_fd_sc_hd__buf_6
Xmax_cap149 _4714_/A VGND VGND VPWR VPWR _4866_/A sky130_fd_sc_hd__buf_12
X_3420_ _5260_/Q _3448_/B _3420_/C VGND VGND VPWR VPWR _3420_/X sky130_fd_sc_hd__and3_2
XFILLER_7_496 VGND VGND VPWR VPWR sky130_fd_sc_hd__decap_3
X_3351_ _5143_/Q _3337_/A _3350_/Y _3442_/B VGND VGND VPWR VPWR _5143_/D sky130_fd_sc_hd__o211a_2
X_3282_ _3273_/A _3273_/B _3270_/A VGND VGND VPWR VPWR _3283_/B sky130_fd_sc_hd__o21bai_2
X_5021_ _5210_/CLK _5021_/D VGND VGND VPWR VPWR _5021_/Q sky130_fd_sc_hd__dfxtp_2
XFILLER_85_429 VGND VGND VPWR VPWR sky130_fd_sc_hd__decap_3
XFILLER_38_323 VGND VGND VPWR VPWR sky130_fd_sc_hd__decap_3
XFILLER_38_345 VGND VGND VPWR VPWR sky130_fd_sc_hd__decap_3
XTAP_TAPCELL_ROW_64_811 VGND VPWR sky130_fd_sc_hd__tapvpwrvgnd_1
XFILLER_93_473 VGND VGND VPWR VPWR sky130_fd_sc_hd__decap_3
XFILLER_0_60 VGND VGND VPWR VPWR sky130_fd_sc_hd__decap_3
XFILLER_53_337 VGND VGND VPWR VPWR sky130_fd_sc_hd__decap_3
XFILLER_65_175 VGND VGND VPWR VPWR sky130_fd_sc_hd__decap_3
XFILLER_93_495 VGND VGND VPWR VPWR sky130_fd_sc_hd__decap_3
XFILLER_80_134 VGND VGND VPWR VPWR sky130_fd_sc_hd__decap_3
XTAP_TAPCELL_ROW_36_546 VGND VPWR sky130_fd_sc_hd__tapvpwrvgnd_1
XFILLER_80_167 VGND VGND VPWR VPWR sky130_fd_sc_hd__fill_1
XFILLER_21_212 VGND VGND VPWR VPWR sky130_fd_sc_hd__fill_2
X_4805_ _4635_/B _4803_/X _4804_/Y _4695_/A _4537_/X VGND VGND VPWR VPWR _4806_/B
+ sky130_fd_sc_hd__a32o_2
X_2997_ _2926_/X _2987_/B _2987_/Y _4924_/Q VGND VGND VPWR VPWR _4924_/D sky130_fd_sc_hd__a22o_2
XFILLER_21_289 VGND VGND VPWR VPWR sky130_fd_sc_hd__decap_3
X_4736_ _4432_/B _3634_/S _3627_/Y VGND VGND VPWR VPWR _4736_/Y sky130_fd_sc_hd__o21ai_2
X_4667_ _4635_/Y _4661_/Y _4666_/X _4657_/X VGND VGND VPWR VPWR _4667_/X sky130_fd_sc_hd__o211a_2
X_3618_ _4883_/Q _4867_/Q _5091_/Q _5075_/Q _3834_/S0 _3834_/S1 VGND VGND VPWR VPWR
+ _3618_/X sky130_fd_sc_hd__mux4_2
X_4598_ _4574_/Y _4576_/X _4597_/X _4136_/Y VGND VGND VPWR VPWR _4598_/X sky130_fd_sc_hd__a31o_2
XFILLER_0_105 VGND VGND VPWR VPWR sky130_fd_sc_hd__decap_3
XFILLER_0_116 VGND VGND VPWR VPWR sky130_fd_sc_hd__decap_3
XFILLER_0_127 VGND VGND VPWR VPWR sky130_fd_sc_hd__decap_3
X_3549_ _3549_/A _3549_/B _3549_/C VGND VGND VPWR VPWR _3549_/Y sky130_fd_sc_hd__nor3_2
XFILLER_88_256 VGND VGND VPWR VPWR sky130_fd_sc_hd__decap_3
XFILLER_48_109 VGND VGND VPWR VPWR sky130_fd_sc_hd__decap_3
X_5219_ _5252_/CLK _5219_/D VGND VGND VPWR VPWR _5219_/Q sky130_fd_sc_hd__dfxtp_2
XFILLER_56_131 VGND VGND VPWR VPWR sky130_fd_sc_hd__fill_2
XFILLER_56_164 VGND VGND VPWR VPWR sky130_fd_sc_hd__fill_2
XFILLER_29_389 VGND VGND VPWR VPWR sky130_fd_sc_hd__decap_3
XFILLER_44_337 VGND VGND VPWR VPWR sky130_fd_sc_hd__fill_2
XFILLER_84_495 VGND VGND VPWR VPWR sky130_fd_sc_hd__decap_3
XFILLER_25_540 VGND VGND VPWR VPWR sky130_fd_sc_hd__decap_3
XFILLER_44_359 VGND VGND VPWR VPWR sky130_fd_sc_hd__decap_3
XFILLER_44_44 VGND VGND VPWR VPWR sky130_fd_sc_hd__decap_3
XFILLER_40_510 VGND VGND VPWR VPWR sky130_fd_sc_hd__fill_2
XTAP_TAPCELL_ROW_70_869 VGND VPWR sky130_fd_sc_hd__tapvpwrvgnd_1
XFILLER_12_267 VGND VGND VPWR VPWR sky130_fd_sc_hd__decap_3
XFILLER_60_65 VGND VGND VPWR VPWR sky130_fd_sc_hd__decap_3
XFILLER_4_433 VGND VGND VPWR VPWR sky130_fd_sc_hd__decap_3
XFILLER_4_477 VGND VGND VPWR VPWR sky130_fd_sc_hd__decap_3
XFILLER_69_63 VGND VGND VPWR VPWR sky130_fd_sc_hd__decap_3
XFILLER_79_267 VGND VGND VPWR VPWR sky130_fd_sc_hd__decap_3
XFILLER_79_245 VGND VGND VPWR VPWR sky130_fd_sc_hd__decap_3
XTAP_TAPCELL_ROW_7_271 VGND VPWR sky130_fd_sc_hd__tapvpwrvgnd_1
XTAP_TAPCELL_ROW_78_947 VGND VPWR sky130_fd_sc_hd__tapvpwrvgnd_1
XFILLER_75_440 VGND VGND VPWR VPWR sky130_fd_sc_hd__decap_3
XFILLER_47_142 VGND VGND VPWR VPWR sky130_fd_sc_hd__decap_3
XFILLER_47_186 VGND VGND VPWR VPWR sky130_fd_sc_hd__decap_3
XFILLER_90_432 VGND VGND VPWR VPWR sky130_fd_sc_hd__fill_1
XFILLER_90_421 VGND VGND VPWR VPWR sky130_fd_sc_hd__fill_1
XFILLER_90_410 VGND VGND VPWR VPWR sky130_fd_sc_hd__decap_3
XFILLER_16_551 VGND VGND VPWR VPWR sky130_fd_sc_hd__fill_2
XFILLER_35_348 VGND VGND VPWR VPWR sky130_fd_sc_hd__fill_1
XFILLER_50_318 VGND VGND VPWR VPWR sky130_fd_sc_hd__decap_3
X_2920_ _4874_/Q _2936_/A2 _2919_/X _2936_/B2 VGND VGND VPWR VPWR _4874_/D sky130_fd_sc_hd__a22o_2
XTAP_TAPCELL_ROW_33_516 VGND VPWR sky130_fd_sc_hd__tapvpwrvgnd_1
XFILLER_43_381 VGND VGND VPWR VPWR sky130_fd_sc_hd__fill_2
X_2851_ _2851_/A _3397_/B VGND VGND VPWR VPWR _2851_/X sky130_fd_sc_hd__and2_2
X_2782_ _2780_/X _2781_/X _5133_/Q VGND VGND VPWR VPWR _2782_/X sky130_fd_sc_hd__mux2_1
XTAP_TAPCELL_ROW_41_593 VGND VPWR sky130_fd_sc_hd__tapvpwrvgnd_1
XFILLER_79_3 VGND VGND VPWR VPWR sky130_fd_sc_hd__fill_1
X_4521_ _4464_/A _4523_/S _4225_/X VGND VGND VPWR VPWR _4521_/Y sky130_fd_sc_hd__o21ai_2
X_4452_ _4452_/A _4452_/B VGND VGND VPWR VPWR _4461_/A sky130_fd_sc_hd__xnor2_2
XFILLER_7_293 VGND VGND VPWR VPWR sky130_fd_sc_hd__decap_3
X_3403_ _5152_/Q _3403_/B VGND VGND VPWR VPWR _3403_/X sky130_fd_sc_hd__xor2_2
X_4383_ _4464_/A _4466_/A VGND VGND VPWR VPWR _4475_/A sky130_fd_sc_hd__nor2_2
X_3334_ _5160_/Q _3323_/B _3324_/X VGND VGND VPWR VPWR _3335_/B sky130_fd_sc_hd__a21o_2
X_3265_ _5185_/Q _3265_/B VGND VGND VPWR VPWR _3265_/Y sky130_fd_sc_hd__nand2_2
X_5004_ _5117_/CLK _5004_/D VGND VGND VPWR VPWR _5004_/Q sky130_fd_sc_hd__dfxtp_2
XFILLER_66_451 VGND VGND VPWR VPWR sky130_fd_sc_hd__decap_3
X_3196_ _2913_/X _3203_/A2 _3203_/B1 _5096_/Q VGND VGND VPWR VPWR _5096_/D sky130_fd_sc_hd__a22o_2
XFILLER_26_315 VGND VGND VPWR VPWR sky130_fd_sc_hd__fill_1
XFILLER_38_197 VGND VGND VPWR VPWR sky130_fd_sc_hd__decap_3
XTAP_TAPCELL_ROW_49_671 VGND VPWR sky130_fd_sc_hd__tapvpwrvgnd_1
XFILLER_93_281 VGND VGND VPWR VPWR sky130_fd_sc_hd__decap_3
XFILLER_81_421 VGND VGND VPWR VPWR sky130_fd_sc_hd__decap_3
XFILLER_22_510 VGND VGND VPWR VPWR sky130_fd_sc_hd__decap_3
XFILLER_53_189 VGND VGND VPWR VPWR sky130_fd_sc_hd__decap_3
X_4719_ _4547_/A _2638_/B _4218_/A _4246_/A _4716_/Y VGND VGND VPWR VPWR _4719_/X
+ sky130_fd_sc_hd__o221a_2
XFILLER_30_35 VGND VGND VPWR VPWR sky130_fd_sc_hd__decap_3
XFILLER_39_22 VGND VGND VPWR VPWR sky130_fd_sc_hd__fill_1
XFILLER_49_429 VGND VGND VPWR VPWR sky130_fd_sc_hd__decap_3
XTAP_TAPCELL_ROW_4_241 VGND VPWR sky130_fd_sc_hd__tapvpwrvgnd_1
XFILLER_17_304 VGND VGND VPWR VPWR sky130_fd_sc_hd__decap_3
XFILLER_29_131 VGND VGND VPWR VPWR sky130_fd_sc_hd__decap_3
XTAP_TAPCELL_ROW_75_917 VGND VPWR sky130_fd_sc_hd__tapvpwrvgnd_1
XFILLER_44_112 VGND VGND VPWR VPWR sky130_fd_sc_hd__fill_1
XFILLER_55_43 VGND VGND VPWR VPWR sky130_fd_sc_hd__decap_3
XFILLER_57_484 VGND VGND VPWR VPWR sky130_fd_sc_hd__decap_3
XFILLER_72_421 VGND VGND VPWR VPWR sky130_fd_sc_hd__fill_1
XFILLER_44_123 VGND VGND VPWR VPWR sky130_fd_sc_hd__decap_3
XFILLER_55_87 VGND VGND VPWR VPWR sky130_fd_sc_hd__decap_3
XFILLER_72_443 VGND VGND VPWR VPWR sky130_fd_sc_hd__decap_3
XFILLER_32_318 VGND VGND VPWR VPWR sky130_fd_sc_hd__decap_3
XFILLER_72_498 VGND VGND VPWR VPWR sky130_fd_sc_hd__decap_3
XTAP_TAPCELL_ROW_83_994 VGND VPWR sky130_fd_sc_hd__tapvpwrvgnd_1
XFILLER_71_20 VGND VGND VPWR VPWR sky130_fd_sc_hd__decap_3
XFILLER_71_53 VGND VGND VPWR VPWR sky130_fd_sc_hd__decap_3
XFILLER_9_525 VGND VGND VPWR VPWR sky130_fd_sc_hd__fill_1
XFILLER_40_373 VGND VGND VPWR VPWR sky130_fd_sc_hd__decap_3
XTAP_TAPCELL_ROW_10_298 VGND VPWR sky130_fd_sc_hd__tapvpwrvgnd_1
XFILLER_4_274 VGND VGND VPWR VPWR sky130_fd_sc_hd__decap_3
XFILLER_0_480 VGND VGND VPWR VPWR sky130_fd_sc_hd__decap_3
XFILLER_67_237 VGND VGND VPWR VPWR sky130_fd_sc_hd__decap_3
X_3050_ _2916_/X _3056_/A2 _3043_/Y _4969_/Q VGND VGND VPWR VPWR _4969_/D sky130_fd_sc_hd__a22o_2
XFILLER_48_440 VGND VGND VPWR VPWR sky130_fd_sc_hd__decap_3
XFILLER_48_462 VGND VGND VPWR VPWR sky130_fd_sc_hd__decap_3
XFILLER_63_421 VGND VGND VPWR VPWR sky130_fd_sc_hd__fill_1
XFILLER_75_281 VGND VGND VPWR VPWR sky130_fd_sc_hd__decap_3
XTAP_TAPCELL_ROW_85_1013 VGND VPWR sky130_fd_sc_hd__tapvpwrvgnd_1
XFILLER_35_145 VGND VGND VPWR VPWR sky130_fd_sc_hd__decap_3
XTAP_TAPCELL_ROW_46_641 VGND VPWR sky130_fd_sc_hd__tapvpwrvgnd_1
XFILLER_23_318 VGND VGND VPWR VPWR sky130_fd_sc_hd__decap_3
XFILLER_63_476 VGND VGND VPWR VPWR sky130_fd_sc_hd__decap_3
XTAP_TAPCELL_ROW_18_376 VGND VPWR sky130_fd_sc_hd__tapvpwrvgnd_1
X_3952_ _4453_/B _4787_/S VGND VGND VPWR VPWR _3952_/Y sky130_fd_sc_hd__nand2_2
XFILLER_90_284 VGND VGND VPWR VPWR sky130_fd_sc_hd__decap_3
XFILLER_31_340 VGND VGND VPWR VPWR sky130_fd_sc_hd__fill_2
X_3883_ _4479_/B _3883_/B VGND VGND VPWR VPWR _3883_/Y sky130_fd_sc_hd__nor2_2
X_2903_ _5192_/Q _2455_/X _3456_/B _5240_/Q _2902_/X VGND VGND VPWR VPWR _2903_/X
+ sky130_fd_sc_hd__a221o_2
X_2834_ _4897_/Q _4881_/Q _5105_/Q _5089_/Q _5131_/Q _5132_/Q VGND VGND VPWR VPWR
+ _2834_/X sky130_fd_sc_hd__mux4_2
X_4504_ _4504_/A _4504_/B VGND VGND VPWR VPWR _4506_/B sky130_fd_sc_hd__xnor2_2
X_2765_ _5113_/Q _5001_/Q _4985_/Q _4969_/Q _5131_/Q _2848_/S1 VGND VGND VPWR VPWR
+ _2766_/B sky130_fd_sc_hd__mux4_2
X_2696_ _2887_/B _2696_/B VGND VGND VPWR VPWR _2701_/B sky130_fd_sc_hd__or2_2
XFILLER_6_81 VGND VGND VPWR VPWR sky130_fd_sc_hd__decap_3
X_4435_ _4464_/A _4466_/B VGND VGND VPWR VPWR _4435_/Y sky130_fd_sc_hd__nor2_2
X_4366_ _4340_/A _4316_/X _4619_/A _4365_/Y _4297_/A VGND VGND VPWR VPWR _4366_/X
+ sky130_fd_sc_hd__a221o_2
X_3317_ _5140_/Q _5139_/Q _3317_/C VGND VGND VPWR VPWR _3327_/B sky130_fd_sc_hd__and3_2
XFILLER_86_513 VGND VGND VPWR VPWR sky130_fd_sc_hd__decap_3
XFILLER_58_237 VGND VGND VPWR VPWR sky130_fd_sc_hd__decap_3
X_4297_ _4297_/A _4297_/B VGND VGND VPWR VPWR _4297_/Y sky130_fd_sc_hd__nor2_2
X_3248_ _5173_/Q _3227_/X _3247_/X VGND VGND VPWR VPWR _4864_/B sky130_fd_sc_hd__a21oi_2
XFILLER_54_421 VGND VGND VPWR VPWR sky130_fd_sc_hd__decap_3
XFILLER_73_218 VGND VGND VPWR VPWR sky130_fd_sc_hd__decap_3
X_3179_ _2916_/X _3185_/A2 _3185_/B1 _5081_/Q VGND VGND VPWR VPWR _5081_/D sky130_fd_sc_hd__a22o_2
XTAP_TAPCELL_ROW_1_211 VGND VPWR sky130_fd_sc_hd__tapvpwrvgnd_1
XFILLER_26_134 VGND VGND VPWR VPWR sky130_fd_sc_hd__decap_3
XFILLER_54_454 VGND VGND VPWR VPWR sky130_fd_sc_hd__decap_3
XFILLER_66_292 VGND VGND VPWR VPWR sky130_fd_sc_hd__decap_3
XFILLER_14_307 VGND VGND VPWR VPWR sky130_fd_sc_hd__fill_1
XFILLER_26_167 VGND VGND VPWR VPWR sky130_fd_sc_hd__decap_3
XFILLER_81_273 VGND VGND VPWR VPWR sky130_fd_sc_hd__decap_3
XFILLER_25_57 VGND VGND VPWR VPWR sky130_fd_sc_hd__fill_1
XFILLER_81_284 VGND VGND VPWR VPWR sky130_fd_sc_hd__decap_3
XFILLER_22_362 VGND VGND VPWR VPWR sky130_fd_sc_hd__fill_2
XTAP_TAPCELL_ROW_80_964 VGND VPWR sky130_fd_sc_hd__tapvpwrvgnd_1
XFILLER_22_395 VGND VGND VPWR VPWR sky130_fd_sc_hd__decap_3
XTAP_TAPCELL_ROW_52_699 VGND VPWR sky130_fd_sc_hd__tapvpwrvgnd_1
XFILLER_41_78 VGND VGND VPWR VPWR sky130_fd_sc_hd__decap_3
XFILLER_41_89 VGND VGND VPWR VPWR sky130_fd_sc_hd__decap_3
XFILLER_9_3 VGND VGND VPWR VPWR sky130_fd_sc_hd__fill_1
XFILLER_1_277 VGND VGND VPWR VPWR sky130_fd_sc_hd__decap_3
XFILLER_89_384 VGND VGND VPWR VPWR sky130_fd_sc_hd__decap_3
XFILLER_57_281 VGND VGND VPWR VPWR sky130_fd_sc_hd__fill_1
XFILLER_92_538 VGND VGND VPWR VPWR sky130_fd_sc_hd__decap_3
XFILLER_92_527 VGND VGND VPWR VPWR sky130_fd_sc_hd__decap_3
XFILLER_17_178 VGND VGND VPWR VPWR sky130_fd_sc_hd__decap_3
XFILLER_45_487 VGND VGND VPWR VPWR sky130_fd_sc_hd__decap_3
XFILLER_72_273 VGND VGND VPWR VPWR sky130_fd_sc_hd__decap_3
XFILLER_82_41 VGND VGND VPWR VPWR sky130_fd_sc_hd__decap_3
XFILLER_60_424 VGND VGND VPWR VPWR sky130_fd_sc_hd__decap_3
XTAP_TAPCELL_ROW_43_611 VGND VPWR sky130_fd_sc_hd__tapvpwrvgnd_1
XFILLER_13_340 VGND VGND VPWR VPWR sky130_fd_sc_hd__fill_1
XFILLER_60_457 VGND VGND VPWR VPWR sky130_fd_sc_hd__decap_3
XTAP_TAPCELL_ROW_15_346 VGND VPWR sky130_fd_sc_hd__tapvpwrvgnd_1
XFILLER_82_85 VGND VGND VPWR VPWR sky130_fd_sc_hd__decap_3
XFILLER_40_170 VGND VGND VPWR VPWR sky130_fd_sc_hd__decap_3
XFILLER_40_181 VGND VGND VPWR VPWR sky130_fd_sc_hd__decap_3
Xoutput107 _2797_/X VGND VGND VPWR VPWR MEM_STR_DATA[9] sky130_fd_sc_hd__clkdlybuf4s25_1
X_2550_ _4887_/Q _4871_/Q _5095_/Q _5079_/Q _2658_/S0 _2671_/S1 VGND VGND VPWR VPWR
+ _2550_/X sky130_fd_sc_hd__mux4_2
X_2481_ _2667_/A _2481_/B VGND VGND VPWR VPWR _2481_/X sky130_fd_sc_hd__or2_2
X_4220_ _4218_/A _3903_/B _3905_/B _4246_/A VGND VGND VPWR VPWR _4220_/X sky130_fd_sc_hd__a31o_2
XFILLER_68_513 VGND VGND VPWR VPWR sky130_fd_sc_hd__decap_3
X_4151_ _4464_/B _4466_/A _4523_/S VGND VGND VPWR VPWR _4151_/X sky130_fd_sc_hd__mux2_1
XFILLER_55_207 VGND VGND VPWR VPWR sky130_fd_sc_hd__decap_3
X_4082_ _5178_/Q _3930_/Y _4001_/B _3876_/A VGND VGND VPWR VPWR _4087_/C sky130_fd_sc_hd__o211a_2
X_3102_ _2903_/X _3099_/B _3099_/Y _5013_/Q VGND VGND VPWR VPWR _5013_/D sky130_fd_sc_hd__a22o_2
XFILLER_36_410 VGND VGND VPWR VPWR sky130_fd_sc_hd__decap_3
X_3033_ _2922_/X _3024_/B _3024_/Y _4955_/Q VGND VGND VPWR VPWR _4955_/D sky130_fd_sc_hd__a22o_2
XFILLER_83_549 VGND VGND VPWR VPWR sky130_fd_sc_hd__decap_3
XFILLER_36_421 VGND VGND VPWR VPWR sky130_fd_sc_hd__fill_2
XFILLER_23_104 VGND VGND VPWR VPWR sky130_fd_sc_hd__decap_3
XFILLER_23_137 VGND VGND VPWR VPWR sky130_fd_sc_hd__fill_1
XFILLER_51_435 VGND VGND VPWR VPWR sky130_fd_sc_hd__decap_3
X_4984_ _5112_/CLK _4984_/D VGND VGND VPWR VPWR _4984_/Q sky130_fd_sc_hd__dfxtp_2
XFILLER_51_479 VGND VGND VPWR VPWR sky130_fd_sc_hd__decap_3
X_3935_ _3932_/A _3932_/B _2618_/Y _3932_/C _3934_/Y VGND VGND VPWR VPWR _3936_/B
+ sky130_fd_sc_hd__a41o_2
X_3866_ _4482_/S _4003_/A VGND VGND VPWR VPWR _3866_/Y sky130_fd_sc_hd__nand2_2
X_3797_ _5066_/Q _5050_/Q _5034_/Q _5018_/Q _3834_/S0 _3834_/S1 VGND VGND VPWR VPWR
+ _3797_/X sky130_fd_sc_hd__mux4_2
X_2817_ _5071_/Q _5055_/Q _5039_/Q _5023_/Q _5131_/Q _2848_/S1 VGND VGND VPWR VPWR
+ _2817_/X sky130_fd_sc_hd__mux4_2
XFILLER_11_48 VGND VGND VPWR VPWR sky130_fd_sc_hd__decap_3
X_2748_ _2831_/S _2748_/B VGND VGND VPWR VPWR _2748_/X sky130_fd_sc_hd__or2_2
X_4418_ _4408_/S _4535_/B _4393_/Y VGND VGND VPWR VPWR _4642_/C sky130_fd_sc_hd__o21a_2
X_2679_ _2870_/A _2679_/B _3922_/A _3682_/D VGND VGND VPWR VPWR _2881_/B sky130_fd_sc_hd__nand4_2
X_4349_ _3668_/B _4160_/X _4172_/X VGND VGND VPWR VPWR _4350_/B sky130_fd_sc_hd__o21ai_2
XFILLER_86_321 VGND VGND VPWR VPWR sky130_fd_sc_hd__decap_3
XFILLER_86_354 VGND VGND VPWR VPWR sky130_fd_sc_hd__decap_3
XFILLER_46_218 VGND VGND VPWR VPWR sky130_fd_sc_hd__decap_3
XFILLER_74_549 VGND VGND VPWR VPWR sky130_fd_sc_hd__decap_3
XFILLER_39_281 VGND VGND VPWR VPWR sky130_fd_sc_hd__decap_3
XTAP_TAPCELL_ROW_57_747 VGND VPWR sky130_fd_sc_hd__tapvpwrvgnd_1
XFILLER_27_487 VGND VGND VPWR VPWR sky130_fd_sc_hd__decap_3
XFILLER_36_67 VGND VGND VPWR VPWR sky130_fd_sc_hd__decap_3
XFILLER_14_126 VGND VGND VPWR VPWR sky130_fd_sc_hd__decap_3
XFILLER_42_424 VGND VGND VPWR VPWR sky130_fd_sc_hd__decap_3
XFILLER_22_170 VGND VGND VPWR VPWR sky130_fd_sc_hd__decap_3
XFILLER_52_44 VGND VGND VPWR VPWR sky130_fd_sc_hd__decap_3
XTAP_TAPCELL_ROW_12_316 VGND VPWR sky130_fd_sc_hd__tapvpwrvgnd_1
XFILLER_10_321 VGND VGND VPWR VPWR sky130_fd_sc_hd__decap_3
XFILLER_52_88 VGND VGND VPWR VPWR sky130_fd_sc_hd__decap_3
XFILLER_10_398 VGND VGND VPWR VPWR sky130_fd_sc_hd__fill_2
XFILLER_6_347 VGND VGND VPWR VPWR sky130_fd_sc_hd__decap_3
XTAP_TAPCELL_ROW_20_393 VGND VPWR sky130_fd_sc_hd__tapvpwrvgnd_1
XFILLER_77_332 VGND VGND VPWR VPWR sky130_fd_sc_hd__decap_3
XFILLER_65_505 VGND VGND VPWR VPWR sky130_fd_sc_hd__decap_3
XFILLER_77_96 VGND VGND VPWR VPWR sky130_fd_sc_hd__decap_3
XFILLER_77_343 VGND VGND VPWR VPWR sky130_fd_sc_hd__decap_3
XFILLER_77_387 VGND VGND VPWR VPWR sky130_fd_sc_hd__decap_3
XFILLER_18_421 VGND VGND VPWR VPWR sky130_fd_sc_hd__decap_3
XFILLER_93_51 VGND VGND VPWR VPWR sky130_fd_sc_hd__decap_3
XFILLER_92_346 VGND VGND VPWR VPWR sky130_fd_sc_hd__decap_3
XFILLER_18_454 VGND VGND VPWR VPWR sky130_fd_sc_hd__decap_3
XFILLER_45_251 VGND VGND VPWR VPWR sky130_fd_sc_hd__decap_3
XFILLER_18_498 VGND VGND VPWR VPWR sky130_fd_sc_hd__decap_3
XFILLER_33_446 VGND VGND VPWR VPWR sky130_fd_sc_hd__fill_2
XFILLER_45_284 VGND VGND VPWR VPWR sky130_fd_sc_hd__decap_3
XFILLER_60_221 VGND VGND VPWR VPWR sky130_fd_sc_hd__decap_3
XTAP_TAPCELL_ROW_28_471 VGND VPWR sky130_fd_sc_hd__tapvpwrvgnd_1
XFILLER_60_298 VGND VGND VPWR VPWR sky130_fd_sc_hd__decap_3
X_3720_ _5117_/Q _5005_/Q _4989_/Q _4973_/Q _5127_/Q _3834_/S1 VGND VGND VPWR VPWR
+ _3720_/X sky130_fd_sc_hd__mux4_2
XFILLER_41_490 VGND VGND VPWR VPWR sky130_fd_sc_hd__decap_3
X_3651_ _4107_/B _4208_/B VGND VGND VPWR VPWR _3651_/Y sky130_fd_sc_hd__nand2_2
X_3582_ _5167_/Q _5148_/Q VGND VGND VPWR VPWR _3582_/Y sky130_fd_sc_hd__nand2_2
X_2602_ _2596_/X _2598_/X _2601_/X _2435_/Y VGND VGND VPWR VPWR _4493_/B sky130_fd_sc_hd__a22oi_2
XFILLER_9_196 VGND VGND VPWR VPWR sky130_fd_sc_hd__fill_1
X_2533_ _2531_/X _2532_/X _5125_/Q VGND VGND VPWR VPWR _2533_/X sky130_fd_sc_hd__mux2_1
X_5252_ _5252_/CLK _5252_/D VGND VGND VPWR VPWR _5252_/Q sky130_fd_sc_hd__dfxtp_2
X_2464_ _5263_/Q _2465_/B VGND VGND VPWR VPWR _4700_/S sky130_fd_sc_hd__and2_2
X_4203_ _4202_/X _4151_/X _4340_/A VGND VGND VPWR VPWR _4294_/B sky130_fd_sc_hd__mux2_1
X_5183_ _5254_/CLK _5183_/D VGND VGND VPWR VPWR _5183_/Q sky130_fd_sc_hd__dfxtp_2
XFILLER_68_332 VGND VGND VPWR VPWR sky130_fd_sc_hd__decap_3
XFILLER_68_365 VGND VGND VPWR VPWR sky130_fd_sc_hd__decap_3
X_4134_ _4662_/B _4371_/B VGND VGND VPWR VPWR _4134_/Y sky130_fd_sc_hd__nor2_2
XFILLER_56_516 VGND VGND VPWR VPWR sky130_fd_sc_hd__decap_3
XFILLER_68_398 VGND VGND VPWR VPWR sky130_fd_sc_hd__decap_3
XFILLER_83_313 VGND VGND VPWR VPWR sky130_fd_sc_hd__decap_3
X_4065_ _4062_/X _4064_/Y _4107_/B VGND VGND VPWR VPWR _4066_/B sky130_fd_sc_hd__mux2_1
XFILLER_83_335 VGND VGND VPWR VPWR sky130_fd_sc_hd__fill_1
XFILLER_36_240 VGND VGND VPWR VPWR sky130_fd_sc_hd__decap_3
XFILLER_36_262 VGND VGND VPWR VPWR sky130_fd_sc_hd__decap_3
XFILLER_71_508 VGND VGND VPWR VPWR sky130_fd_sc_hd__decap_3
X_3016_ _2926_/X _3006_/B _3006_/Y _4940_/Q VGND VGND VPWR VPWR _4940_/D sky130_fd_sc_hd__a22o_2
XTAP_TAPCELL_ROW_54_717 VGND VPWR sky130_fd_sc_hd__tapvpwrvgnd_1
XFILLER_83_368 VGND VGND VPWR VPWR sky130_fd_sc_hd__decap_3
XFILLER_24_424 VGND VGND VPWR VPWR sky130_fd_sc_hd__decap_3
XFILLER_51_232 VGND VGND VPWR VPWR sky130_fd_sc_hd__fill_2
XFILLER_51_287 VGND VGND VPWR VPWR sky130_fd_sc_hd__decap_3
X_4967_ _5118_/CLK _4967_/D VGND VGND VPWR VPWR _4967_/Q sky130_fd_sc_hd__dfxtp_2
XTAP_TAPCELL_ROW_62_794 VGND VPWR sky130_fd_sc_hd__tapvpwrvgnd_1
X_4898_ _5106_/CLK _4898_/D VGND VGND VPWR VPWR _4898_/Q sky130_fd_sc_hd__dfxtp_2
X_3918_ _5160_/Q _4477_/A VGND VGND VPWR VPWR _4223_/B sky130_fd_sc_hd__and2b_2
X_3849_ _3844_/X _3992_/A _3849_/C _3849_/D VGND VGND VPWR VPWR _3880_/B sky130_fd_sc_hd__and4b_2
XFILLER_78_129 VGND VGND VPWR VPWR sky130_fd_sc_hd__fill_1
XFILLER_59_332 VGND VGND VPWR VPWR sky130_fd_sc_hd__decap_3
XFILLER_59_343 VGND VGND VPWR VPWR sky130_fd_sc_hd__decap_3
XFILLER_47_55 VGND VGND VPWR VPWR sky130_fd_sc_hd__fill_1
XFILLER_74_324 VGND VGND VPWR VPWR sky130_fd_sc_hd__decap_3
XFILLER_47_66 VGND VGND VPWR VPWR sky130_fd_sc_hd__decap_3
XFILLER_74_335 VGND VGND VPWR VPWR sky130_fd_sc_hd__decap_3
XFILLER_47_99 VGND VGND VPWR VPWR sky130_fd_sc_hd__decap_3
XFILLER_74_368 VGND VGND VPWR VPWR sky130_fd_sc_hd__decap_3
XFILLER_42_221 VGND VGND VPWR VPWR sky130_fd_sc_hd__decap_3
XFILLER_15_468 VGND VGND VPWR VPWR sky130_fd_sc_hd__fill_1
XFILLER_63_54 VGND VGND VPWR VPWR sky130_fd_sc_hd__fill_2
XTAP_TAPCELL_ROW_25_441 VGND VPWR sky130_fd_sc_hd__tapvpwrvgnd_1
XFILLER_42_287 VGND VGND VPWR VPWR sky130_fd_sc_hd__decap_3
XFILLER_6_100 VGND VGND VPWR VPWR sky130_fd_sc_hd__decap_3
XFILLER_6_177 VGND VGND VPWR VPWR sky130_fd_sc_hd__decap_3
XFILLER_12_91 VGND VGND VPWR VPWR sky130_fd_sc_hd__decap_3
XFILLER_26_6 VGND VGND VPWR VPWR sky130_fd_sc_hd__decap_3
XFILLER_38_516 VGND VGND VPWR VPWR sky130_fd_sc_hd__decap_3
XFILLER_38_527 VGND VGND VPWR VPWR sky130_fd_sc_hd__decap_3
XFILLER_65_324 VGND VGND VPWR VPWR sky130_fd_sc_hd__decap_3
XFILLER_65_346 VGND VGND VPWR VPWR sky130_fd_sc_hd__decap_3
XFILLER_53_508 VGND VGND VPWR VPWR sky130_fd_sc_hd__decap_3
XFILLER_33_254 VGND VGND VPWR VPWR sky130_fd_sc_hd__fill_1
X_4821_ _5240_/Q _4847_/B VGND VGND VPWR VPWR _4821_/X sky130_fd_sc_hd__or2_2
XFILLER_21_449 VGND VGND VPWR VPWR sky130_fd_sc_hd__decap_3
X_4752_ _2443_/Y _2665_/B _4285_/B _4279_/B _4751_/X VGND VGND VPWR VPWR _4752_/Y
+ sky130_fd_sc_hd__a221oi_2
X_4683_ _4156_/X _4674_/X _4682_/X _4136_/Y VGND VGND VPWR VPWR _4683_/X sky130_fd_sc_hd__a31o_2
X_3703_ _4468_/A _3703_/B VGND VGND VPWR VPWR _4716_/A sky130_fd_sc_hd__and2_2
X_3634_ _4551_/A _4614_/A _3634_/S VGND VGND VPWR VPWR _4025_/B sky130_fd_sc_hd__mux2_1
XTAP_TAPCELL_ROW_31_499 VGND VPWR sky130_fd_sc_hd__tapvpwrvgnd_1
X_3565_ _4714_/A _3565_/B VGND VGND VPWR VPWR _5202_/D sky130_fd_sc_hd__nor2_2
XFILLER_0_309 VGND VGND VPWR VPWR sky130_fd_sc_hd__decap_3
X_3496_ _3496_/A _3496_/B _3496_/C VGND VGND VPWR VPWR _3497_/A sky130_fd_sc_hd__and3_2
X_2516_ _2516_/A _4764_/S VGND VGND VPWR VPWR _4292_/A sky130_fd_sc_hd__nor2_2
X_5235_ _5252_/CLK _5235_/D VGND VGND VPWR VPWR _5235_/Q sky130_fd_sc_hd__dfxtp_2
X_2447_ _5183_/Q _5182_/Q VGND VGND VPWR VPWR _2889_/C sky130_fd_sc_hd__nor2_2
XFILLER_88_449 VGND VGND VPWR VPWR sky130_fd_sc_hd__decap_3
XFILLER_29_505 VGND VGND VPWR VPWR sky130_fd_sc_hd__fill_1
XFILLER_68_151 VGND VGND VPWR VPWR sky130_fd_sc_hd__decap_3
X_5166_ _5177_/CLK _5166_/D VGND VGND VPWR VPWR _5166_/Q sky130_fd_sc_hd__dfxtp_2
XFILLER_56_324 VGND VGND VPWR VPWR sky130_fd_sc_hd__decap_3
XFILLER_68_195 VGND VGND VPWR VPWR sky130_fd_sc_hd__fill_1
X_4117_ _4111_/X _4113_/Y _4116_/X _4095_/X _4546_/A VGND VGND VPWR VPWR _4117_/X
+ sky130_fd_sc_hd__o32a_2
X_5097_ clkload6/A _5097_/D VGND VGND VPWR VPWR _5097_/Q sky130_fd_sc_hd__dfxtp_2
XTAP_TAPCELL_ROW_67_842 VGND VPWR sky130_fd_sc_hd__tapvpwrvgnd_1
XFILLER_56_368 VGND VGND VPWR VPWR sky130_fd_sc_hd__decap_3
X_4048_ _4048_/A _4048_/B VGND VGND VPWR VPWR _4048_/Y sky130_fd_sc_hd__nand2_2
XFILLER_83_143 VGND VGND VPWR VPWR sky130_fd_sc_hd__decap_3
XFILLER_71_349 VGND VGND VPWR VPWR sky130_fd_sc_hd__decap_3
XFILLER_24_276 VGND VGND VPWR VPWR sky130_fd_sc_hd__decap_3
XFILLER_12_449 VGND VGND VPWR VPWR sky130_fd_sc_hd__fill_2
XTAP_TAPCELL_ROW_22_411 VGND VPWR sky130_fd_sc_hd__tapvpwrvgnd_1
XFILLER_79_405 VGND VGND VPWR VPWR sky130_fd_sc_hd__decap_3
XFILLER_79_449 VGND VGND VPWR VPWR sky130_fd_sc_hd__decap_3
XFILLER_58_32 VGND VGND VPWR VPWR sky130_fd_sc_hd__decap_3
XFILLER_87_471 VGND VGND VPWR VPWR sky130_fd_sc_hd__decap_3
XFILLER_47_324 VGND VGND VPWR VPWR sky130_fd_sc_hd__decap_3
XFILLER_59_184 VGND VGND VPWR VPWR sky130_fd_sc_hd__decap_3
XFILLER_35_508 VGND VGND VPWR VPWR sky130_fd_sc_hd__decap_3
XFILLER_47_357 VGND VGND VPWR VPWR sky130_fd_sc_hd__decap_3
XFILLER_62_349 VGND VGND VPWR VPWR sky130_fd_sc_hd__decap_3
XFILLER_74_176 VGND VGND VPWR VPWR sky130_fd_sc_hd__decap_3
XFILLER_43_552 VGND VGND VPWR VPWR sky130_fd_sc_hd__fill_1
XFILLER_70_360 VGND VGND VPWR VPWR sky130_fd_sc_hd__decap_3
XFILLER_70_371 VGND VGND VPWR VPWR sky130_fd_sc_hd__decap_3
XFILLER_30_279 VGND VGND VPWR VPWR sky130_fd_sc_hd__decap_3
XFILLER_7_431 VGND VGND VPWR VPWR sky130_fd_sc_hd__decap_3
Xmax_cap117 _2948_/Y VGND VGND VPWR VPWR _2961_/B1 sky130_fd_sc_hd__buf_6
Xmax_cap139 _2452_/Y VGND VGND VPWR VPWR _4110_/A sky130_fd_sc_hd__buf_6
X_3350_ _3353_/B _3346_/Y _3349_/X VGND VGND VPWR VPWR _3350_/Y sky130_fd_sc_hd__o21ai_2
X_5020_ _5085_/CLK _5020_/D VGND VGND VPWR VPWR _5020_/Q sky130_fd_sc_hd__dfxtp_2
X_3281_ _3294_/A _3281_/B VGND VGND VPWR VPWR _3283_/A sky130_fd_sc_hd__nor2_2
XFILLER_85_408 VGND VGND VPWR VPWR sky130_fd_sc_hd__fill_2
XFILLER_24_3 VGND VGND VPWR VPWR sky130_fd_sc_hd__decap_3
XFILLER_38_335 VGND VGND VPWR VPWR sky130_fd_sc_hd__decap_3
XTAP_TAPCELL_ROW_88_1033 VGND VPWR sky130_fd_sc_hd__tapvpwrvgnd_1
XFILLER_93_430 VGND VGND VPWR VPWR sky130_fd_sc_hd__decap_3
XFILLER_38_357 VGND VGND VPWR VPWR sky130_fd_sc_hd__decap_3
XFILLER_53_305 VGND VGND VPWR VPWR sky130_fd_sc_hd__decap_3
XFILLER_93_452 VGND VGND VPWR VPWR sky130_fd_sc_hd__decap_3
XFILLER_65_187 VGND VGND VPWR VPWR sky130_fd_sc_hd__decap_3
XTAP_TAPCELL_ROW_64_812 VGND VPWR sky130_fd_sc_hd__tapvpwrvgnd_1
XFILLER_0_72 VGND VGND VPWR VPWR sky130_fd_sc_hd__decap_3
XFILLER_0_94 VGND VGND VPWR VPWR sky130_fd_sc_hd__decap_3
XFILLER_34_541 VGND VGND VPWR VPWR sky130_fd_sc_hd__decap_3
XFILLER_53_349 VGND VGND VPWR VPWR sky130_fd_sc_hd__fill_1
XTAP_TAPCELL_ROW_36_547 VGND VPWR sky130_fd_sc_hd__tapvpwrvgnd_1
XFILLER_21_235 VGND VGND VPWR VPWR sky130_fd_sc_hd__decap_3
X_4804_ _4804_/A _4804_/B VGND VGND VPWR VPWR _4804_/Y sky130_fd_sc_hd__nand2_2
X_4735_ _4580_/Y _4641_/X _4734_/X _4258_/D VGND VGND VPWR VPWR _4735_/X sky130_fd_sc_hd__o211a_2
X_2996_ _2922_/X _2987_/B _2987_/Y _4923_/Q VGND VGND VPWR VPWR _4923_/D sky130_fd_sc_hd__a22o_2
X_4666_ _4666_/A _4666_/B _4666_/C _4666_/D VGND VGND VPWR VPWR _4666_/X sky130_fd_sc_hd__and4_2
X_4597_ _4642_/A _4584_/X _4596_/X _4030_/X VGND VGND VPWR VPWR _4597_/X sky130_fd_sc_hd__o211a_2
X_3617_ _4405_/A _5153_/Q _4542_/S VGND VGND VPWR VPWR _4063_/A sky130_fd_sc_hd__mux2_1
X_3548_ _3549_/A _3549_/C _3549_/B VGND VGND VPWR VPWR _3548_/X sky130_fd_sc_hd__o21a_2
XFILLER_0_139 VGND VGND VPWR VPWR sky130_fd_sc_hd__fill_1
X_3479_ _5152_/Q _5149_/Q _3479_/C VGND VGND VPWR VPWR _3479_/X sky130_fd_sc_hd__and3_2
XFILLER_88_235 VGND VGND VPWR VPWR sky130_fd_sc_hd__fill_1
XFILLER_28_13 VGND VGND VPWR VPWR sky130_fd_sc_hd__decap_3
XFILLER_29_302 VGND VGND VPWR VPWR sky130_fd_sc_hd__decap_3
X_5218_ _5252_/CLK _5218_/D VGND VGND VPWR VPWR _5218_/Q sky130_fd_sc_hd__dfxtp_2
XFILLER_88_279 VGND VGND VPWR VPWR sky130_fd_sc_hd__decap_3
XFILLER_76_419 VGND VGND VPWR VPWR sky130_fd_sc_hd__fill_1
XFILLER_28_35 VGND VGND VPWR VPWR sky130_fd_sc_hd__decap_3
X_5149_ _5254_/CLK _5149_/D VGND VGND VPWR VPWR _5149_/Q sky130_fd_sc_hd__dfxtp_2
XFILLER_84_430 VGND VGND VPWR VPWR sky130_fd_sc_hd__fill_1
XFILLER_28_68 VGND VGND VPWR VPWR sky130_fd_sc_hd__decap_3
XFILLER_84_474 VGND VGND VPWR VPWR sky130_fd_sc_hd__fill_2
XFILLER_71_102 VGND VGND VPWR VPWR sky130_fd_sc_hd__fill_2
XFILLER_71_113 VGND VGND VPWR VPWR sky130_fd_sc_hd__decap_3
XFILLER_25_552 VGND VGND VPWR VPWR sky130_fd_sc_hd__fill_1
XFILLER_71_157 VGND VGND VPWR VPWR sky130_fd_sc_hd__decap_3
XFILLER_52_360 VGND VGND VPWR VPWR sky130_fd_sc_hd__decap_3
XFILLER_52_371 VGND VGND VPWR VPWR sky130_fd_sc_hd__decap_3
XFILLER_12_213 VGND VGND VPWR VPWR sky130_fd_sc_hd__decap_3
XFILLER_40_533 VGND VGND VPWR VPWR sky130_fd_sc_hd__decap_3
XFILLER_60_77 VGND VGND VPWR VPWR sky130_fd_sc_hd__fill_1
XFILLER_4_445 VGND VGND VPWR VPWR sky130_fd_sc_hd__decap_3
XFILLER_4_489 VGND VGND VPWR VPWR sky130_fd_sc_hd__decap_3
XFILLER_69_97 VGND VGND VPWR VPWR sky130_fd_sc_hd__decap_3
XFILLER_67_408 VGND VGND VPWR VPWR sky130_fd_sc_hd__decap_3
XFILLER_67_419 VGND VGND VPWR VPWR sky130_fd_sc_hd__decap_3
XTAP_TAPCELL_ROW_7_272 VGND VPWR sky130_fd_sc_hd__tapvpwrvgnd_1
XFILLER_10_9 VGND VGND VPWR VPWR sky130_fd_sc_hd__fill_1
XFILLER_87_290 VGND VGND VPWR VPWR sky130_fd_sc_hd__decap_3
XFILLER_35_305 VGND VGND VPWR VPWR sky130_fd_sc_hd__decap_3
XFILLER_85_63 VGND VGND VPWR VPWR sky130_fd_sc_hd__fill_2
XFILLER_75_452 VGND VGND VPWR VPWR sky130_fd_sc_hd__decap_3
XFILLER_75_485 VGND VGND VPWR VPWR sky130_fd_sc_hd__decap_3
XFILLER_16_530 VGND VGND VPWR VPWR sky130_fd_sc_hd__fill_2
XFILLER_43_360 VGND VGND VPWR VPWR sky130_fd_sc_hd__decap_3
XFILLER_62_168 VGND VGND VPWR VPWR sky130_fd_sc_hd__fill_1
XTAP_TAPCELL_ROW_33_517 VGND VPWR sky130_fd_sc_hd__tapvpwrvgnd_1
XFILLER_31_533 VGND VGND VPWR VPWR sky130_fd_sc_hd__decap_3
XFILLER_43_393 VGND VGND VPWR VPWR sky130_fd_sc_hd__decap_3
X_2850_ _2844_/X _2846_/X _2849_/X _2437_/Y VGND VGND VPWR VPWR _3397_/B sky130_fd_sc_hd__a22o_2
XFILLER_93_6 VGND VGND VPWR VPWR sky130_fd_sc_hd__decap_3
X_2781_ _5067_/Q _5051_/Q _5035_/Q _5019_/Q _5131_/Q _2848_/S1 VGND VGND VPWR VPWR
+ _2781_/X sky130_fd_sc_hd__mux4_2
X_4520_ _3924_/B _3923_/B _4523_/S VGND VGND VPWR VPWR _4520_/X sky130_fd_sc_hd__mux2_1
XTAP_TAPCELL_ROW_41_594 VGND VPWR sky130_fd_sc_hd__tapvpwrvgnd_1
X_4451_ _4451_/A _4451_/B VGND VGND VPWR VPWR _4452_/B sky130_fd_sc_hd__xnor2_2
X_3402_ _3396_/Y _3401_/Y _4866_/A VGND VGND VPWR VPWR _5148_/D sky130_fd_sc_hd__a21oi_2
X_4382_ _4493_/A _4381_/Y _4466_/B VGND VGND VPWR VPWR _4382_/X sky130_fd_sc_hd__a21o_2
X_3333_ _3333_/A _3361_/A VGND VGND VPWR VPWR _3335_/A sky130_fd_sc_hd__nand2_2
XFILLER_58_419 VGND VGND VPWR VPWR sky130_fd_sc_hd__fill_1
X_3264_ _5256_/Q _5151_/Q VGND VGND VPWR VPWR _3265_/B sky130_fd_sc_hd__nor2_2
XPHY_EDGE_ROW_7_Right_7 VGND VGND VPWR VPWR sky130_fd_sc_hd__decap_3
XFILLER_66_430 VGND VGND VPWR VPWR sky130_fd_sc_hd__decap_3
X_5003_ _5121_/CLK _5003_/D VGND VGND VPWR VPWR _5003_/Q sky130_fd_sc_hd__dfxtp_2
XFILLER_85_249 VGND VGND VPWR VPWR sky130_fd_sc_hd__decap_3
X_3195_ _2910_/X _3203_/A2 _3203_/B1 _5095_/Q VGND VGND VPWR VPWR _5095_/D sky130_fd_sc_hd__a22o_2
XFILLER_81_411 VGND VGND VPWR VPWR sky130_fd_sc_hd__fill_2
XFILLER_93_293 VGND VGND VPWR VPWR sky130_fd_sc_hd__decap_3
XFILLER_81_455 VGND VGND VPWR VPWR sky130_fd_sc_hd__decap_3
XFILLER_81_433 VGND VGND VPWR VPWR sky130_fd_sc_hd__decap_3
XFILLER_22_522 VGND VGND VPWR VPWR sky130_fd_sc_hd__fill_2
XFILLER_22_533 VGND VGND VPWR VPWR sky130_fd_sc_hd__fill_1
XFILLER_34_393 VGND VGND VPWR VPWR sky130_fd_sc_hd__decap_3
XFILLER_14_37 VGND VGND VPWR VPWR sky130_fd_sc_hd__fill_1
X_2979_ _2929_/X _2984_/A2 _2968_/Y _4909_/Q VGND VGND VPWR VPWR _4909_/D sky130_fd_sc_hd__a22o_2
XFILLER_5_209 VGND VGND VPWR VPWR sky130_fd_sc_hd__decap_3
X_4718_ _4115_/A _2652_/B _3874_/D _2652_/A _4717_/X VGND VGND VPWR VPWR _4718_/X
+ sky130_fd_sc_hd__o221a_2
X_4649_ _3874_/A _4224_/A _4246_/A _4095_/A _4648_/X VGND VGND VPWR VPWR _4650_/C
+ sky130_fd_sc_hd__o221a_2
XFILLER_49_408 VGND VGND VPWR VPWR sky130_fd_sc_hd__decap_3
XTAP_TAPCELL_ROW_4_242 VGND VPWR sky130_fd_sc_hd__tapvpwrvgnd_1
XFILLER_76_238 VGND VGND VPWR VPWR sky130_fd_sc_hd__decap_3
XFILLER_69_290 VGND VGND VPWR VPWR sky130_fd_sc_hd__decap_3
XTAP_TAPCELL_ROW_75_918 VGND VPWR sky130_fd_sc_hd__tapvpwrvgnd_1
XFILLER_29_198 VGND VGND VPWR VPWR sky130_fd_sc_hd__decap_3
XFILLER_55_55 VGND VGND VPWR VPWR sky130_fd_sc_hd__fill_1
XFILLER_55_66 VGND VGND VPWR VPWR sky130_fd_sc_hd__decap_3
XFILLER_40_330 VGND VGND VPWR VPWR sky130_fd_sc_hd__decap_3
XFILLER_40_385 VGND VGND VPWR VPWR sky130_fd_sc_hd__decap_3
XTAP_TAPCELL_ROW_10_299 VGND VPWR sky130_fd_sc_hd__tapvpwrvgnd_1
XFILLER_67_249 VGND VGND VPWR VPWR sky130_fd_sc_hd__decap_3
XFILLER_0_492 VGND VGND VPWR VPWR sky130_fd_sc_hd__decap_3
XFILLER_48_452 VGND VGND VPWR VPWR sky130_fd_sc_hd__decap_3
XFILLER_35_113 VGND VGND VPWR VPWR sky130_fd_sc_hd__decap_3
XFILLER_75_293 VGND VGND VPWR VPWR sky130_fd_sc_hd__decap_3
XTAP_TAPCELL_ROW_46_642 VGND VPWR sky130_fd_sc_hd__tapvpwrvgnd_1
XFILLER_63_488 VGND VGND VPWR VPWR sky130_fd_sc_hd__decap_3
X_3951_ _4249_/A _3917_/B _4787_/S VGND VGND VPWR VPWR _3951_/X sky130_fd_sc_hd__mux2_1
XFILLER_50_127 VGND VGND VPWR VPWR sky130_fd_sc_hd__decap_3
X_2902_ _5224_/Q _4850_/A _3458_/B _5208_/Q VGND VGND VPWR VPWR _2902_/X sky130_fd_sc_hd__a22o_2
XTAP_TAPCELL_ROW_18_377 VGND VPWR sky130_fd_sc_hd__tapvpwrvgnd_1
X_3882_ _3917_/B _3882_/B VGND VGND VPWR VPWR _4278_/A sky130_fd_sc_hd__nor2_2
XFILLER_91_3 VGND VGND VPWR VPWR sky130_fd_sc_hd__fill_2
XFILLER_31_363 VGND VGND VPWR VPWR sky130_fd_sc_hd__fill_2
XFILLER_31_385 VGND VGND VPWR VPWR sky130_fd_sc_hd__decap_3
X_2833_ _2851_/A _3376_/B VGND VGND VPWR VPWR _2833_/X sky130_fd_sc_hd__and2_2
X_2764_ _2762_/X _2763_/X _5133_/Q VGND VGND VPWR VPWR _2764_/X sky130_fd_sc_hd__mux2_1
X_4503_ _4504_/A _4504_/B VGND VGND VPWR VPWR _4567_/A sky130_fd_sc_hd__and2b_2
X_2695_ _4546_/A _2695_/B VGND VGND VPWR VPWR _2695_/Y sky130_fd_sc_hd__nor2_2
X_4434_ _4434_/A _4434_/B VGND VGND VPWR VPWR _4443_/A sky130_fd_sc_hd__xnor2_2
X_4365_ _4551_/A _4523_/S _4340_/A VGND VGND VPWR VPWR _4365_/Y sky130_fd_sc_hd__a21oi_2
XFILLER_58_205 VGND VGND VPWR VPWR sky130_fd_sc_hd__decap_3
X_3316_ _3315_/A _3315_/B _5185_/Q VGND VGND VPWR VPWR _3316_/X sky130_fd_sc_hd__o21a_2
XFILLER_58_249 VGND VGND VPWR VPWR sky130_fd_sc_hd__decap_3
X_4296_ _4340_/B _4250_/X _4340_/A VGND VGND VPWR VPWR _4297_/B sky130_fd_sc_hd__mux2_1
XFILLER_39_430 VGND VGND VPWR VPWR sky130_fd_sc_hd__decap_3
XFILLER_39_452 VGND VGND VPWR VPWR sky130_fd_sc_hd__decap_3
X_3247_ _5260_/Q _3247_/B _3252_/C VGND VGND VPWR VPWR _3247_/X sky130_fd_sc_hd__and3_2
XFILLER_39_485 VGND VGND VPWR VPWR sky130_fd_sc_hd__decap_3
XFILLER_54_400 VGND VGND VPWR VPWR sky130_fd_sc_hd__decap_3
XFILLER_66_271 VGND VGND VPWR VPWR sky130_fd_sc_hd__decap_3
X_3178_ _2913_/X _3185_/A2 _3185_/B1 _5080_/Q VGND VGND VPWR VPWR _5080_/D sky130_fd_sc_hd__a22o_2
XTAP_TAPCELL_ROW_1_212 VGND VPWR sky130_fd_sc_hd__tapvpwrvgnd_1
XFILLER_54_433 VGND VGND VPWR VPWR sky130_fd_sc_hd__decap_3
XFILLER_25_36 VGND VGND VPWR VPWR sky130_fd_sc_hd__fill_2
XFILLER_41_105 VGND VGND VPWR VPWR sky130_fd_sc_hd__decap_3
XFILLER_54_477 VGND VGND VPWR VPWR sky130_fd_sc_hd__decap_3
XFILLER_81_252 VGND VGND VPWR VPWR sky130_fd_sc_hd__decap_3
XFILLER_41_116 VGND VGND VPWR VPWR sky130_fd_sc_hd__decap_3
XFILLER_81_296 VGND VGND VPWR VPWR sky130_fd_sc_hd__decap_3
XFILLER_22_341 VGND VGND VPWR VPWR sky130_fd_sc_hd__fill_2
XTAP_TAPCELL_ROW_80_965 VGND VPWR sky130_fd_sc_hd__tapvpwrvgnd_1
XFILLER_10_525 VGND VGND VPWR VPWR sky130_fd_sc_hd__decap_3
XFILLER_41_57 VGND VGND VPWR VPWR sky130_fd_sc_hd__decap_3
XFILLER_1_234 VGND VGND VPWR VPWR sky130_fd_sc_hd__decap_3
XFILLER_89_352 VGND VGND VPWR VPWR sky130_fd_sc_hd__decap_3
XFILLER_77_514 VGND VGND VPWR VPWR sky130_fd_sc_hd__decap_3
XFILLER_66_32 VGND VGND VPWR VPWR sky130_fd_sc_hd__decap_3
XFILLER_45_411 VGND VGND VPWR VPWR sky130_fd_sc_hd__decap_3
XFILLER_64_208 VGND VGND VPWR VPWR sky130_fd_sc_hd__decap_3
XFILLER_17_113 VGND VGND VPWR VPWR sky130_fd_sc_hd__decap_3
XFILLER_45_455 VGND VGND VPWR VPWR sky130_fd_sc_hd__decap_3
XFILLER_60_403 VGND VGND VPWR VPWR sky130_fd_sc_hd__decap_3
XFILLER_72_241 VGND VGND VPWR VPWR sky130_fd_sc_hd__decap_3
XFILLER_32_116 VGND VGND VPWR VPWR sky130_fd_sc_hd__decap_3
XFILLER_45_499 VGND VGND VPWR VPWR sky130_fd_sc_hd__decap_3
XFILLER_60_436 VGND VGND VPWR VPWR sky130_fd_sc_hd__decap_3
XFILLER_72_285 VGND VGND VPWR VPWR sky130_fd_sc_hd__decap_3
XTAP_TAPCELL_ROW_43_612 VGND VPWR sky130_fd_sc_hd__tapvpwrvgnd_1
XFILLER_82_75 VGND VGND VPWR VPWR sky130_fd_sc_hd__decap_3
XFILLER_32_149 VGND VGND VPWR VPWR sky130_fd_sc_hd__decap_3
XTAP_TAPCELL_ROW_15_347 VGND VPWR sky130_fd_sc_hd__tapvpwrvgnd_1
XFILLER_82_97 VGND VGND VPWR VPWR sky130_fd_sc_hd__decap_3
XFILLER_13_374 VGND VGND VPWR VPWR sky130_fd_sc_hd__decap_3
XFILLER_9_356 VGND VGND VPWR VPWR sky130_fd_sc_hd__decap_3
XFILLER_9_389 VGND VGND VPWR VPWR sky130_fd_sc_hd__decap_3
X_2480_ _5073_/Q _5057_/Q _5041_/Q _5025_/Q _5123_/Q _2671_/S1 VGND VGND VPWR VPWR
+ _2481_/B sky130_fd_sc_hd__mux4_2
XFILLER_68_503 VGND VGND VPWR VPWR sky130_fd_sc_hd__fill_1
X_4150_ _3651_/Y _4024_/X _4346_/B _4107_/X VGND VGND VPWR VPWR _4150_/X sky130_fd_sc_hd__o22a_2
XTAP_TAPCELL_ROW_91_1062 VGND VPWR sky130_fd_sc_hd__tapvpwrvgnd_1
XFILLER_68_525 VGND VGND VPWR VPWR sky130_fd_sc_hd__decap_3
XFILLER_68_536 VGND VGND VPWR VPWR sky130_fd_sc_hd__decap_3
Xoutput90 _2871_/Y VGND VGND VPWR VPWR MEM_ADDR[8] sky130_fd_sc_hd__clkdlybuf4s25_1
X_3101_ _2900_/X _3099_/B _3099_/Y _5012_/Q VGND VGND VPWR VPWR _5012_/D sky130_fd_sc_hd__a22o_2
X_4081_ _4115_/A _2860_/B _4091_/A _4080_/X VGND VGND VPWR VPWR _4087_/B sky130_fd_sc_hd__a2bb2o_2
XFILLER_55_219 VGND VGND VPWR VPWR sky130_fd_sc_hd__decap_3
X_3032_ _2919_/X _3024_/B _3024_/Y _4954_/Q VGND VGND VPWR VPWR _4954_/D sky130_fd_sc_hd__a22o_2
XFILLER_83_517 VGND VGND VPWR VPWR sky130_fd_sc_hd__decap_3
XFILLER_36_466 VGND VGND VPWR VPWR sky130_fd_sc_hd__decap_3
XFILLER_36_477 VGND VGND VPWR VPWR sky130_fd_sc_hd__decap_3
XFILLER_91_550 VGND VGND VPWR VPWR sky130_fd_sc_hd__decap_3
XFILLER_23_116 VGND VGND VPWR VPWR sky130_fd_sc_hd__decap_3
X_4983_ _5118_/CLK _4983_/D VGND VGND VPWR VPWR _4983_/Q sky130_fd_sc_hd__dfxtp_2
X_3934_ _5156_/Q _3934_/B _3934_/C VGND VGND VPWR VPWR _3934_/Y sky130_fd_sc_hd__nor3_2
X_3865_ _5178_/Q _3999_/A VGND VGND VPWR VPWR _4003_/A sky130_fd_sc_hd__nand2_2
X_2816_ _4895_/Q _4879_/Q _5103_/Q _5087_/Q _5131_/Q _2848_/S1 VGND VGND VPWR VPWR
+ _2816_/X sky130_fd_sc_hd__mux4_2
X_3796_ _5129_/Q _3796_/B VGND VGND VPWR VPWR _3796_/X sky130_fd_sc_hd__or2_2
XFILLER_11_27 VGND VGND VPWR VPWR sky130_fd_sc_hd__decap_3
X_2747_ _4951_/Q _4935_/Q _4919_/Q _4903_/Q _2812_/S0 _2848_/S1 VGND VGND VPWR VPWR
+ _2748_/B sky130_fd_sc_hd__mux4_2
X_2678_ _2678_/A _4732_/S VGND VGND VPWR VPWR _4242_/A sky130_fd_sc_hd__nand2_2
X_4417_ _4412_/X _4416_/X _4686_/S VGND VGND VPWR VPWR _4417_/X sky130_fd_sc_hd__mux2_1
XFILLER_59_503 VGND VGND VPWR VPWR sky130_fd_sc_hd__fill_1
XFILLER_59_514 VGND VGND VPWR VPWR sky130_fd_sc_hd__decap_3
XFILLER_59_536 VGND VGND VPWR VPWR sky130_fd_sc_hd__decap_3
X_4348_ _3681_/B _4000_/X _4002_/Y _2689_/A _4110_/A VGND VGND VPWR VPWR _4348_/X
+ sky130_fd_sc_hd__a221o_2
XFILLER_86_300 VGND VGND VPWR VPWR sky130_fd_sc_hd__decap_3
XFILLER_74_506 VGND VGND VPWR VPWR sky130_fd_sc_hd__decap_3
X_4279_ _4285_/B _4279_/B _4279_/C VGND VGND VPWR VPWR _4279_/Y sky130_fd_sc_hd__nand3_2
XFILLER_86_333 VGND VGND VPWR VPWR sky130_fd_sc_hd__decap_3
XFILLER_27_411 VGND VGND VPWR VPWR sky130_fd_sc_hd__fill_2
XFILLER_86_388 VGND VGND VPWR VPWR sky130_fd_sc_hd__decap_3
XFILLER_39_293 VGND VGND VPWR VPWR sky130_fd_sc_hd__decap_3
XFILLER_42_403 VGND VGND VPWR VPWR sky130_fd_sc_hd__decap_3
XFILLER_54_241 VGND VGND VPWR VPWR sky130_fd_sc_hd__fill_2
XFILLER_27_499 VGND VGND VPWR VPWR sky130_fd_sc_hd__decap_3
XFILLER_42_447 VGND VGND VPWR VPWR sky130_fd_sc_hd__fill_1
XFILLER_10_300 VGND VGND VPWR VPWR sky130_fd_sc_hd__decap_3
XTAP_TAPCELL_ROW_12_317 VGND VPWR sky130_fd_sc_hd__tapvpwrvgnd_1
XFILLER_50_480 VGND VGND VPWR VPWR sky130_fd_sc_hd__decap_3
XFILLER_52_78 VGND VGND VPWR VPWR sky130_fd_sc_hd__decap_3
XFILLER_6_359 VGND VGND VPWR VPWR sky130_fd_sc_hd__decap_3
XTAP_TAPCELL_ROW_20_394 VGND VPWR sky130_fd_sc_hd__tapvpwrvgnd_1
XFILLER_77_64 VGND VGND VPWR VPWR sky130_fd_sc_hd__decap_3
XFILLER_77_42 VGND VGND VPWR VPWR sky130_fd_sc_hd__decap_3
XFILLER_77_311 VGND VGND VPWR VPWR sky130_fd_sc_hd__decap_3
XFILLER_77_355 VGND VGND VPWR VPWR sky130_fd_sc_hd__fill_2
XFILLER_65_517 VGND VGND VPWR VPWR sky130_fd_sc_hd__fill_1
XFILLER_77_399 VGND VGND VPWR VPWR sky130_fd_sc_hd__decap_3
XFILLER_77_366 VGND VGND VPWR VPWR sky130_fd_sc_hd__decap_3
XFILLER_18_433 VGND VGND VPWR VPWR sky130_fd_sc_hd__decap_3
XFILLER_93_41 VGND VGND VPWR VPWR sky130_fd_sc_hd__fill_2
XFILLER_92_358 VGND VGND VPWR VPWR sky130_fd_sc_hd__fill_1
XFILLER_18_477 VGND VGND VPWR VPWR sky130_fd_sc_hd__decap_3
XFILLER_45_263 VGND VGND VPWR VPWR sky130_fd_sc_hd__decap_3
XFILLER_73_550 VGND VGND VPWR VPWR sky130_fd_sc_hd__decap_3
XFILLER_33_414 VGND VGND VPWR VPWR sky130_fd_sc_hd__decap_3
XFILLER_45_296 VGND VGND VPWR VPWR sky130_fd_sc_hd__decap_3
XFILLER_60_200 VGND VGND VPWR VPWR sky130_fd_sc_hd__decap_3
XTAP_TAPCELL_ROW_28_472 VGND VPWR sky130_fd_sc_hd__tapvpwrvgnd_1
XFILLER_93_85 VGND VGND VPWR VPWR sky130_fd_sc_hd__decap_3
XFILLER_60_266 VGND VGND VPWR VPWR sky130_fd_sc_hd__decap_3
XFILLER_9_142 VGND VGND VPWR VPWR sky130_fd_sc_hd__fill_1
XFILLER_9_131 VGND VGND VPWR VPWR sky130_fd_sc_hd__decap_3
X_3650_ _3647_/X _3649_/Y _4063_/A VGND VGND VPWR VPWR _3650_/X sky130_fd_sc_hd__mux2_1
X_3581_ _5167_/Q _5148_/Q VGND VGND VPWR VPWR _3581_/X sky130_fd_sc_hd__or2_2
X_2601_ _2599_/X _2600_/X _5125_/Q VGND VGND VPWR VPWR _2601_/X sky130_fd_sc_hd__mux2_1
X_2532_ _4953_/Q _4937_/Q _4921_/Q _4905_/Q _5123_/Q _2671_/S1 VGND VGND VPWR VPWR
+ _2532_/X sky130_fd_sc_hd__mux4_2
X_5251_ _5251_/CLK _5251_/D VGND VGND VPWR VPWR _5251_/Q sky130_fd_sc_hd__dfxtp_2
X_4202_ _4477_/A _4523_/S _4201_/X VGND VGND VPWR VPWR _4202_/X sky130_fd_sc_hd__o21a_2
X_2463_ _2463_/A _2463_/B VGND VGND VPWR VPWR _2465_/B sky130_fd_sc_hd__nor2_2
X_5182_ _5254_/CLK _5182_/D VGND VGND VPWR VPWR _5182_/Q sky130_fd_sc_hd__dfxtp_2
XFILLER_87_119 VGND VGND VPWR VPWR sky130_fd_sc_hd__decap_3
X_4133_ _3979_/X _4012_/X _4173_/A VGND VGND VPWR VPWR _4133_/X sky130_fd_sc_hd__mux2_1
XFILLER_68_388 VGND VGND VPWR VPWR sky130_fd_sc_hd__fill_1
X_4064_ _4369_/B VGND VGND VPWR VPWR _4064_/Y sky130_fd_sc_hd__inv_2
X_3015_ _2922_/X _3006_/B _3006_/Y _4939_/Q VGND VGND VPWR VPWR _4939_/D sky130_fd_sc_hd__a22o_2
XTAP_TAPCELL_ROW_54_718 VGND VPWR sky130_fd_sc_hd__tapvpwrvgnd_1
XFILLER_24_436 VGND VGND VPWR VPWR sky130_fd_sc_hd__decap_3
XFILLER_36_274 VGND VGND VPWR VPWR sky130_fd_sc_hd__decap_3
XFILLER_51_255 VGND VGND VPWR VPWR sky130_fd_sc_hd__decap_3
XFILLER_11_108 VGND VGND VPWR VPWR sky130_fd_sc_hd__decap_3
X_4966_ _5112_/CLK _4966_/D VGND VGND VPWR VPWR _4966_/Q sky130_fd_sc_hd__dfxtp_2
XFILLER_51_299 VGND VGND VPWR VPWR sky130_fd_sc_hd__decap_3
X_4897_ _5134_/CLK _4897_/D VGND VGND VPWR VPWR _4897_/Q sky130_fd_sc_hd__dfxtp_2
X_3917_ _5162_/Q _3917_/B VGND VGND VPWR VPWR _3917_/X sky130_fd_sc_hd__or2_2
XTAP_TAPCELL_ROW_62_795 VGND VPWR sky130_fd_sc_hd__tapvpwrvgnd_1
XFILLER_22_37 VGND VGND VPWR VPWR sky130_fd_sc_hd__fill_2
X_3848_ _4095_/A _3848_/B VGND VGND VPWR VPWR _3849_/D sky130_fd_sc_hd__nor2_2
X_3779_ _3779_/A _4371_/A VGND VGND VPWR VPWR _4360_/A sky130_fd_sc_hd__or2_2
XFILLER_59_300 VGND VGND VPWR VPWR sky130_fd_sc_hd__decap_3
Xclkbuf_leaf_20_CLK clkload2/A VGND VGND VPWR VPWR _5063_/CLK sky130_fd_sc_hd__clkbuf_8
XFILLER_59_355 VGND VGND VPWR VPWR sky130_fd_sc_hd__decap_3
XFILLER_86_141 VGND VGND VPWR VPWR sky130_fd_sc_hd__decap_3
XFILLER_59_377 VGND VGND VPWR VPWR sky130_fd_sc_hd__decap_3
XFILLER_74_314 VGND VGND VPWR VPWR sky130_fd_sc_hd__fill_1
XFILLER_59_399 VGND VGND VPWR VPWR sky130_fd_sc_hd__decap_3
XFILLER_74_347 VGND VGND VPWR VPWR sky130_fd_sc_hd__decap_3
XFILLER_27_252 VGND VGND VPWR VPWR sky130_fd_sc_hd__decap_3
XFILLER_62_509 VGND VGND VPWR VPWR sky130_fd_sc_hd__decap_3
XFILLER_74_358 VGND VGND VPWR VPWR sky130_fd_sc_hd__fill_1
XFILLER_42_200 VGND VGND VPWR VPWR sky130_fd_sc_hd__decap_3
XFILLER_42_233 VGND VGND VPWR VPWR sky130_fd_sc_hd__fill_2
XFILLER_63_66 VGND VGND VPWR VPWR sky130_fd_sc_hd__decap_3
XTAP_TAPCELL_ROW_25_442 VGND VPWR sky130_fd_sc_hd__tapvpwrvgnd_1
XFILLER_82_391 VGND VGND VPWR VPWR sky130_fd_sc_hd__decap_3
XFILLER_63_88 VGND VGND VPWR VPWR sky130_fd_sc_hd__decap_3
XFILLER_10_141 VGND VGND VPWR VPWR sky130_fd_sc_hd__fill_2
XFILLER_6_156 VGND VGND VPWR VPWR sky130_fd_sc_hd__fill_1
XFILLER_88_52 VGND VGND VPWR VPWR sky130_fd_sc_hd__decap_3
XFILLER_2_362 VGND VGND VPWR VPWR sky130_fd_sc_hd__fill_2
Xclkbuf_leaf_11_CLK clkload0/A VGND VGND VPWR VPWR _5254_/CLK sky130_fd_sc_hd__clkbuf_8
XFILLER_88_96 VGND VGND VPWR VPWR sky130_fd_sc_hd__decap_3
XPHY_EDGE_ROW_0_Left_94 VGND VGND VPWR VPWR sky130_fd_sc_hd__decap_3
XFILLER_19_6 VGND VGND VPWR VPWR sky130_fd_sc_hd__decap_3
XFILLER_65_303 VGND VGND VPWR VPWR sky130_fd_sc_hd__decap_3
XFILLER_65_358 VGND VGND VPWR VPWR sky130_fd_sc_hd__decap_3
XFILLER_92_144 VGND VGND VPWR VPWR sky130_fd_sc_hd__fill_1
XFILLER_80_306 VGND VGND VPWR VPWR sky130_fd_sc_hd__fill_2
XFILLER_33_200 VGND VGND VPWR VPWR sky130_fd_sc_hd__decap_3
XFILLER_61_520 VGND VGND VPWR VPWR sky130_fd_sc_hd__decap_3
XFILLER_92_177 VGND VGND VPWR VPWR sky130_fd_sc_hd__decap_3
XFILLER_80_339 VGND VGND VPWR VPWR sky130_fd_sc_hd__decap_3
X_4820_ input40/X _4816_/Y _4819_/X _3448_/B VGND VGND VPWR VPWR _5239_/D sky130_fd_sc_hd__o211a_2
X_4751_ _4333_/B _2663_/Y _4287_/A _4716_/B _4750_/X VGND VGND VPWR VPWR _4751_/X
+ sky130_fd_sc_hd__a221o_2
X_4682_ _4635_/Y _4786_/B _4679_/X _4681_/X VGND VGND VPWR VPWR _4682_/X sky130_fd_sc_hd__o211a_2
X_3702_ _4468_/A _3703_/B VGND VGND VPWR VPWR _4717_/S sky130_fd_sc_hd__nor2_2
X_3633_ _3633_/A VGND VGND VPWR VPWR _3633_/Y sky130_fd_sc_hd__inv_2
X_3564_ _5202_/Q _4800_/B _3585_/A _3563_/Y VGND VGND VPWR VPWR _3565_/B sky130_fd_sc_hd__o2bb2a_2
X_3495_ _3496_/A _3496_/B _3496_/C VGND VGND VPWR VPWR _3495_/X sky130_fd_sc_hd__a21o_2
X_2515_ _5164_/Q _4471_/B VGND VGND VPWR VPWR _4764_/S sky130_fd_sc_hd__nor2_2
XFILLER_88_406 VGND VGND VPWR VPWR sky130_fd_sc_hd__decap_3
X_5234_ _5252_/CLK _5234_/D VGND VGND VPWR VPWR _5234_/Q sky130_fd_sc_hd__dfxtp_2
X_2446_ _5176_/Q _2446_/B _5177_/Q VGND VGND VPWR VPWR _4115_/A sky130_fd_sc_hd__or3b_2
X_5165_ _5251_/CLK _5165_/D VGND VGND VPWR VPWR _5165_/Q sky130_fd_sc_hd__dfxtp_2
XFILLER_68_141 VGND VGND VPWR VPWR sky130_fd_sc_hd__fill_2
XFILLER_68_163 VGND VGND VPWR VPWR sky130_fd_sc_hd__decap_3
X_4116_ _3932_/Y _4313_/B _4114_/X _4115_/Y VGND VGND VPWR VPWR _4116_/X sky130_fd_sc_hd__a31o_2
XFILLER_56_347 VGND VGND VPWR VPWR sky130_fd_sc_hd__decap_3
X_5096_ _5109_/CLK _5096_/D VGND VGND VPWR VPWR _5096_/Q sky130_fd_sc_hd__dfxtp_2
XFILLER_83_122 VGND VGND VPWR VPWR sky130_fd_sc_hd__decap_3
XFILLER_83_100 VGND VGND VPWR VPWR sky130_fd_sc_hd__decap_3
XFILLER_17_37 VGND VGND VPWR VPWR sky130_fd_sc_hd__fill_1
XFILLER_44_509 VGND VGND VPWR VPWR sky130_fd_sc_hd__decap_3
XFILLER_56_358 VGND VGND VPWR VPWR sky130_fd_sc_hd__decap_3
XFILLER_71_306 VGND VGND VPWR VPWR sky130_fd_sc_hd__decap_3
X_4047_ _4155_/A _4047_/B VGND VGND VPWR VPWR _4053_/B sky130_fd_sc_hd__nor2_2
XFILLER_83_166 VGND VGND VPWR VPWR sky130_fd_sc_hd__fill_2
XFILLER_24_200 VGND VGND VPWR VPWR sky130_fd_sc_hd__decap_3
XFILLER_64_380 VGND VGND VPWR VPWR sky130_fd_sc_hd__fill_2
XFILLER_24_244 VGND VGND VPWR VPWR sky130_fd_sc_hd__decap_3
XFILLER_52_531 VGND VGND VPWR VPWR sky130_fd_sc_hd__fill_1
XFILLER_24_288 VGND VGND VPWR VPWR sky130_fd_sc_hd__decap_3
XFILLER_33_47 VGND VGND VPWR VPWR sky130_fd_sc_hd__decap_3
X_4949_ _5109_/CLK _4949_/D VGND VGND VPWR VPWR _4949_/Q sky130_fd_sc_hd__dfxtp_2
XTAP_TAPCELL_ROW_22_412 VGND VPWR sky130_fd_sc_hd__tapvpwrvgnd_1
XPHY_EDGE_ROW_18_Left_112 VGND VGND VPWR VPWR sky130_fd_sc_hd__decap_3
XFILLER_3_148 VGND VGND VPWR VPWR sky130_fd_sc_hd__decap_3
XFILLER_58_22 VGND VGND VPWR VPWR sky130_fd_sc_hd__decap_3
XFILLER_79_428 VGND VGND VPWR VPWR sky130_fd_sc_hd__decap_3
XFILLER_58_88 VGND VGND VPWR VPWR sky130_fd_sc_hd__fill_1
XFILLER_58_99 VGND VGND VPWR VPWR sky130_fd_sc_hd__decap_3
XFILLER_59_152 VGND VGND VPWR VPWR sky130_fd_sc_hd__decap_3
XFILLER_87_483 VGND VGND VPWR VPWR sky130_fd_sc_hd__decap_3
XFILLER_28_550 VGND VGND VPWR VPWR sky130_fd_sc_hd__decap_3
XFILLER_74_155 VGND VGND VPWR VPWR sky130_fd_sc_hd__decap_3
XFILLER_74_43 VGND VGND VPWR VPWR sky130_fd_sc_hd__decap_3
XPHY_EDGE_ROW_27_Left_121 VGND VGND VPWR VPWR sky130_fd_sc_hd__decap_3
XFILLER_43_520 VGND VGND VPWR VPWR sky130_fd_sc_hd__decap_3
XFILLER_74_188 VGND VGND VPWR VPWR sky130_fd_sc_hd__decap_3
XFILLER_15_277 VGND VGND VPWR VPWR sky130_fd_sc_hd__decap_3
XFILLER_30_203 VGND VGND VPWR VPWR sky130_fd_sc_hd__decap_3
XFILLER_70_383 VGND VGND VPWR VPWR sky130_fd_sc_hd__decap_3
Xclkbuf_leaf_0_CLK clkbuf_leaf_8_CLK/A VGND VGND VPWR VPWR _5121_/CLK sky130_fd_sc_hd__clkbuf_8
XFILLER_30_247 VGND VGND VPWR VPWR sky130_fd_sc_hd__decap_3
XFILLER_23_80 VGND VGND VPWR VPWR sky130_fd_sc_hd__decap_3
XFILLER_7_410 VGND VGND VPWR VPWR sky130_fd_sc_hd__decap_3
XFILLER_11_494 VGND VGND VPWR VPWR sky130_fd_sc_hd__decap_3
XPHY_EDGE_ROW_36_Left_130 VGND VGND VPWR VPWR sky130_fd_sc_hd__decap_3
XFILLER_7_443 VGND VGND VPWR VPWR sky130_fd_sc_hd__decap_3
Xmax_cap118 _2897_/Y VGND VGND VPWR VPWR _2936_/A2 sky130_fd_sc_hd__clkbuf_8
Xmax_cap129 _3005_/Y VGND VGND VPWR VPWR _3006_/B sky130_fd_sc_hd__clkbuf_8
X_3280_ _5156_/Q _3280_/B VGND VGND VPWR VPWR _3281_/B sky130_fd_sc_hd__nor2_2
XFILLER_78_472 VGND VGND VPWR VPWR sky130_fd_sc_hd__decap_3
XFILLER_78_450 VGND VGND VPWR VPWR sky130_fd_sc_hd__decap_3
XFILLER_65_111 VGND VGND VPWR VPWR sky130_fd_sc_hd__fill_1
XTAP_TAPCELL_ROW_88_1034 VGND VPWR sky130_fd_sc_hd__tapvpwrvgnd_1
XFILLER_93_464 VGND VGND VPWR VPWR sky130_fd_sc_hd__decap_3
XFILLER_93_442 VGND VGND VPWR VPWR sky130_fd_sc_hd__decap_3
XTAP_TAPCELL_ROW_64_813 VGND VPWR sky130_fd_sc_hd__tapvpwrvgnd_1
XFILLER_93_486 VGND VGND VPWR VPWR sky130_fd_sc_hd__decap_3
XFILLER_34_520 VGND VGND VPWR VPWR sky130_fd_sc_hd__fill_2
XTAP_TAPCELL_ROW_36_548 VGND VPWR sky130_fd_sc_hd__tapvpwrvgnd_1
XFILLER_80_158 VGND VGND VPWR VPWR sky130_fd_sc_hd__decap_3
XFILLER_61_350 VGND VGND VPWR VPWR sky130_fd_sc_hd__decap_3
XFILLER_21_225 VGND VGND VPWR VPWR sky130_fd_sc_hd__decap_3
X_4803_ _4802_/A _4774_/X _4802_/Y _4804_/A VGND VGND VPWR VPWR _4803_/X sky130_fd_sc_hd__a211o_2
XTAP_TAPCELL_ROW_72_890 VGND VPWR sky130_fd_sc_hd__tapvpwrvgnd_1
X_4734_ _3682_/D _4224_/A _4731_/X _4733_/Y VGND VGND VPWR VPWR _4734_/X sky130_fd_sc_hd__o211a_2
X_2995_ _2919_/X _2987_/B _2987_/Y _4922_/Q VGND VGND VPWR VPWR _4922_/D sky130_fd_sc_hd__a22o_2
X_4665_ _4115_/A _2617_/B _3874_/D _2617_/A _4664_/X VGND VGND VPWR VPWR _4666_/D
+ sky130_fd_sc_hd__o221a_2
X_4596_ _4537_/X _4587_/Y _4595_/X VGND VGND VPWR VPWR _4596_/X sky130_fd_sc_hd__o21a_2
X_3616_ _3610_/X _3612_/X _3615_/X _2432_/Y VGND VGND VPWR VPWR _4405_/A sky130_fd_sc_hd__a22o_2
X_3547_ _3534_/B _3534_/C _3540_/B _3537_/A VGND VGND VPWR VPWR _3549_/C sky130_fd_sc_hd__a211oi_2
X_3478_ _5153_/Q _5150_/Q VGND VGND VPWR VPWR _3479_/C sky130_fd_sc_hd__xor2_2
X_5217_ _5221_/CLK _5217_/D VGND VGND VPWR VPWR _5217_/Q sky130_fd_sc_hd__dfxtp_2
X_2429_ _5176_/Q VGND VGND VPWR VPWR _3999_/A sky130_fd_sc_hd__inv_2
XFILLER_28_25 VGND VGND VPWR VPWR sky130_fd_sc_hd__decap_3
XFILLER_28_47 VGND VGND VPWR VPWR sky130_fd_sc_hd__fill_1
XFILLER_56_100 VGND VGND VPWR VPWR sky130_fd_sc_hd__decap_3
XFILLER_69_483 VGND VGND VPWR VPWR sky130_fd_sc_hd__fill_2
X_5148_ _5262_/CLK _5148_/D VGND VGND VPWR VPWR _5148_/Q sky130_fd_sc_hd__dfxtp_2
X_5079_ _5118_/CLK _5079_/D VGND VGND VPWR VPWR _5079_/Q sky130_fd_sc_hd__dfxtp_2
XFILLER_44_317 VGND VGND VPWR VPWR sky130_fd_sc_hd__decap_3
XFILLER_44_328 VGND VGND VPWR VPWR sky130_fd_sc_hd__decap_3
XFILLER_84_486 VGND VGND VPWR VPWR sky130_fd_sc_hd__decap_3
XFILLER_25_531 VGND VGND VPWR VPWR sky130_fd_sc_hd__fill_1
XFILLER_44_35 VGND VGND VPWR VPWR sky130_fd_sc_hd__decap_3
XFILLER_71_125 VGND VGND VPWR VPWR sky130_fd_sc_hd__decap_3
XFILLER_40_501 VGND VGND VPWR VPWR sky130_fd_sc_hd__fill_1
XFILLER_44_79 VGND VGND VPWR VPWR sky130_fd_sc_hd__decap_3
XFILLER_52_394 VGND VGND VPWR VPWR sky130_fd_sc_hd__decap_3
XFILLER_8_229 VGND VGND VPWR VPWR sky130_fd_sc_hd__decap_3
XFILLER_60_56 VGND VGND VPWR VPWR sky130_fd_sc_hd__decap_3
XFILLER_4_424 VGND VGND VPWR VPWR sky130_fd_sc_hd__decap_3
XFILLER_4_457 VGND VGND VPWR VPWR sky130_fd_sc_hd__fill_2
XFILLER_79_236 VGND VGND VPWR VPWR sky130_fd_sc_hd__decap_3
XFILLER_79_225 VGND VGND VPWR VPWR sky130_fd_sc_hd__decap_3
XFILLER_47_111 VGND VGND VPWR VPWR sky130_fd_sc_hd__fill_1
XTAP_TAPCELL_ROW_78_938 VGND VPWR sky130_fd_sc_hd__tapvpwrvgnd_1
XFILLER_85_53 VGND VGND VPWR VPWR sky130_fd_sc_hd__decap_3
XFILLER_75_464 VGND VGND VPWR VPWR sky130_fd_sc_hd__decap_3
XFILLER_47_177 VGND VGND VPWR VPWR sky130_fd_sc_hd__decap_3
XFILLER_62_103 VGND VGND VPWR VPWR sky130_fd_sc_hd__fill_2
XFILLER_90_401 VGND VGND VPWR VPWR sky130_fd_sc_hd__decap_3
XFILLER_16_542 VGND VGND VPWR VPWR sky130_fd_sc_hd__decap_3
XFILLER_18_91 VGND VGND VPWR VPWR sky130_fd_sc_hd__decap_3
XFILLER_62_147 VGND VGND VPWR VPWR sky130_fd_sc_hd__decap_3
XFILLER_31_501 VGND VGND VPWR VPWR sky130_fd_sc_hd__decap_3
XFILLER_50_309 VGND VGND VPWR VPWR sky130_fd_sc_hd__decap_3
XTAP_TAPCELL_ROW_33_518 VGND VPWR sky130_fd_sc_hd__tapvpwrvgnd_1
XFILLER_43_372 VGND VGND VPWR VPWR sky130_fd_sc_hd__decap_3
XFILLER_86_6 VGND VGND VPWR VPWR sky130_fd_sc_hd__decap_3
X_2780_ _4891_/Q _4875_/Q _5099_/Q _5083_/Q _5131_/Q _5132_/Q VGND VGND VPWR VPWR
+ _2780_/X sky130_fd_sc_hd__mux4_2
Xclkbuf_2_1__f_CLK clkbuf_0_CLK/X VGND VGND VPWR VPWR clkload0/A sky130_fd_sc_hd__clkbuf_16
XTAP_TAPCELL_ROW_41_595 VGND VPWR sky130_fd_sc_hd__tapvpwrvgnd_1
X_4450_ _4465_/B _4493_/C VGND VGND VPWR VPWR _4451_/B sky130_fd_sc_hd__and2b_2
X_4381_ _4449_/B _4493_/B _4067_/A VGND VGND VPWR VPWR _4381_/Y sky130_fd_sc_hd__o21ai_2
X_3401_ _3398_/Y _3399_/X _3400_/Y _5185_/Q _3337_/A VGND VGND VPWR VPWR _3401_/Y
+ sky130_fd_sc_hd__o221ai_2
X_3332_ _5161_/Q _3332_/B VGND VGND VPWR VPWR _3361_/A sky130_fd_sc_hd__or2_2
X_3263_ _3262_/A _3262_/B _2425_/Y VGND VGND VPWR VPWR _3263_/X sky130_fd_sc_hd__a21o_2
X_5002_ _5114_/CLK _5002_/D VGND VGND VPWR VPWR _5002_/Q sky130_fd_sc_hd__dfxtp_2
X_3194_ _2906_/X _3203_/A2 _3203_/B1 _5094_/Q VGND VGND VPWR VPWR _5094_/D sky130_fd_sc_hd__a22o_2
XFILLER_85_228 VGND VGND VPWR VPWR sky130_fd_sc_hd__fill_1
XFILLER_66_442 VGND VGND VPWR VPWR sky130_fd_sc_hd__decap_3
XFILLER_93_261 VGND VGND VPWR VPWR sky130_fd_sc_hd__decap_3
XFILLER_19_391 VGND VGND VPWR VPWR sky130_fd_sc_hd__fill_1
XFILLER_41_309 VGND VGND VPWR VPWR sky130_fd_sc_hd__decap_3
XFILLER_81_478 VGND VGND VPWR VPWR sky130_fd_sc_hd__decap_3
XFILLER_61_180 VGND VGND VPWR VPWR sky130_fd_sc_hd__decap_3
X_2978_ _2926_/X _2984_/A2 _2968_/Y _4908_/Q VGND VGND VPWR VPWR _4908_/D sky130_fd_sc_hd__a22o_2
X_4717_ _3457_/A _4546_/A _4717_/S VGND VGND VPWR VPWR _4717_/X sky130_fd_sc_hd__mux2_1
X_4648_ _4547_/A _2562_/B _3874_/D _2560_/Y VGND VGND VPWR VPWR _4648_/X sky130_fd_sc_hd__o22a_2
X_4579_ _4673_/B _4671_/A _4686_/S VGND VGND VPWR VPWR _4580_/A sky130_fd_sc_hd__mux2_1
XFILLER_89_523 VGND VGND VPWR VPWR sky130_fd_sc_hd__decap_3
XFILLER_1_449 VGND VGND VPWR VPWR sky130_fd_sc_hd__decap_3
XFILLER_89_545 VGND VGND VPWR VPWR sky130_fd_sc_hd__decap_3
XFILLER_39_57 VGND VGND VPWR VPWR sky130_fd_sc_hd__decap_3
XFILLER_29_100 VGND VGND VPWR VPWR sky130_fd_sc_hd__decap_3
XFILLER_57_420 VGND VGND VPWR VPWR sky130_fd_sc_hd__fill_2
XFILLER_76_217 VGND VGND VPWR VPWR sky130_fd_sc_hd__decap_3
XFILLER_29_122 VGND VGND VPWR VPWR sky130_fd_sc_hd__decap_3
XTAP_TAPCELL_ROW_4_243 VGND VPWR sky130_fd_sc_hd__tapvpwrvgnd_1
XFILLER_55_34 VGND VGND VPWR VPWR sky130_fd_sc_hd__decap_3
XFILLER_72_412 VGND VGND VPWR VPWR sky130_fd_sc_hd__decap_3
XFILLER_84_250 VGND VGND VPWR VPWR sky130_fd_sc_hd__fill_2
XFILLER_44_147 VGND VGND VPWR VPWR sky130_fd_sc_hd__decap_3
XFILLER_55_78 VGND VGND VPWR VPWR sky130_fd_sc_hd__decap_3
XFILLER_72_434 VGND VGND VPWR VPWR sky130_fd_sc_hd__decap_3
XFILLER_72_456 VGND VGND VPWR VPWR sky130_fd_sc_hd__fill_2
XFILLER_84_283 VGND VGND VPWR VPWR sky130_fd_sc_hd__decap_3
XFILLER_32_309 VGND VGND VPWR VPWR sky130_fd_sc_hd__decap_3
XFILLER_72_489 VGND VGND VPWR VPWR sky130_fd_sc_hd__decap_3
XFILLER_13_534 VGND VGND VPWR VPWR sky130_fd_sc_hd__fill_1
XFILLER_71_44 VGND VGND VPWR VPWR sky130_fd_sc_hd__decap_3
XFILLER_71_99 VGND VGND VPWR VPWR sky130_fd_sc_hd__decap_3
XFILLER_67_217 VGND VGND VPWR VPWR sky130_fd_sc_hd__decap_3
XFILLER_67_228 VGND VGND VPWR VPWR sky130_fd_sc_hd__decap_3
XFILLER_48_431 VGND VGND VPWR VPWR sky130_fd_sc_hd__decap_3
XFILLER_63_412 VGND VGND VPWR VPWR sky130_fd_sc_hd__decap_3
XFILLER_63_445 VGND VGND VPWR VPWR sky130_fd_sc_hd__decap_3
XTAP_TAPCELL_ROW_46_643 VGND VPWR sky130_fd_sc_hd__tapvpwrvgnd_1
XFILLER_16_350 VGND VGND VPWR VPWR sky130_fd_sc_hd__decap_3
XFILLER_35_169 VGND VGND VPWR VPWR sky130_fd_sc_hd__decap_3
X_3950_ _4022_/B VGND VGND VPWR VPWR _3950_/Y sky130_fd_sc_hd__inv_2
X_2901_ _4868_/Q _2936_/A2 _2900_/X _2936_/B2 VGND VGND VPWR VPWR _4868_/D sky130_fd_sc_hd__a22o_2
X_3881_ _5206_/Q _4168_/A _3880_/X _3448_/B VGND VGND VPWR VPWR _5206_/D sky130_fd_sc_hd__o211a_2
X_2832_ _2827_/X _2828_/X _2831_/X _2437_/Y VGND VGND VPWR VPWR _3376_/B sky130_fd_sc_hd__a22o_2
XFILLER_84_3 VGND VGND VPWR VPWR sky130_fd_sc_hd__decap_3
X_2763_ _5065_/Q _5049_/Q _5033_/Q _5017_/Q _2812_/S0 _2848_/S1 VGND VGND VPWR VPWR
+ _2763_/X sky130_fd_sc_hd__mux4_2
X_4502_ _4563_/B _4502_/B VGND VGND VPWR VPWR _4504_/B sky130_fd_sc_hd__nor2_2
X_2694_ _3457_/A _2695_/B VGND VGND VPWR VPWR _2694_/Y sky130_fd_sc_hd__nor2_2
XFILLER_6_72 VGND VGND VPWR VPWR sky130_fd_sc_hd__decap_3
XFILLER_6_94 VGND VGND VPWR VPWR sky130_fd_sc_hd__decap_3
X_4433_ _4469_/B _4500_/B VGND VGND VPWR VPWR _4434_/B sky130_fd_sc_hd__and2b_2
X_4364_ _4619_/A VGND VGND VPWR VPWR _4364_/Y sky130_fd_sc_hd__inv_2
X_4295_ _4471_/B _4429_/B _4523_/S VGND VGND VPWR VPWR _4340_/B sky130_fd_sc_hd__mux2_1
X_3315_ _3315_/A _3315_/B VGND VGND VPWR VPWR _3315_/Y sky130_fd_sc_hd__nand2_2
XFILLER_58_217 VGND VGND VPWR VPWR sky130_fd_sc_hd__decap_3
X_3246_ _5172_/Q _3252_/C _3245_/X _3448_/B VGND VGND VPWR VPWR _5131_/D sky130_fd_sc_hd__o211a_2
XFILLER_86_548 VGND VGND VPWR VPWR sky130_fd_sc_hd__decap_3
XFILLER_39_442 VGND VGND VPWR VPWR sky130_fd_sc_hd__decap_3
XFILLER_39_464 VGND VGND VPWR VPWR sky130_fd_sc_hd__decap_3
XFILLER_54_412 VGND VGND VPWR VPWR sky130_fd_sc_hd__decap_3
XFILLER_73_209 VGND VGND VPWR VPWR sky130_fd_sc_hd__decap_3
X_3177_ _2910_/X _3185_/A2 _3185_/B1 _5079_/Q VGND VGND VPWR VPWR _5079_/D sky130_fd_sc_hd__a22o_2
XTAP_TAPCELL_ROW_1_213 VGND VPWR sky130_fd_sc_hd__tapvpwrvgnd_1
XFILLER_26_114 VGND VGND VPWR VPWR sky130_fd_sc_hd__decap_3
XFILLER_54_445 VGND VGND VPWR VPWR sky130_fd_sc_hd__decap_3
XFILLER_66_283 VGND VGND VPWR VPWR sky130_fd_sc_hd__fill_1
XFILLER_14_309 VGND VGND VPWR VPWR sky130_fd_sc_hd__decap_3
XFILLER_22_320 VGND VGND VPWR VPWR sky130_fd_sc_hd__decap_3
XTAP_TAPCELL_ROW_80_966 VGND VPWR sky130_fd_sc_hd__tapvpwrvgnd_1
XFILLER_22_386 VGND VGND VPWR VPWR sky130_fd_sc_hd__decap_3
XFILLER_49_217 VGND VGND VPWR VPWR sky130_fd_sc_hd__fill_2
XFILLER_49_228 VGND VGND VPWR VPWR sky130_fd_sc_hd__decap_3
XFILLER_66_11 VGND VGND VPWR VPWR sky130_fd_sc_hd__fill_1
XFILLER_77_526 VGND VGND VPWR VPWR sky130_fd_sc_hd__fill_2
XFILLER_57_250 VGND VGND VPWR VPWR sky130_fd_sc_hd__decap_3
XFILLER_57_272 VGND VGND VPWR VPWR sky130_fd_sc_hd__decap_3
XFILLER_92_518 VGND VGND VPWR VPWR sky130_fd_sc_hd__decap_3
XFILLER_17_125 VGND VGND VPWR VPWR sky130_fd_sc_hd__decap_3
XFILLER_45_434 VGND VGND VPWR VPWR sky130_fd_sc_hd__decap_3
XFILLER_17_169 VGND VGND VPWR VPWR sky130_fd_sc_hd__fill_1
XFILLER_45_467 VGND VGND VPWR VPWR sky130_fd_sc_hd__fill_1
XFILLER_45_478 VGND VGND VPWR VPWR sky130_fd_sc_hd__decap_3
XFILLER_72_253 VGND VGND VPWR VPWR sky130_fd_sc_hd__fill_1
XFILLER_72_264 VGND VGND VPWR VPWR sky130_fd_sc_hd__decap_3
XFILLER_82_32 VGND VGND VPWR VPWR sky130_fd_sc_hd__decap_3
XFILLER_60_415 VGND VGND VPWR VPWR sky130_fd_sc_hd__decap_3
XFILLER_72_297 VGND VGND VPWR VPWR sky130_fd_sc_hd__decap_3
XTAP_TAPCELL_ROW_43_613 VGND VPWR sky130_fd_sc_hd__tapvpwrvgnd_1
XFILLER_60_448 VGND VGND VPWR VPWR sky130_fd_sc_hd__decap_3
XTAP_TAPCELL_ROW_15_348 VGND VPWR sky130_fd_sc_hd__tapvpwrvgnd_1
XFILLER_13_364 VGND VGND VPWR VPWR sky130_fd_sc_hd__fill_2
XFILLER_13_386 VGND VGND VPWR VPWR sky130_fd_sc_hd__decap_3
XFILLER_15_70 VGND VGND VPWR VPWR sky130_fd_sc_hd__decap_3
XTAP_TAPCELL_ROW_51_690 VGND VPWR sky130_fd_sc_hd__tapvpwrvgnd_1
XTAP_TAPCELL_ROW_91_1063 VGND VPWR sky130_fd_sc_hd__tapvpwrvgnd_1
XFILLER_68_548 VGND VGND VPWR VPWR sky130_fd_sc_hd__decap_3
Xoutput80 _2885_/Y VGND VGND VPWR VPWR MEM_ADDR[13] sky130_fd_sc_hd__clkdlybuf4s25_1
Xoutput91 _2874_/Y VGND VGND VPWR VPWR MEM_ADDR[9] sky130_fd_sc_hd__clkdlybuf4s25_1
X_3100_ _2891_/X _3099_/B _3099_/Y _5011_/Q VGND VGND VPWR VPWR _5011_/D sky130_fd_sc_hd__a22o_2
XFILLER_0_290 VGND VGND VPWR VPWR sky130_fd_sc_hd__decap_3
X_4080_ _3892_/Y _4360_/B _3998_/Y VGND VGND VPWR VPWR _4080_/X sky130_fd_sc_hd__a21o_2
XFILLER_36_401 VGND VGND VPWR VPWR sky130_fd_sc_hd__decap_3
X_3031_ _2916_/X _3024_/B _3024_/Y _4953_/Q VGND VGND VPWR VPWR _4953_/D sky130_fd_sc_hd__a22o_2
XFILLER_83_529 VGND VGND VPWR VPWR sky130_fd_sc_hd__fill_2
XFILLER_36_434 VGND VGND VPWR VPWR sky130_fd_sc_hd__decap_3
XFILLER_63_242 VGND VGND VPWR VPWR sky130_fd_sc_hd__decap_3
XFILLER_23_128 VGND VGND VPWR VPWR sky130_fd_sc_hd__fill_1
XFILLER_36_489 VGND VGND VPWR VPWR sky130_fd_sc_hd__decap_3
XFILLER_51_426 VGND VGND VPWR VPWR sky130_fd_sc_hd__fill_1
XFILLER_63_297 VGND VGND VPWR VPWR sky130_fd_sc_hd__decap_3
X_4982_ _4982_/CLK _4982_/D VGND VGND VPWR VPWR _4982_/Q sky130_fd_sc_hd__dfxtp_2
X_3933_ _5156_/Q _3934_/B VGND VGND VPWR VPWR _3933_/X sky130_fd_sc_hd__or2_2
XFILLER_31_150 VGND VGND VPWR VPWR sky130_fd_sc_hd__decap_3
X_3864_ _4155_/A _3864_/B _4297_/A VGND VGND VPWR VPWR _3877_/A sky130_fd_sc_hd__nor3_2
XFILLER_31_172 VGND VGND VPWR VPWR sky130_fd_sc_hd__decap_3
X_2815_ _2851_/A _3352_/B VGND VGND VPWR VPWR _2815_/X sky130_fd_sc_hd__and2_2
X_3795_ _4890_/Q _4874_/Q _5098_/Q _5082_/Q _3834_/S0 _3834_/S1 VGND VGND VPWR VPWR
+ _3796_/B sky130_fd_sc_hd__mux4_2
XFILLER_11_39 VGND VGND VPWR VPWR sky130_fd_sc_hd__decap_3
X_2746_ _2744_/X _2745_/X _5133_/Q VGND VGND VPWR VPWR _2746_/X sky130_fd_sc_hd__mux2_1
XFILLER_8_390 VGND VGND VPWR VPWR sky130_fd_sc_hd__decap_3
X_2677_ _2678_/A _4732_/S VGND VGND VPWR VPWR _3682_/D sky130_fd_sc_hd__and2_2
X_4416_ _4414_/Y _4578_/B _4624_/A VGND VGND VPWR VPWR _4416_/X sky130_fd_sc_hd__mux2_1
X_4347_ _5176_/Q _4794_/S _3768_/B _3999_/B VGND VGND VPWR VPWR _4350_/D sky130_fd_sc_hd__a211o_2
XFILLER_86_312 VGND VGND VPWR VPWR sky130_fd_sc_hd__decap_3
XFILLER_59_548 VGND VGND VPWR VPWR sky130_fd_sc_hd__decap_3
X_4278_ _4278_/A _4278_/B VGND VGND VPWR VPWR _4279_/C sky130_fd_sc_hd__nor2_2
XFILLER_86_345 VGND VGND VPWR VPWR sky130_fd_sc_hd__decap_3
XFILLER_46_209 VGND VGND VPWR VPWR sky130_fd_sc_hd__decap_3
XFILLER_74_529 VGND VGND VPWR VPWR sky130_fd_sc_hd__decap_3
X_3229_ _5260_/Q _3448_/B input8/X VGND VGND VPWR VPWR _3229_/X sky130_fd_sc_hd__and3_2
XFILLER_27_445 VGND VGND VPWR VPWR sky130_fd_sc_hd__decap_3
XFILLER_36_58 VGND VGND VPWR VPWR sky130_fd_sc_hd__decap_3
XFILLER_54_253 VGND VGND VPWR VPWR sky130_fd_sc_hd__decap_3
XFILLER_42_415 VGND VGND VPWR VPWR sky130_fd_sc_hd__decap_3
XFILLER_54_286 VGND VGND VPWR VPWR sky130_fd_sc_hd__decap_3
XFILLER_42_459 VGND VGND VPWR VPWR sky130_fd_sc_hd__fill_1
XFILLER_52_35 VGND VGND VPWR VPWR sky130_fd_sc_hd__decap_3
XTAP_TAPCELL_ROW_12_318 VGND VPWR sky130_fd_sc_hd__tapvpwrvgnd_1
XFILLER_10_312 VGND VGND VPWR VPWR sky130_fd_sc_hd__fill_1
XFILLER_6_305 VGND VGND VPWR VPWR sky130_fd_sc_hd__decap_3
XFILLER_6_338 VGND VGND VPWR VPWR sky130_fd_sc_hd__decap_3
XTAP_TAPCELL_ROW_20_395 VGND VPWR sky130_fd_sc_hd__tapvpwrvgnd_1
XFILLER_2_533 VGND VGND VPWR VPWR sky130_fd_sc_hd__fill_1
XFILLER_77_323 VGND VGND VPWR VPWR sky130_fd_sc_hd__decap_3
XFILLER_77_87 VGND VGND VPWR VPWR sky130_fd_sc_hd__decap_3
XFILLER_92_304 VGND VGND VPWR VPWR sky130_fd_sc_hd__decap_3
XFILLER_77_378 VGND VGND VPWR VPWR sky130_fd_sc_hd__decap_3
XFILLER_92_337 VGND VGND VPWR VPWR sky130_fd_sc_hd__decap_3
XFILLER_45_242 VGND VGND VPWR VPWR sky130_fd_sc_hd__decap_3
XFILLER_18_489 VGND VGND VPWR VPWR sky130_fd_sc_hd__fill_1
XFILLER_60_212 VGND VGND VPWR VPWR sky130_fd_sc_hd__decap_3
XFILLER_60_245 VGND VGND VPWR VPWR sky130_fd_sc_hd__decap_3
XFILLER_60_256 VGND VGND VPWR VPWR sky130_fd_sc_hd__fill_2
XFILLER_13_161 VGND VGND VPWR VPWR sky130_fd_sc_hd__fill_2
XFILLER_13_194 VGND VGND VPWR VPWR sky130_fd_sc_hd__decap_3
X_3580_ _5205_/Q _4800_/B VGND VGND VPWR VPWR _3580_/Y sky130_fd_sc_hd__nand2_2
X_2600_ _4947_/Q _4931_/Q _4915_/Q _4899_/Q _2658_/S0 _2671_/S1 VGND VGND VPWR VPWR
+ _2600_/X sky130_fd_sc_hd__mux4_2
X_2531_ _5113_/Q _5001_/Q _4985_/Q _4969_/Q _5123_/Q _2671_/S1 VGND VGND VPWR VPWR
+ _2531_/X sky130_fd_sc_hd__mux4_2
X_5250_ _5252_/CLK _5250_/D VGND VGND VPWR VPWR _5250_/Q sky130_fd_sc_hd__dfxtp_2
XFILLER_5_393 VGND VGND VPWR VPWR sky130_fd_sc_hd__decap_3
X_4201_ _4464_/A _4225_/B VGND VGND VPWR VPWR _4201_/X sky130_fd_sc_hd__or2_2
X_2462_ _2889_/C _4850_/A _2460_/X _2455_/X VGND VGND VPWR VPWR _2463_/B sky130_fd_sc_hd__a2bb2o_2
XFILLER_87_109 VGND VGND VPWR VPWR sky130_fd_sc_hd__decap_3
XFILLER_68_301 VGND VGND VPWR VPWR sky130_fd_sc_hd__decap_3
XFILLER_68_312 VGND VGND VPWR VPWR sky130_fd_sc_hd__fill_2
X_5181_ clkload5/A _5181_/D VGND VGND VPWR VPWR _5181_/Q sky130_fd_sc_hd__dfxtp_2
XFILLER_68_356 VGND VGND VPWR VPWR sky130_fd_sc_hd__fill_1
X_4132_ _4132_/A _4132_/B VGND VGND VPWR VPWR _4132_/X sky130_fd_sc_hd__and2_2
XFILLER_56_529 VGND VGND VPWR VPWR sky130_fd_sc_hd__decap_3
X_4063_ _4063_/A _4063_/B VGND VGND VPWR VPWR _4369_/B sky130_fd_sc_hd__nor2_2
XFILLER_83_304 VGND VGND VPWR VPWR sky130_fd_sc_hd__decap_3
X_3014_ _2919_/X _3006_/B _3006_/Y _4938_/Q VGND VGND VPWR VPWR _4938_/D sky130_fd_sc_hd__a22o_2
XFILLER_83_348 VGND VGND VPWR VPWR sky130_fd_sc_hd__decap_3
XFILLER_36_253 VGND VGND VPWR VPWR sky130_fd_sc_hd__decap_3
XFILLER_64_551 VGND VGND VPWR VPWR sky130_fd_sc_hd__fill_2
XTAP_TAPCELL_ROW_54_719 VGND VPWR sky130_fd_sc_hd__tapvpwrvgnd_1
XFILLER_36_286 VGND VGND VPWR VPWR sky130_fd_sc_hd__decap_3
X_4965_ _5109_/CLK _4965_/D VGND VGND VPWR VPWR _4965_/Q sky130_fd_sc_hd__dfxtp_2
X_3916_ _3916_/A _3916_/B VGND VGND VPWR VPWR _3916_/X sky130_fd_sc_hd__or2_2
XFILLER_32_470 VGND VGND VPWR VPWR sky130_fd_sc_hd__decap_3
X_4896_ _5134_/CLK _4896_/D VGND VGND VPWR VPWR _4896_/Q sky130_fd_sc_hd__dfxtp_2
XFILLER_22_27 VGND VGND VPWR VPWR sky130_fd_sc_hd__fill_1
X_3847_ _3847_/A _3847_/B _3847_/C _3900_/A VGND VGND VPWR VPWR _3848_/B sky130_fd_sc_hd__or4_2
X_3778_ _4614_/A _3910_/B VGND VGND VPWR VPWR _4371_/A sky130_fd_sc_hd__and2_2
X_2729_ _5109_/Q _4997_/Q _4981_/Q _4965_/Q _2812_/S0 _2848_/S1 VGND VGND VPWR VPWR
+ _2730_/B sky130_fd_sc_hd__mux4_2
XFILLER_0_9 VGND VGND VPWR VPWR sky130_fd_sc_hd__decap_3
XFILLER_59_312 VGND VGND VPWR VPWR sky130_fd_sc_hd__decap_3
XFILLER_47_46 VGND VGND VPWR VPWR sky130_fd_sc_hd__decap_3
XFILLER_47_518 VGND VGND VPWR VPWR sky130_fd_sc_hd__fill_1
XFILLER_86_164 VGND VGND VPWR VPWR sky130_fd_sc_hd__decap_3
XFILLER_47_57 VGND VGND VPWR VPWR sky130_fd_sc_hd__decap_3
XPHY_EDGE_ROW_29_Right_29 VGND VGND VPWR VPWR sky130_fd_sc_hd__decap_3
XFILLER_86_197 VGND VGND VPWR VPWR sky130_fd_sc_hd__decap_3
XFILLER_55_551 VGND VGND VPWR VPWR sky130_fd_sc_hd__fill_2
XFILLER_30_418 VGND VGND VPWR VPWR sky130_fd_sc_hd__fill_2
XFILLER_30_429 VGND VGND VPWR VPWR sky130_fd_sc_hd__decap_3
XFILLER_42_278 VGND VGND VPWR VPWR sky130_fd_sc_hd__decap_3
XTAP_TAPCELL_ROW_25_443 VGND VPWR sky130_fd_sc_hd__tapvpwrvgnd_1
XPHY_EDGE_ROW_38_Right_38 VGND VGND VPWR VPWR sky130_fd_sc_hd__decap_3
XFILLER_10_197 VGND VGND VPWR VPWR sky130_fd_sc_hd__decap_3
XFILLER_88_64 VGND VGND VPWR VPWR sky130_fd_sc_hd__decap_3
XPHY_EDGE_ROW_47_Right_47 VGND VGND VPWR VPWR sky130_fd_sc_hd__decap_3
XFILLER_65_337 VGND VGND VPWR VPWR sky130_fd_sc_hd__decap_3
XFILLER_77_186 VGND VGND VPWR VPWR sky130_fd_sc_hd__decap_3
XFILLER_18_253 VGND VGND VPWR VPWR sky130_fd_sc_hd__decap_3
XFILLER_80_318 VGND VGND VPWR VPWR sky130_fd_sc_hd__decap_3
XFILLER_33_245 VGND VGND VPWR VPWR sky130_fd_sc_hd__decap_3
XFILLER_61_532 VGND VGND VPWR VPWR sky130_fd_sc_hd__decap_3
X_4750_ _2449_/Y _4110_/A _4750_/S VGND VGND VPWR VPWR _4750_/X sky130_fd_sc_hd__mux2_1
XPHY_EDGE_ROW_56_Right_56 VGND VGND VPWR VPWR sky130_fd_sc_hd__decap_3
X_4681_ _3457_/A _3794_/A _4149_/A _4246_/A _4680_/X VGND VGND VPWR VPWR _4681_/X
+ sky130_fd_sc_hd__o221a_2
X_3701_ _3695_/X _3697_/X _3700_/X _2432_/Y VGND VGND VPWR VPWR _3703_/B sky130_fd_sc_hd__a22o_2
X_3632_ _4471_/B _4471_/A _3634_/S VGND VGND VPWR VPWR _3633_/A sky130_fd_sc_hd__mux2_1
X_3563_ _3563_/A _3563_/B VGND VGND VPWR VPWR _3563_/Y sky130_fd_sc_hd__xnor2_2
X_3494_ _3488_/A _3488_/C _3488_/B VGND VGND VPWR VPWR _3496_/C sky130_fd_sc_hd__a21bo_2
X_2514_ _2684_/A VGND VGND VPWR VPWR _2516_/A sky130_fd_sc_hd__inv_2
X_5233_ _5253_/CLK _5233_/D VGND VGND VPWR VPWR _5233_/Q sky130_fd_sc_hd__dfxtp_2
X_2445_ _5178_/Q _5177_/Q _3999_/A _5179_/Q VGND VGND VPWR VPWR _4333_/B sky130_fd_sc_hd__and4b_2
XPHY_EDGE_ROW_65_Right_65 VGND VGND VPWR VPWR sky130_fd_sc_hd__decap_3
XFILLER_88_418 VGND VGND VPWR VPWR sky130_fd_sc_hd__fill_2
X_5164_ _5164_/CLK _5164_/D VGND VGND VPWR VPWR _5164_/Q sky130_fd_sc_hd__dfxtp_2
XFILLER_56_304 VGND VGND VPWR VPWR sky130_fd_sc_hd__decap_3
X_4115_ _4115_/A _4115_/B VGND VGND VPWR VPWR _4115_/Y sky130_fd_sc_hd__nor2_2
XFILLER_56_315 VGND VGND VPWR VPWR sky130_fd_sc_hd__decap_3
XFILLER_68_175 VGND VGND VPWR VPWR sky130_fd_sc_hd__decap_3
XFILLER_68_197 VGND VGND VPWR VPWR sky130_fd_sc_hd__decap_3
X_5095_ _5118_/CLK _5095_/D VGND VGND VPWR VPWR _5095_/Q sky130_fd_sc_hd__dfxtp_2
X_4046_ _4297_/A _4046_/B VGND VGND VPWR VPWR _4047_/B sky130_fd_sc_hd__or2_2
XTAP_TAPCELL_ROW_39_568 VGND VPWR sky130_fd_sc_hd__tapvpwrvgnd_1
XFILLER_83_134 VGND VGND VPWR VPWR sky130_fd_sc_hd__decap_3
XFILLER_52_510 VGND VGND VPWR VPWR sky130_fd_sc_hd__decap_3
XFILLER_71_318 VGND VGND VPWR VPWR sky130_fd_sc_hd__decap_3
XFILLER_83_178 VGND VGND VPWR VPWR sky130_fd_sc_hd__fill_1
XFILLER_24_223 VGND VGND VPWR VPWR sky130_fd_sc_hd__decap_3
XPHY_EDGE_ROW_74_Right_74 VGND VGND VPWR VPWR sky130_fd_sc_hd__decap_3
XFILLER_12_429 VGND VGND VPWR VPWR sky130_fd_sc_hd__decap_3
X_4948_ _5119_/CLK _4948_/D VGND VGND VPWR VPWR _4948_/Q sky130_fd_sc_hd__dfxtp_2
XTAP_TAPCELL_ROW_22_413 VGND VPWR sky130_fd_sc_hd__tapvpwrvgnd_1
X_4879_ _5098_/CLK _4879_/D VGND VGND VPWR VPWR _4879_/Q sky130_fd_sc_hd__dfxtp_2
XTAP_TAPCELL_ROW_30_490 VGND VPWR sky130_fd_sc_hd__tapvpwrvgnd_1
XPHY_EDGE_ROW_83_Right_83 VGND VGND VPWR VPWR sky130_fd_sc_hd__decap_3
XFILLER_47_337 VGND VGND VPWR VPWR sky130_fd_sc_hd__decap_3
XFILLER_59_175 VGND VGND VPWR VPWR sky130_fd_sc_hd__decap_3
XFILLER_47_348 VGND VGND VPWR VPWR sky130_fd_sc_hd__decap_3
XFILLER_15_201 VGND VGND VPWR VPWR sky130_fd_sc_hd__decap_3
XFILLER_55_370 VGND VGND VPWR VPWR sky130_fd_sc_hd__decap_3
XFILLER_62_318 VGND VGND VPWR VPWR sky130_fd_sc_hd__fill_1
XFILLER_74_167 VGND VGND VPWR VPWR sky130_fd_sc_hd__decap_3
XFILLER_15_234 VGND VGND VPWR VPWR sky130_fd_sc_hd__decap_3
XFILLER_43_543 VGND VGND VPWR VPWR sky130_fd_sc_hd__decap_3
XFILLER_74_88 VGND VGND VPWR VPWR sky130_fd_sc_hd__decap_3
XPHY_EDGE_ROW_92_Right_92 VGND VGND VPWR VPWR sky130_fd_sc_hd__decap_3
XFILLER_70_351 VGND VGND VPWR VPWR sky130_fd_sc_hd__decap_3
XFILLER_30_215 VGND VGND VPWR VPWR sky130_fd_sc_hd__decap_3
XFILLER_30_237 VGND VGND VPWR VPWR sky130_fd_sc_hd__fill_2
XFILLER_70_395 VGND VGND VPWR VPWR sky130_fd_sc_hd__decap_3
XFILLER_90_32 VGND VGND VPWR VPWR sky130_fd_sc_hd__decap_3
XFILLER_23_92 VGND VGND VPWR VPWR sky130_fd_sc_hd__decap_3
Xmax_cap108 _3226_/Y VGND VGND VPWR VPWR _3252_/C sky130_fd_sc_hd__buf_4
Xmax_cap119 _3634_/S VGND VGND VPWR VPWR _4787_/S sky130_fd_sc_hd__buf_12
XFILLER_7_499 VGND VGND VPWR VPWR sky130_fd_sc_hd__decap_3
XFILLER_38_326 VGND VGND VPWR VPWR sky130_fd_sc_hd__decap_3
XFILLER_93_421 VGND VGND VPWR VPWR sky130_fd_sc_hd__decap_3
XFILLER_93_410 VGND VGND VPWR VPWR sky130_fd_sc_hd__decap_3
XFILLER_78_484 VGND VGND VPWR VPWR sky130_fd_sc_hd__decap_3
XFILLER_38_348 VGND VGND VPWR VPWR sky130_fd_sc_hd__decap_3
XTAP_TAPCELL_ROW_88_1035 VGND VPWR sky130_fd_sc_hd__tapvpwrvgnd_1
XFILLER_0_52 VGND VGND VPWR VPWR sky130_fd_sc_hd__decap_3
XFILLER_65_178 VGND VGND VPWR VPWR sky130_fd_sc_hd__decap_3
XTAP_TAPCELL_ROW_64_814 VGND VPWR sky130_fd_sc_hd__tapvpwrvgnd_1
XFILLER_93_498 VGND VGND VPWR VPWR sky130_fd_sc_hd__decap_3
XFILLER_0_63 VGND VGND VPWR VPWR sky130_fd_sc_hd__decap_3
XFILLER_0_85 VGND VGND VPWR VPWR sky130_fd_sc_hd__decap_3
XFILLER_46_392 VGND VGND VPWR VPWR sky130_fd_sc_hd__decap_3
XFILLER_80_137 VGND VGND VPWR VPWR sky130_fd_sc_hd__decap_3
XFILLER_61_340 VGND VGND VPWR VPWR sky130_fd_sc_hd__decap_3
XFILLER_61_362 VGND VGND VPWR VPWR sky130_fd_sc_hd__decap_3
X_4802_ _4802_/A _4802_/B VGND VGND VPWR VPWR _4802_/Y sky130_fd_sc_hd__nor2_2
X_2994_ _2916_/X _2987_/B _2987_/Y _4921_/Q VGND VGND VPWR VPWR _4921_/D sky130_fd_sc_hd__a22o_2
X_4733_ _4285_/C _4279_/B _4732_/X VGND VGND VPWR VPWR _4733_/Y sky130_fd_sc_hd__a21oi_2
X_4664_ _3457_/A _4546_/A _4664_/S VGND VGND VPWR VPWR _4664_/X sky130_fd_sc_hd__mux2_1
X_4595_ _4053_/B _4593_/X _4595_/C _4595_/D VGND VGND VPWR VPWR _4595_/X sky130_fd_sc_hd__and4bb_2
X_3615_ _3613_/X _3614_/X _5129_/Q VGND VGND VPWR VPWR _3615_/X sky130_fd_sc_hd__mux2_1
X_3546_ _3546_/A _3546_/B VGND VGND VPWR VPWR _3549_/B sky130_fd_sc_hd__nand2_2
XFILLER_0_108 VGND VGND VPWR VPWR sky130_fd_sc_hd__decap_3
XFILLER_88_204 VGND VGND VPWR VPWR sky130_fd_sc_hd__fill_2
X_5216_ _5253_/CLK _5216_/D VGND VGND VPWR VPWR _5216_/Q sky130_fd_sc_hd__dfxtp_2
X_3477_ _5153_/Q _5150_/Q VGND VGND VPWR VPWR _3477_/X sky130_fd_sc_hd__and2_2
X_2428_ _5179_/Q VGND VGND VPWR VPWR _3867_/A sky130_fd_sc_hd__inv_2
XFILLER_88_259 VGND VGND VPWR VPWR sky130_fd_sc_hd__decap_3
XFILLER_29_337 VGND VGND VPWR VPWR sky130_fd_sc_hd__decap_3
X_5147_ _5164_/CLK _5147_/D VGND VGND VPWR VPWR _5147_/Q sky130_fd_sc_hd__dfxtp_2
XFILLER_84_421 VGND VGND VPWR VPWR sky130_fd_sc_hd__fill_1
XFILLER_29_359 VGND VGND VPWR VPWR sky130_fd_sc_hd__decap_3
X_5078_ _5078_/CLK _5078_/D VGND VGND VPWR VPWR _5078_/Q sky130_fd_sc_hd__dfxtp_2
X_4029_ _4346_/A _4029_/B VGND VGND VPWR VPWR _4029_/X sky130_fd_sc_hd__or2_2
XFILLER_84_498 VGND VGND VPWR VPWR sky130_fd_sc_hd__decap_3
XFILLER_25_543 VGND VGND VPWR VPWR sky130_fd_sc_hd__decap_3
XFILLER_44_47 VGND VGND VPWR VPWR sky130_fd_sc_hd__fill_2
XFILLER_52_351 VGND VGND VPWR VPWR sky130_fd_sc_hd__decap_3
XFILLER_60_35 VGND VGND VPWR VPWR sky130_fd_sc_hd__decap_3
XFILLER_60_68 VGND VGND VPWR VPWR sky130_fd_sc_hd__decap_3
XFILLER_4_436 VGND VGND VPWR VPWR sky130_fd_sc_hd__decap_3
XFILLER_69_22 VGND VGND VPWR VPWR sky130_fd_sc_hd__decap_3
XFILLER_69_66 VGND VGND VPWR VPWR sky130_fd_sc_hd__decap_3
XFILLER_79_248 VGND VGND VPWR VPWR sky130_fd_sc_hd__decap_3
XFILLER_75_410 VGND VGND VPWR VPWR sky130_fd_sc_hd__decap_3
XTAP_TAPCELL_ROW_78_939 VGND VPWR sky130_fd_sc_hd__tapvpwrvgnd_1
XFILLER_87_281 VGND VGND VPWR VPWR sky130_fd_sc_hd__decap_3
XFILLER_87_270 VGND VGND VPWR VPWR sky130_fd_sc_hd__fill_2
XFILLER_47_145 VGND VGND VPWR VPWR sky130_fd_sc_hd__decap_3
XFILLER_75_443 VGND VGND VPWR VPWR sky130_fd_sc_hd__decap_3
XFILLER_47_167 VGND VGND VPWR VPWR sky130_fd_sc_hd__fill_1
XFILLER_47_189 VGND VGND VPWR VPWR sky130_fd_sc_hd__fill_1
XFILLER_90_413 VGND VGND VPWR VPWR sky130_fd_sc_hd__fill_2
XFILLER_75_476 VGND VGND VPWR VPWR sky130_fd_sc_hd__decap_3
XFILLER_28_370 VGND VGND VPWR VPWR sky130_fd_sc_hd__decap_3
XFILLER_43_340 VGND VGND VPWR VPWR sky130_fd_sc_hd__decap_3
XTAP_TAPCELL_ROW_33_519 VGND VPWR sky130_fd_sc_hd__tapvpwrvgnd_1
XFILLER_34_91 VGND VGND VPWR VPWR sky130_fd_sc_hd__decap_3
XFILLER_11_270 VGND VGND VPWR VPWR sky130_fd_sc_hd__decap_3
XFILLER_11_292 VGND VGND VPWR VPWR sky130_fd_sc_hd__decap_3
X_4380_ _4614_/A _4380_/B VGND VGND VPWR VPWR _4551_/B sky130_fd_sc_hd__or2_2
X_3400_ _5148_/Q _3400_/B VGND VGND VPWR VPWR _3400_/Y sky130_fd_sc_hd__xnor2_2
XFILLER_7_296 VGND VGND VPWR VPWR sky130_fd_sc_hd__decap_3
X_3331_ _5161_/Q _3332_/B VGND VGND VPWR VPWR _3333_/A sky130_fd_sc_hd__nand2_2
X_3262_ _3262_/A _3262_/B VGND VGND VPWR VPWR _3262_/Y sky130_fd_sc_hd__nor2_2
XFILLER_66_410 VGND VGND VPWR VPWR sky130_fd_sc_hd__decap_3
XFILLER_66_421 VGND VGND VPWR VPWR sky130_fd_sc_hd__decap_3
X_5001_ clkload9/A _5001_/D VGND VGND VPWR VPWR _5001_/Q sky130_fd_sc_hd__dfxtp_2
X_3193_ _2903_/X _3203_/A2 _3203_/B1 _5093_/Q VGND VGND VPWR VPWR _5093_/D sky130_fd_sc_hd__a22o_2
XFILLER_85_218 VGND VGND VPWR VPWR sky130_fd_sc_hd__decap_3
XFILLER_78_281 VGND VGND VPWR VPWR sky130_fd_sc_hd__decap_3
XFILLER_66_454 VGND VGND VPWR VPWR sky130_fd_sc_hd__decap_3
XFILLER_66_487 VGND VGND VPWR VPWR sky130_fd_sc_hd__decap_3
XTAP_TAPCELL_ROW_49_663 VGND VPWR sky130_fd_sc_hd__tapvpwrvgnd_1
XFILLER_93_273 VGND VGND VPWR VPWR sky130_fd_sc_hd__decap_3
XFILLER_81_402 VGND VGND VPWR VPWR sky130_fd_sc_hd__decap_3
XFILLER_93_284 VGND VGND VPWR VPWR sky130_fd_sc_hd__decap_3
XFILLER_81_424 VGND VGND VPWR VPWR sky130_fd_sc_hd__decap_3
XFILLER_34_340 VGND VGND VPWR VPWR sky130_fd_sc_hd__decap_3
XFILLER_22_513 VGND VGND VPWR VPWR sky130_fd_sc_hd__decap_3
XFILLER_34_373 VGND VGND VPWR VPWR sky130_fd_sc_hd__decap_3
XFILLER_34_384 VGND VGND VPWR VPWR sky130_fd_sc_hd__decap_3
XFILLER_61_192 VGND VGND VPWR VPWR sky130_fd_sc_hd__decap_3
X_2977_ _2922_/X _2984_/A2 _2968_/Y _4907_/Q VGND VGND VPWR VPWR _4907_/D sky130_fd_sc_hd__a22o_2
X_4716_ _4716_/A _4716_/B VGND VGND VPWR VPWR _4716_/Y sky130_fd_sc_hd__nand2_2
XFILLER_30_38 VGND VGND VPWR VPWR sky130_fd_sc_hd__fill_2
X_4647_ _4333_/B _2562_/B _4662_/A _3839_/B _4646_/X VGND VGND VPWR VPWR _4647_/X
+ sky130_fd_sc_hd__a221o_2
X_4578_ _4624_/A _4578_/B VGND VGND VPWR VPWR _4671_/A sky130_fd_sc_hd__nor2_2
XFILLER_89_502 VGND VGND VPWR VPWR sky130_fd_sc_hd__fill_2
XFILLER_1_428 VGND VGND VPWR VPWR sky130_fd_sc_hd__decap_3
X_3529_ _5160_/Q _5141_/Q VGND VGND VPWR VPWR _3534_/A sky130_fd_sc_hd__nand2_2
XPHY_EDGE_ROW_55_Left_149 VGND VGND VPWR VPWR sky130_fd_sc_hd__decap_3
XFILLER_39_69 VGND VGND VPWR VPWR sky130_fd_sc_hd__decap_3
XFILLER_29_134 VGND VGND VPWR VPWR sky130_fd_sc_hd__fill_1
XFILLER_69_281 VGND VGND VPWR VPWR sky130_fd_sc_hd__decap_3
XTAP_TAPCELL_ROW_4_244 VGND VPWR sky130_fd_sc_hd__tapvpwrvgnd_1
XFILLER_17_307 VGND VGND VPWR VPWR sky130_fd_sc_hd__decap_3
XFILLER_57_487 VGND VGND VPWR VPWR sky130_fd_sc_hd__fill_1
XFILLER_29_189 VGND VGND VPWR VPWR sky130_fd_sc_hd__decap_3
XFILLER_55_46 VGND VGND VPWR VPWR sky130_fd_sc_hd__decap_3
XFILLER_55_57 VGND VGND VPWR VPWR sky130_fd_sc_hd__decap_3
XFILLER_72_446 VGND VGND VPWR VPWR sky130_fd_sc_hd__decap_3
XFILLER_25_340 VGND VGND VPWR VPWR sky130_fd_sc_hd__decap_3
XFILLER_25_351 VGND VGND VPWR VPWR sky130_fd_sc_hd__decap_3
XTAP_TAPCELL_ROW_83_986 VGND VPWR sky130_fd_sc_hd__tapvpwrvgnd_1
XPHY_EDGE_ROW_64_Left_158 VGND VGND VPWR VPWR sky130_fd_sc_hd__decap_3
XFILLER_40_321 VGND VGND VPWR VPWR sky130_fd_sc_hd__decap_3
XFILLER_71_23 VGND VGND VPWR VPWR sky130_fd_sc_hd__decap_3
XFILLER_40_376 VGND VGND VPWR VPWR sky130_fd_sc_hd__decap_3
XFILLER_40_398 VGND VGND VPWR VPWR sky130_fd_sc_hd__decap_3
XFILLER_4_200 VGND VGND VPWR VPWR sky130_fd_sc_hd__fill_1
XPHY_EDGE_ROW_73_Left_167 VGND VGND VPWR VPWR sky130_fd_sc_hd__decap_3
XFILLER_48_410 VGND VGND VPWR VPWR sky130_fd_sc_hd__decap_3
XFILLER_0_483 VGND VGND VPWR VPWR sky130_fd_sc_hd__decap_3
XFILLER_48_443 VGND VGND VPWR VPWR sky130_fd_sc_hd__decap_3
XFILLER_29_91 VGND VGND VPWR VPWR sky130_fd_sc_hd__decap_3
XFILLER_48_465 VGND VGND VPWR VPWR sky130_fd_sc_hd__fill_2
XTAP_TAPCELL_ROW_85_1005 VGND VPWR sky130_fd_sc_hd__tapvpwrvgnd_1
XFILLER_75_284 VGND VGND VPWR VPWR sky130_fd_sc_hd__decap_3
XPHY_EDGE_ROW_82_Left_176 VGND VGND VPWR VPWR sky130_fd_sc_hd__decap_3
XFILLER_35_148 VGND VGND VPWR VPWR sky130_fd_sc_hd__decap_3
XFILLER_63_479 VGND VGND VPWR VPWR sky130_fd_sc_hd__fill_1
XFILLER_16_362 VGND VGND VPWR VPWR sky130_fd_sc_hd__fill_2
XFILLER_31_310 VGND VGND VPWR VPWR sky130_fd_sc_hd__decap_3
X_2900_ _5191_/Q _2455_/X _3456_/B _5239_/Q _2899_/X VGND VGND VPWR VPWR _2900_/X
+ sky130_fd_sc_hd__a221o_2
XTAP_TAPCELL_ROW_18_368 VGND VPWR sky130_fd_sc_hd__tapvpwrvgnd_1
XFILLER_90_287 VGND VGND VPWR VPWR sky130_fd_sc_hd__decap_3
X_3880_ _4850_/B _3880_/B _3880_/C _3880_/D VGND VGND VPWR VPWR _3880_/X sky130_fd_sc_hd__or4_2
X_2831_ _2829_/X _2830_/X _2831_/S VGND VGND VPWR VPWR _2831_/X sky130_fd_sc_hd__mux2_1
X_2762_ _4889_/Q _4873_/Q _5097_/Q _5081_/Q _2812_/S0 _2848_/S1 VGND VGND VPWR VPWR
+ _2762_/X sky130_fd_sc_hd__mux4_2
XFILLER_77_3 VGND VGND VPWR VPWR sky130_fd_sc_hd__decap_3
X_4501_ _4469_/A _4469_/B _4500_/B _4500_/A VGND VGND VPWR VPWR _4502_/B sky130_fd_sc_hd__o211a_2
XFILLER_6_40 VGND VGND VPWR VPWR sky130_fd_sc_hd__decap_3
X_4432_ _4468_/A _4432_/B VGND VGND VPWR VPWR _4500_/B sky130_fd_sc_hd__nand2_2
X_2693_ _4115_/A _2695_/B VGND VGND VPWR VPWR _2693_/Y sky130_fd_sc_hd__nor2_2
XPHY_EDGE_ROW_91_Left_185 VGND VGND VPWR VPWR sky130_fd_sc_hd__decap_3
X_4363_ _4473_/A _4523_/S VGND VGND VPWR VPWR _4619_/A sky130_fd_sc_hd__or2_2
X_4294_ _4339_/A _4294_/B VGND VGND VPWR VPWR _4294_/Y sky130_fd_sc_hd__nor2_2
X_3314_ _3291_/A _3302_/X _3303_/X _3302_/B _5158_/Q VGND VGND VPWR VPWR _3315_/B
+ sky130_fd_sc_hd__a32o_2
X_3245_ _5260_/Q input13/X _3227_/X VGND VGND VPWR VPWR _3245_/X sky130_fd_sc_hd__a21o_2
XFILLER_86_516 VGND VGND VPWR VPWR sky130_fd_sc_hd__decap_3
XFILLER_39_421 VGND VGND VPWR VPWR sky130_fd_sc_hd__decap_3
XFILLER_39_476 VGND VGND VPWR VPWR sky130_fd_sc_hd__decap_3
XFILLER_66_262 VGND VGND VPWR VPWR sky130_fd_sc_hd__decap_3
X_3176_ _2906_/X _3185_/A2 _3185_/B1 _5078_/Q VGND VGND VPWR VPWR _5078_/D sky130_fd_sc_hd__a22o_2
XTAP_TAPCELL_ROW_1_214 VGND VPWR sky130_fd_sc_hd__tapvpwrvgnd_1
XFILLER_26_137 VGND VGND VPWR VPWR sky130_fd_sc_hd__decap_3
XFILLER_54_424 VGND VGND VPWR VPWR sky130_fd_sc_hd__decap_3
XFILLER_66_295 VGND VGND VPWR VPWR sky130_fd_sc_hd__decap_3
XFILLER_54_457 VGND VGND VPWR VPWR sky130_fd_sc_hd__decap_3
XFILLER_81_287 VGND VGND VPWR VPWR sky130_fd_sc_hd__decap_3
XFILLER_81_276 VGND VGND VPWR VPWR sky130_fd_sc_hd__decap_3
XFILLER_22_332 VGND VGND VPWR VPWR sky130_fd_sc_hd__decap_3
XFILLER_34_192 VGND VGND VPWR VPWR sky130_fd_sc_hd__decap_3
XFILLER_22_398 VGND VGND VPWR VPWR sky130_fd_sc_hd__decap_3
XFILLER_1_225 VGND VGND VPWR VPWR sky130_fd_sc_hd__decap_3
XFILLER_89_310 VGND VGND VPWR VPWR sky130_fd_sc_hd__decap_3
XFILLER_89_343 VGND VGND VPWR VPWR sky130_fd_sc_hd__decap_3
XFILLER_77_505 VGND VGND VPWR VPWR sky130_fd_sc_hd__decap_3
XFILLER_89_387 VGND VGND VPWR VPWR sky130_fd_sc_hd__decap_3
XFILLER_45_402 VGND VGND VPWR VPWR sky130_fd_sc_hd__decap_3
XFILLER_17_159 VGND VGND VPWR VPWR sky130_fd_sc_hd__decap_3
XFILLER_72_232 VGND VGND VPWR VPWR sky130_fd_sc_hd__decap_3
XFILLER_60_427 VGND VGND VPWR VPWR sky130_fd_sc_hd__decap_3
XFILLER_72_276 VGND VGND VPWR VPWR sky130_fd_sc_hd__decap_3
XTAP_TAPCELL_ROW_43_614 VGND VPWR sky130_fd_sc_hd__tapvpwrvgnd_1
XFILLER_82_66 VGND VGND VPWR VPWR sky130_fd_sc_hd__decap_3
XFILLER_82_44 VGND VGND VPWR VPWR sky130_fd_sc_hd__decap_3
XFILLER_13_332 VGND VGND VPWR VPWR sky130_fd_sc_hd__decap_3
XFILLER_82_88 VGND VGND VPWR VPWR sky130_fd_sc_hd__decap_3
XFILLER_40_184 VGND VGND VPWR VPWR sky130_fd_sc_hd__decap_3
Xoutput70 _5142_/Q VGND VGND VPWR VPWR INSTR_ADDR[9] sky130_fd_sc_hd__clkdlybuf4s25_1
XTAP_TAPCELL_ROW_91_1064 VGND VPWR sky130_fd_sc_hd__tapvpwrvgnd_1
XFILLER_68_516 VGND VGND VPWR VPWR sky130_fd_sc_hd__decap_3
Xoutput81 _2887_/Y VGND VGND VPWR VPWR MEM_ADDR[14] sky130_fd_sc_hd__clkdlybuf4s25_1
Xoutput92 _2716_/X VGND VGND VPWR VPWR MEM_STR_DATA[0] sky130_fd_sc_hd__clkdlybuf4s25_1
X_3030_ _2913_/X _3024_/B _3024_/Y _4952_/Q VGND VGND VPWR VPWR _4952_/D sky130_fd_sc_hd__a22o_2
XFILLER_36_413 VGND VGND VPWR VPWR sky130_fd_sc_hd__decap_3
XFILLER_23_107 VGND VGND VPWR VPWR sky130_fd_sc_hd__decap_3
XFILLER_51_438 VGND VGND VPWR VPWR sky130_fd_sc_hd__fill_2
X_4981_ _5109_/CLK _4981_/D VGND VGND VPWR VPWR _4981_/Q sky130_fd_sc_hd__dfxtp_2
X_3932_ _3932_/A _3932_/B _3932_/C VGND VGND VPWR VPWR _3932_/Y sky130_fd_sc_hd__nand3_2
XFILLER_31_140 VGND VGND VPWR VPWR sky130_fd_sc_hd__fill_1
X_3863_ _5154_/Q _4404_/S _3861_/X VGND VGND VPWR VPWR _4339_/A sky130_fd_sc_hd__o21ai_2
XFILLER_31_162 VGND VGND VPWR VPWR sky130_fd_sc_hd__decap_3
X_2814_ _2808_/X _2810_/X _2813_/X _2437_/Y VGND VGND VPWR VPWR _3352_/B sky130_fd_sc_hd__a22o_2
X_3794_ _3794_/A _3794_/B VGND VGND VPWR VPWR _4149_/A sky130_fd_sc_hd__nor2_2
X_2745_ _5063_/Q _5047_/Q _5031_/Q _5015_/Q _2812_/S0 _2848_/S1 VGND VGND VPWR VPWR
+ _2745_/X sky130_fd_sc_hd__mux4_2
X_2676_ _5162_/Q _4432_/B VGND VGND VPWR VPWR _4732_/S sky130_fd_sc_hd__or2_2
X_4415_ _4473_/A _4523_/S _4343_/Y VGND VGND VPWR VPWR _4578_/B sky130_fd_sc_hd__a21o_2
X_4346_ _4346_/A _4346_/B VGND VGND VPWR VPWR _4796_/A sky130_fd_sc_hd__or2_2
XFILLER_59_505 VGND VGND VPWR VPWR sky130_fd_sc_hd__decap_3
X_4277_ _4546_/A _4277_/B _4277_/C VGND VGND VPWR VPWR _4277_/X sky130_fd_sc_hd__or3_2
XFILLER_86_324 VGND VGND VPWR VPWR sky130_fd_sc_hd__decap_3
XFILLER_39_251 VGND VGND VPWR VPWR sky130_fd_sc_hd__fill_1
X_3228_ _4714_/A _3450_/C VGND VGND VPWR VPWR _3228_/Y sky130_fd_sc_hd__nor2_4
XFILLER_39_284 VGND VGND VPWR VPWR sky130_fd_sc_hd__decap_3
X_3159_ _2910_/X _3170_/A2 _3170_/B1 _5063_/Q VGND VGND VPWR VPWR _5063_/D sky130_fd_sc_hd__a22o_2
XTAP_TAPCELL_ROW_57_739 VGND VPWR sky130_fd_sc_hd__tapvpwrvgnd_1
XFILLER_82_552 VGND VGND VPWR VPWR sky130_fd_sc_hd__fill_1
XFILLER_42_427 VGND VGND VPWR VPWR sky130_fd_sc_hd__decap_3
XFILLER_14_129 VGND VGND VPWR VPWR sky130_fd_sc_hd__fill_1
XFILLER_52_25 VGND VGND VPWR VPWR sky130_fd_sc_hd__decap_3
XFILLER_52_47 VGND VGND VPWR VPWR sky130_fd_sc_hd__decap_3
XFILLER_10_324 VGND VGND VPWR VPWR sky130_fd_sc_hd__fill_1
XFILLER_22_173 VGND VGND VPWR VPWR sky130_fd_sc_hd__decap_3
XTAP_TAPCELL_ROW_12_319 VGND VPWR sky130_fd_sc_hd__tapvpwrvgnd_1
XFILLER_22_195 VGND VGND VPWR VPWR sky130_fd_sc_hd__fill_1
XTAP_TAPCELL_ROW_20_396 VGND VPWR sky130_fd_sc_hd__tapvpwrvgnd_1
XFILLER_2_523 VGND VGND VPWR VPWR sky130_fd_sc_hd__fill_1
XFILLER_7_3 VGND VGND VPWR VPWR sky130_fd_sc_hd__decap_3
XFILLER_77_302 VGND VGND VPWR VPWR sky130_fd_sc_hd__decap_3
XFILLER_77_346 VGND VGND VPWR VPWR sky130_fd_sc_hd__decap_3
XFILLER_77_335 VGND VGND VPWR VPWR sky130_fd_sc_hd__fill_1
XFILLER_65_508 VGND VGND VPWR VPWR sky130_fd_sc_hd__decap_3
XFILLER_77_99 VGND VGND VPWR VPWR sky130_fd_sc_hd__decap_3
XFILLER_18_402 VGND VGND VPWR VPWR sky130_fd_sc_hd__decap_3
XFILLER_18_413 VGND VGND VPWR VPWR sky130_fd_sc_hd__decap_3
XFILLER_18_424 VGND VGND VPWR VPWR sky130_fd_sc_hd__decap_3
XFILLER_93_32 VGND VGND VPWR VPWR sky130_fd_sc_hd__decap_3
XFILLER_93_21 VGND VGND VPWR VPWR sky130_fd_sc_hd__decap_3
XFILLER_92_349 VGND VGND VPWR VPWR sky130_fd_sc_hd__decap_3
XFILLER_18_457 VGND VGND VPWR VPWR sky130_fd_sc_hd__decap_3
XFILLER_45_254 VGND VGND VPWR VPWR sky130_fd_sc_hd__decap_3
XFILLER_73_541 VGND VGND VPWR VPWR sky130_fd_sc_hd__decap_3
XFILLER_93_54 VGND VGND VPWR VPWR sky130_fd_sc_hd__fill_2
XFILLER_45_287 VGND VGND VPWR VPWR sky130_fd_sc_hd__decap_3
XTAP_TAPCELL_ROW_28_463 VGND VPWR sky130_fd_sc_hd__tapvpwrvgnd_1
XFILLER_26_490 VGND VGND VPWR VPWR sky130_fd_sc_hd__decap_3
XFILLER_33_449 VGND VGND VPWR VPWR sky130_fd_sc_hd__decap_3
XFILLER_60_224 VGND VGND VPWR VPWR sky130_fd_sc_hd__fill_1
XFILLER_41_493 VGND VGND VPWR VPWR sky130_fd_sc_hd__fill_1
XFILLER_42_80 VGND VGND VPWR VPWR sky130_fd_sc_hd__decap_3
XFILLER_42_91 VGND VGND VPWR VPWR sky130_fd_sc_hd__decap_3
X_2530_ _2667_/A _2527_/X _5126_/Q VGND VGND VPWR VPWR _2530_/X sky130_fd_sc_hd__o21a_2
X_2461_ _5183_/Q _5182_/Q _2889_/A _2461_/D VGND VGND VPWR VPWR _4850_/A sky130_fd_sc_hd__and4b_2
X_4200_ _4528_/A _4200_/B VGND VGND VPWR VPWR _4200_/Y sky130_fd_sc_hd__nand2_2
X_5180_ _5254_/CLK _5180_/D VGND VGND VPWR VPWR _5180_/Q sky130_fd_sc_hd__dfxtp_2
XFILLER_3_74 VGND VGND VPWR VPWR sky130_fd_sc_hd__decap_3
X_4131_ _4173_/A _4008_/X _4076_/Y VGND VGND VPWR VPWR _4132_/B sky130_fd_sc_hd__o21a_2
XFILLER_56_519 VGND VGND VPWR VPWR sky130_fd_sc_hd__decap_3
XFILLER_68_368 VGND VGND VPWR VPWR sky130_fd_sc_hd__fill_2
X_4062_ _3953_/Y _3956_/Y _4063_/A VGND VGND VPWR VPWR _4062_/X sky130_fd_sc_hd__mux2_1
X_3013_ _2916_/X _3006_/B _3006_/Y _4937_/Q VGND VGND VPWR VPWR _4937_/D sky130_fd_sc_hd__a22o_2
XFILLER_83_316 VGND VGND VPWR VPWR sky130_fd_sc_hd__decap_3
XFILLER_36_243 VGND VGND VPWR VPWR sky130_fd_sc_hd__decap_3
XFILLER_64_530 VGND VGND VPWR VPWR sky130_fd_sc_hd__fill_2
XFILLER_24_427 VGND VGND VPWR VPWR sky130_fd_sc_hd__decap_3
XFILLER_36_265 VGND VGND VPWR VPWR sky130_fd_sc_hd__decap_3
XFILLER_91_360 VGND VGND VPWR VPWR sky130_fd_sc_hd__decap_3
X_4964_ _5119_/CLK _4964_/D VGND VGND VPWR VPWR _4964_/Q sky130_fd_sc_hd__dfxtp_2
XFILLER_91_393 VGND VGND VPWR VPWR sky130_fd_sc_hd__fill_1
XFILLER_51_268 VGND VGND VPWR VPWR sky130_fd_sc_hd__decap_3
X_3915_ _3767_/B _4551_/A VGND VGND VPWR VPWR _3916_/B sky130_fd_sc_hd__and2b_2
X_4895_ _5103_/CLK _4895_/D VGND VGND VPWR VPWR _4895_/Q sky130_fd_sc_hd__dfxtp_2
XTAP_TAPCELL_ROW_62_786 VGND VPWR sky130_fd_sc_hd__tapvpwrvgnd_1
X_3846_ _4149_/A _4191_/A VGND VGND VPWR VPWR _3900_/A sky130_fd_sc_hd__or2_2
X_3777_ _4614_/A _3910_/B VGND VGND VPWR VPWR _3779_/A sky130_fd_sc_hd__nor2_2
X_2728_ _2726_/X _2727_/X _2831_/S VGND VGND VPWR VPWR _2728_/X sky130_fd_sc_hd__mux2_1
X_2659_ _2657_/X _2658_/X _2667_/A VGND VGND VPWR VPWR _2659_/X sky130_fd_sc_hd__mux2_1
XFILLER_59_335 VGND VGND VPWR VPWR sky130_fd_sc_hd__fill_1
XFILLER_59_346 VGND VGND VPWR VPWR sky130_fd_sc_hd__decap_3
X_4329_ _5219_/Q _4700_/S _4310_/Y _4328_/Y _3442_/B VGND VGND VPWR VPWR _5219_/D
+ sky130_fd_sc_hd__o221a_2
XFILLER_86_132 VGND VGND VPWR VPWR sky130_fd_sc_hd__decap_3
XFILLER_86_110 VGND VGND VPWR VPWR sky130_fd_sc_hd__fill_1
XFILLER_47_69 VGND VGND VPWR VPWR sky130_fd_sc_hd__decap_3
XFILLER_74_327 VGND VGND VPWR VPWR sky130_fd_sc_hd__decap_3
XFILLER_74_338 VGND VGND VPWR VPWR sky130_fd_sc_hd__decap_3
XFILLER_27_221 VGND VGND VPWR VPWR sky130_fd_sc_hd__decap_3
XFILLER_67_390 VGND VGND VPWR VPWR sky130_fd_sc_hd__fill_2
XFILLER_63_24 VGND VGND VPWR VPWR sky130_fd_sc_hd__decap_3
XFILLER_70_511 VGND VGND VPWR VPWR sky130_fd_sc_hd__decap_3
XFILLER_15_449 VGND VGND VPWR VPWR sky130_fd_sc_hd__decap_3
XFILLER_42_224 VGND VGND VPWR VPWR sky130_fd_sc_hd__decap_3
XFILLER_63_57 VGND VGND VPWR VPWR sky130_fd_sc_hd__decap_3
XFILLER_82_382 VGND VGND VPWR VPWR sky130_fd_sc_hd__decap_3
XFILLER_42_257 VGND VGND VPWR VPWR sky130_fd_sc_hd__decap_3
XFILLER_6_103 VGND VGND VPWR VPWR sky130_fd_sc_hd__fill_1
XFILLER_12_94 VGND VGND VPWR VPWR sky130_fd_sc_hd__decap_3
XFILLER_88_32 VGND VGND VPWR VPWR sky130_fd_sc_hd__decap_3
XFILLER_26_9 VGND VGND VPWR VPWR sky130_fd_sc_hd__fill_1
XFILLER_38_519 VGND VGND VPWR VPWR sky130_fd_sc_hd__fill_1
XFILLER_65_327 VGND VGND VPWR VPWR sky130_fd_sc_hd__decap_3
XFILLER_46_552 VGND VGND VPWR VPWR sky130_fd_sc_hd__fill_1
XFILLER_65_349 VGND VGND VPWR VPWR sky130_fd_sc_hd__decap_3
XFILLER_61_500 VGND VGND VPWR VPWR sky130_fd_sc_hd__decap_3
XFILLER_61_511 VGND VGND VPWR VPWR sky130_fd_sc_hd__decap_3
X_3700_ _3698_/X _3699_/X _5129_/Q VGND VGND VPWR VPWR _3700_/X sky130_fd_sc_hd__mux2_1
XFILLER_41_290 VGND VGND VPWR VPWR sky130_fd_sc_hd__decap_3
X_4680_ _2621_/A _3874_/D _3847_/A _3793_/Y _4678_/X VGND VGND VPWR VPWR _4680_/X
+ sky130_fd_sc_hd__o221a_2
X_3631_ _3631_/A VGND VGND VPWR VPWR _3631_/Y sky130_fd_sc_hd__inv_2
X_3562_ _3555_/A _3555_/B _3555_/C VGND VGND VPWR VPWR _3563_/B sky130_fd_sc_hd__o21ba_2
X_2513_ _5164_/Q _4471_/B VGND VGND VPWR VPWR _2684_/A sky130_fd_sc_hd__nand2_2
XFILLER_5_191 VGND VGND VPWR VPWR sky130_fd_sc_hd__decap_3
X_3493_ _5155_/Q _5136_/Q VGND VGND VPWR VPWR _3496_/B sky130_fd_sc_hd__or2_2
X_5232_ _5253_/CLK _5232_/D VGND VGND VPWR VPWR _5232_/Q sky130_fd_sc_hd__dfxtp_2
X_2444_ _3867_/A _4171_/A VGND VGND VPWR VPWR _4547_/A sky130_fd_sc_hd__or2_2
X_5163_ _5253_/CLK _5163_/D VGND VGND VPWR VPWR _5163_/Q sky130_fd_sc_hd__dfxtp_2
XFILLER_68_154 VGND VGND VPWR VPWR sky130_fd_sc_hd__decap_3
X_4114_ _3932_/B _3932_/C _3932_/A VGND VGND VPWR VPWR _4114_/X sky130_fd_sc_hd__a21o_2
XFILLER_56_327 VGND VGND VPWR VPWR sky130_fd_sc_hd__fill_1
XFILLER_56_338 VGND VGND VPWR VPWR sky130_fd_sc_hd__decap_3
X_5094_ _5094_/CLK _5094_/D VGND VGND VPWR VPWR _5094_/Q sky130_fd_sc_hd__dfxtp_2
XTAP_TAPCELL_ROW_67_834 VGND VPWR sky130_fd_sc_hd__tapvpwrvgnd_1
XFILLER_83_113 VGND VGND VPWR VPWR sky130_fd_sc_hd__decap_3
XFILLER_37_552 VGND VGND VPWR VPWR sky130_fd_sc_hd__fill_1
X_4045_ _4044_/X _4421_/C _4340_/A VGND VGND VPWR VPWR _4046_/B sky130_fd_sc_hd__mux2_1
XFILLER_64_371 VGND VGND VPWR VPWR sky130_fd_sc_hd__decap_3
XTAP_TAPCELL_ROW_39_569 VGND VPWR sky130_fd_sc_hd__tapvpwrvgnd_1
XFILLER_52_522 VGND VGND VPWR VPWR sky130_fd_sc_hd__decap_3
XFILLER_52_533 VGND VGND VPWR VPWR sky130_fd_sc_hd__decap_3
XFILLER_24_279 VGND VGND VPWR VPWR sky130_fd_sc_hd__decap_3
X_4947_ _4982_/CLK _4947_/D VGND VGND VPWR VPWR _4947_/Q sky130_fd_sc_hd__dfxtp_2
XTAP_TAPCELL_ROW_22_414 VGND VPWR sky130_fd_sc_hd__tapvpwrvgnd_1
X_4878_ _5100_/CLK _4878_/D VGND VGND VPWR VPWR _4878_/Q sky130_fd_sc_hd__dfxtp_2
X_3829_ _4887_/Q _4871_/Q _5095_/Q _5079_/Q _3834_/S0 _3834_/S1 VGND VGND VPWR VPWR
+ _3829_/X sky130_fd_sc_hd__mux4_2
XTAP_TAPCELL_ROW_30_491 VGND VPWR sky130_fd_sc_hd__tapvpwrvgnd_1
XFILLER_79_419 VGND VGND VPWR VPWR sky130_fd_sc_hd__decap_3
XFILLER_79_408 VGND VGND VPWR VPWR sky130_fd_sc_hd__decap_3
XFILLER_58_35 VGND VGND VPWR VPWR sky130_fd_sc_hd__decap_3
XFILLER_59_121 VGND VGND VPWR VPWR sky130_fd_sc_hd__fill_1
XFILLER_58_57 VGND VGND VPWR VPWR sky130_fd_sc_hd__fill_2
XFILLER_87_452 VGND VGND VPWR VPWR sky130_fd_sc_hd__decap_3
XFILLER_87_441 VGND VGND VPWR VPWR sky130_fd_sc_hd__decap_3
XFILLER_47_327 VGND VGND VPWR VPWR sky130_fd_sc_hd__decap_3
XFILLER_87_474 VGND VGND VPWR VPWR sky130_fd_sc_hd__decap_3
XFILLER_28_530 VGND VGND VPWR VPWR sky130_fd_sc_hd__fill_2
XFILLER_28_541 VGND VGND VPWR VPWR sky130_fd_sc_hd__decap_3
XFILLER_74_179 VGND VGND VPWR VPWR sky130_fd_sc_hd__decap_3
XFILLER_55_382 VGND VGND VPWR VPWR sky130_fd_sc_hd__fill_1
XFILLER_55_393 VGND VGND VPWR VPWR sky130_fd_sc_hd__decap_3
XFILLER_70_363 VGND VGND VPWR VPWR sky130_fd_sc_hd__fill_1
XFILLER_70_374 VGND VGND VPWR VPWR sky130_fd_sc_hd__decap_3
XFILLER_90_55 VGND VGND VPWR VPWR sky130_fd_sc_hd__fill_2
XFILLER_23_290 VGND VGND VPWR VPWR sky130_fd_sc_hd__fill_1
XFILLER_23_60 VGND VGND VPWR VPWR sky130_fd_sc_hd__fill_1
XFILLER_11_485 VGND VGND VPWR VPWR sky130_fd_sc_hd__decap_3
XFILLER_7_434 VGND VGND VPWR VPWR sky130_fd_sc_hd__fill_1
Xmax_cap109 _3226_/Y VGND VGND VPWR VPWR _3450_/C sky130_fd_sc_hd__buf_4
XFILLER_24_6 VGND VGND VPWR VPWR sky130_fd_sc_hd__decap_3
XFILLER_78_441 VGND VGND VPWR VPWR sky130_fd_sc_hd__decap_3
XFILLER_65_113 VGND VGND VPWR VPWR sky130_fd_sc_hd__decap_3
XTAP_TAPCELL_ROW_88_1036 VGND VPWR sky130_fd_sc_hd__tapvpwrvgnd_1
XFILLER_93_455 VGND VGND VPWR VPWR sky130_fd_sc_hd__decap_3
XFILLER_93_433 VGND VGND VPWR VPWR sky130_fd_sc_hd__decap_3
XFILLER_19_552 VGND VGND VPWR VPWR sky130_fd_sc_hd__fill_1
XFILLER_46_360 VGND VGND VPWR VPWR sky130_fd_sc_hd__decap_3
XFILLER_53_308 VGND VGND VPWR VPWR sky130_fd_sc_hd__decap_3
XFILLER_93_477 VGND VGND VPWR VPWR sky130_fd_sc_hd__decap_3
XFILLER_0_75 VGND VGND VPWR VPWR sky130_fd_sc_hd__fill_1
XFILLER_34_511 VGND VGND VPWR VPWR sky130_fd_sc_hd__decap_3
XFILLER_34_544 VGND VGND VPWR VPWR sky130_fd_sc_hd__decap_3
XTAP_TAPCELL_ROW_36_539 VGND VPWR sky130_fd_sc_hd__tapvpwrvgnd_1
XFILLER_0_97 VGND VGND VPWR VPWR sky130_fd_sc_hd__fill_2
XFILLER_61_374 VGND VGND VPWR VPWR sky130_fd_sc_hd__decap_3
X_4801_ _4614_/A _4787_/S _3955_/Y VGND VGND VPWR VPWR _4802_/B sky130_fd_sc_hd__o21ai_2
X_2993_ _2913_/X _2987_/B _2987_/Y _4920_/Q VGND VGND VPWR VPWR _4920_/D sky130_fd_sc_hd__a22o_2
XTAP_TAPCELL_ROW_72_881 VGND VPWR sky130_fd_sc_hd__tapvpwrvgnd_1
XFILLER_21_238 VGND VGND VPWR VPWR sky130_fd_sc_hd__fill_1
X_4732_ _4333_/B _2443_/Y _4732_/S VGND VGND VPWR VPWR _4732_/X sky130_fd_sc_hd__mux2_1
X_4663_ _2443_/Y _2617_/B _3934_/C _4224_/A VGND VGND VPWR VPWR _4666_/C sky130_fd_sc_hd__o2bb2a_2
X_3614_ _4948_/Q _4932_/Q _4916_/Q _4900_/Q _3834_/S0 _3834_/S1 VGND VGND VPWR VPWR
+ _3614_/X sky130_fd_sc_hd__mux4_2
X_4594_ _4048_/A _4224_/A _4246_/A _4040_/A _4591_/X VGND VGND VPWR VPWR _4595_/C
+ sky130_fd_sc_hd__o221a_2
X_3545_ _5162_/Q _5143_/Q VGND VGND VPWR VPWR _3546_/B sky130_fd_sc_hd__or2_2
X_3476_ _4866_/A _3476_/B VGND VGND VPWR VPWR _5190_/D sky130_fd_sc_hd__nor2_2
X_5215_ _5221_/CLK _5215_/D VGND VGND VPWR VPWR _5215_/Q sky130_fd_sc_hd__dfxtp_2
X_2427_ _5180_/Q VGND VGND VPWR VPWR _2461_/D sky130_fd_sc_hd__inv_2
XFILLER_69_441 VGND VGND VPWR VPWR sky130_fd_sc_hd__decap_3
XFILLER_69_452 VGND VGND VPWR VPWR sky130_fd_sc_hd__decap_3
XFILLER_28_16 VGND VGND VPWR VPWR sky130_fd_sc_hd__fill_1
XFILLER_28_38 VGND VGND VPWR VPWR sky130_fd_sc_hd__decap_3
XFILLER_29_305 VGND VGND VPWR VPWR sky130_fd_sc_hd__decap_3
X_5146_ _5164_/CLK _5146_/D VGND VGND VPWR VPWR _5146_/Q sky130_fd_sc_hd__dfxtp_2
X_5077_ _5078_/CLK _5077_/D VGND VGND VPWR VPWR _5077_/Q sky130_fd_sc_hd__dfxtp_2
XFILLER_84_444 VGND VGND VPWR VPWR sky130_fd_sc_hd__decap_3
X_4028_ _3641_/X _3647_/X _4063_/A VGND VGND VPWR VPWR _4029_/B sky130_fd_sc_hd__mux2_1
XFILLER_84_477 VGND VGND VPWR VPWR sky130_fd_sc_hd__decap_3
XFILLER_71_116 VGND VGND VPWR VPWR sky130_fd_sc_hd__decap_3
XFILLER_52_330 VGND VGND VPWR VPWR sky130_fd_sc_hd__decap_3
XFILLER_12_216 VGND VGND VPWR VPWR sky130_fd_sc_hd__fill_2
XFILLER_40_536 VGND VGND VPWR VPWR sky130_fd_sc_hd__fill_1
XFILLER_52_363 VGND VGND VPWR VPWR sky130_fd_sc_hd__fill_1
XFILLER_60_25 VGND VGND VPWR VPWR sky130_fd_sc_hd__decap_3
XFILLER_4_448 VGND VGND VPWR VPWR sky130_fd_sc_hd__decap_3
XFILLER_69_78 VGND VGND VPWR VPWR sky130_fd_sc_hd__fill_2
XTAP_TAPCELL_ROW_7_264 VGND VPWR sky130_fd_sc_hd__tapvpwrvgnd_1
XFILLER_47_102 VGND VGND VPWR VPWR sky130_fd_sc_hd__decap_3
XFILLER_47_113 VGND VGND VPWR VPWR sky130_fd_sc_hd__decap_3
XFILLER_75_422 VGND VGND VPWR VPWR sky130_fd_sc_hd__decap_3
XFILLER_87_293 VGND VGND VPWR VPWR sky130_fd_sc_hd__decap_3
XFILLER_75_455 VGND VGND VPWR VPWR sky130_fd_sc_hd__decap_3
XFILLER_35_308 VGND VGND VPWR VPWR sky130_fd_sc_hd__decap_3
XFILLER_75_488 VGND VGND VPWR VPWR sky130_fd_sc_hd__fill_1
XFILLER_18_82 VGND VGND VPWR VPWR sky130_fd_sc_hd__fill_2
XFILLER_43_330 VGND VGND VPWR VPWR sky130_fd_sc_hd__decap_3
XFILLER_43_363 VGND VGND VPWR VPWR sky130_fd_sc_hd__decap_3
XFILLER_34_81 VGND VGND VPWR VPWR sky130_fd_sc_hd__decap_3
XFILLER_43_396 VGND VGND VPWR VPWR sky130_fd_sc_hd__decap_3
XFILLER_70_182 VGND VGND VPWR VPWR sky130_fd_sc_hd__fill_1
XFILLER_93_9 VGND VGND VPWR VPWR sky130_fd_sc_hd__decap_3
XFILLER_7_242 VGND VGND VPWR VPWR sky130_fd_sc_hd__decap_3
X_3330_ _5141_/Q _3337_/A _3329_/Y _3448_/B VGND VGND VPWR VPWR _5141_/D sky130_fd_sc_hd__o211a_2
X_5000_ _5112_/CLK _5000_/D VGND VGND VPWR VPWR _5000_/Q sky130_fd_sc_hd__dfxtp_2
X_3261_ _3406_/A _3406_/B _3258_/Y VGND VGND VPWR VPWR _3262_/B sky130_fd_sc_hd__o21ai_2
XFILLER_22_3 VGND VGND VPWR VPWR sky130_fd_sc_hd__decap_3
XFILLER_38_102 VGND VGND VPWR VPWR sky130_fd_sc_hd__fill_2
X_3192_ _2900_/X _3203_/A2 _3203_/B1 _5092_/Q VGND VGND VPWR VPWR _5092_/D sky130_fd_sc_hd__a22o_2
XFILLER_66_433 VGND VGND VPWR VPWR sky130_fd_sc_hd__decap_3
XFILLER_66_477 VGND VGND VPWR VPWR sky130_fd_sc_hd__decap_3
XTAP_TAPCELL_ROW_49_664 VGND VPWR sky130_fd_sc_hd__tapvpwrvgnd_1
XFILLER_19_371 VGND VGND VPWR VPWR sky130_fd_sc_hd__decap_3
XFILLER_19_393 VGND VGND VPWR VPWR sky130_fd_sc_hd__decap_3
XFILLER_93_296 VGND VGND VPWR VPWR sky130_fd_sc_hd__decap_3
XFILLER_34_352 VGND VGND VPWR VPWR sky130_fd_sc_hd__decap_3
XFILLER_34_396 VGND VGND VPWR VPWR sky130_fd_sc_hd__decap_3
X_2976_ _2919_/X _2984_/A2 _2968_/Y _4906_/Q VGND VGND VPWR VPWR _4906_/D sky130_fd_sc_hd__a22o_2
X_4715_ _4641_/X _4715_/B VGND VGND VPWR VPWR _4715_/Y sky130_fd_sc_hd__nand2b_2
X_4646_ _2449_/Y _2452_/Y _4646_/S VGND VGND VPWR VPWR _4646_/X sky130_fd_sc_hd__mux2_1
X_4577_ _4411_/A _4414_/A _4624_/A VGND VGND VPWR VPWR _4673_/B sky130_fd_sc_hd__mux2_1
X_3528_ _4866_/A _3528_/B VGND VGND VPWR VPWR _5197_/D sky130_fd_sc_hd__nor2_2
X_3459_ _5184_/Q _4168_/A _3456_/X _3458_/X _3448_/B VGND VGND VPWR VPWR _3459_/X
+ sky130_fd_sc_hd__o221a_2
XFILLER_57_411 VGND VGND VPWR VPWR sky130_fd_sc_hd__decap_3
XFILLER_69_271 VGND VGND VPWR VPWR sky130_fd_sc_hd__decap_3
XFILLER_76_208 VGND VGND VPWR VPWR sky130_fd_sc_hd__decap_3
XFILLER_29_113 VGND VGND VPWR VPWR sky130_fd_sc_hd__decap_3
XFILLER_69_293 VGND VGND VPWR VPWR sky130_fd_sc_hd__decap_3
X_5129_ clkload3/A _5129_/D VGND VGND VPWR VPWR _5129_/Q sky130_fd_sc_hd__dfxtp_2
XFILLER_55_25 VGND VGND VPWR VPWR sky130_fd_sc_hd__decap_3
XFILLER_44_116 VGND VGND VPWR VPWR sky130_fd_sc_hd__fill_1
XFILLER_55_69 VGND VGND VPWR VPWR sky130_fd_sc_hd__decap_3
XFILLER_84_274 VGND VGND VPWR VPWR sky130_fd_sc_hd__decap_3
XFILLER_13_525 VGND VGND VPWR VPWR sky130_fd_sc_hd__decap_3
XFILLER_25_374 VGND VGND VPWR VPWR sky130_fd_sc_hd__fill_1
XFILLER_52_171 VGND VGND VPWR VPWR sky130_fd_sc_hd__fill_1
XTAP_TAPCELL_ROW_83_987 VGND VPWR sky130_fd_sc_hd__tapvpwrvgnd_1
XFILLER_80_480 VGND VGND VPWR VPWR sky130_fd_sc_hd__fill_1
XFILLER_40_333 VGND VGND VPWR VPWR sky130_fd_sc_hd__decap_3
XFILLER_71_35 VGND VGND VPWR VPWR sky130_fd_sc_hd__decap_3
XFILLER_71_57 VGND VGND VPWR VPWR sky130_fd_sc_hd__fill_1
XFILLER_40_388 VGND VGND VPWR VPWR sky130_fd_sc_hd__decap_3
XFILLER_20_61 VGND VGND VPWR VPWR sky130_fd_sc_hd__decap_3
XFILLER_67_208 VGND VGND VPWR VPWR sky130_fd_sc_hd__decap_3
XFILLER_0_495 VGND VGND VPWR VPWR sky130_fd_sc_hd__decap_3
XFILLER_75_252 VGND VGND VPWR VPWR sky130_fd_sc_hd__fill_2
XFILLER_35_116 VGND VGND VPWR VPWR sky130_fd_sc_hd__decap_3
XTAP_TAPCELL_ROW_85_1006 VGND VPWR sky130_fd_sc_hd__tapvpwrvgnd_1
XTAP_TAPCELL_ROW_46_634 VGND VPWR sky130_fd_sc_hd__tapvpwrvgnd_1
XTAP_TAPCELL_ROW_18_369 VGND VPWR sky130_fd_sc_hd__tapvpwrvgnd_1
XFILLER_90_299 VGND VGND VPWR VPWR sky130_fd_sc_hd__fill_1
XFILLER_90_266 VGND VGND VPWR VPWR sky130_fd_sc_hd__fill_1
X_2830_ _5120_/Q _5008_/Q _4992_/Q _4976_/Q _5131_/Q _5132_/Q VGND VGND VPWR VPWR
+ _2830_/X sky130_fd_sc_hd__mux4_2
XFILLER_31_388 VGND VGND VPWR VPWR sky130_fd_sc_hd__decap_3
X_2761_ _2851_/A _3292_/B VGND VGND VPWR VPWR _2761_/X sky130_fd_sc_hd__and2_2
XFILLER_61_90 VGND VGND VPWR VPWR sky130_fd_sc_hd__decap_3
X_4500_ _4500_/A _4500_/B VGND VGND VPWR VPWR _4563_/B sky130_fd_sc_hd__nor2_2
X_2692_ _4547_/A _2695_/B VGND VGND VPWR VPWR _2692_/Y sky130_fd_sc_hd__nor2_2
XFILLER_8_551 VGND VGND VPWR VPWR sky130_fd_sc_hd__fill_2
XANTENNA_1 _4466_/A VGND VGND VPWR VPWR sky130_fd_sc_hd__diode_2
X_4431_ _4468_/A _4432_/B VGND VGND VPWR VPWR _4469_/B sky130_fd_sc_hd__nor2_2
XFILLER_6_85 VGND VGND VPWR VPWR sky130_fd_sc_hd__decap_3
X_4362_ _4337_/Y _4361_/Y _4313_/B VGND VGND VPWR VPWR _4362_/Y sky130_fd_sc_hd__o21ai_2
X_4293_ _4292_/A _4312_/B _4224_/A VGND VGND VPWR VPWR _4293_/X sky130_fd_sc_hd__a21o_2
X_3313_ _3313_/A _3313_/B VGND VGND VPWR VPWR _3315_/A sky130_fd_sc_hd__and2_2
XFILLER_39_411 VGND VGND VPWR VPWR sky130_fd_sc_hd__fill_2
XFILLER_58_208 VGND VGND VPWR VPWR sky130_fd_sc_hd__decap_3
X_3244_ _5167_/Q _3429_/C _3228_/Y _3243_/X VGND VGND VPWR VPWR _5130_/D sky130_fd_sc_hd__o22a_2
XFILLER_39_433 VGND VGND VPWR VPWR sky130_fd_sc_hd__decap_3
XFILLER_39_455 VGND VGND VPWR VPWR sky130_fd_sc_hd__decap_3
XFILLER_54_403 VGND VGND VPWR VPWR sky130_fd_sc_hd__decap_3
XFILLER_66_241 VGND VGND VPWR VPWR sky130_fd_sc_hd__decap_3
X_3175_ _2903_/X _3185_/A2 _3185_/B1 _5077_/Q VGND VGND VPWR VPWR _5077_/D sky130_fd_sc_hd__a22o_2
XTAP_TAPCELL_ROW_1_215 VGND VPWR sky130_fd_sc_hd__tapvpwrvgnd_1
XFILLER_39_488 VGND VGND VPWR VPWR sky130_fd_sc_hd__decap_3
XFILLER_54_436 VGND VGND VPWR VPWR sky130_fd_sc_hd__decap_3
XFILLER_66_274 VGND VGND VPWR VPWR sky130_fd_sc_hd__decap_3
XFILLER_81_200 VGND VGND VPWR VPWR sky130_fd_sc_hd__decap_3
XFILLER_81_255 VGND VGND VPWR VPWR sky130_fd_sc_hd__decap_3
XFILLER_41_108 VGND VGND VPWR VPWR sky130_fd_sc_hd__decap_3
XFILLER_41_119 VGND VGND VPWR VPWR sky130_fd_sc_hd__decap_3
XFILLER_81_299 VGND VGND VPWR VPWR sky130_fd_sc_hd__decap_3
XTAP_TAPCELL_ROW_80_957 VGND VPWR sky130_fd_sc_hd__tapvpwrvgnd_1
XFILLER_10_528 VGND VGND VPWR VPWR sky130_fd_sc_hd__decap_3
X_2959_ _2929_/X _2961_/A2 _2961_/B1 _4893_/Q VGND VGND VPWR VPWR _4893_/D sky130_fd_sc_hd__a22o_2
XFILLER_41_49 VGND VGND VPWR VPWR sky130_fd_sc_hd__decap_3
X_4629_ _4604_/X _4617_/X _4628_/X _4136_/Y VGND VGND VPWR VPWR _4629_/X sky130_fd_sc_hd__a31o_2
XFILLER_89_322 VGND VGND VPWR VPWR sky130_fd_sc_hd__decap_3
XFILLER_1_237 VGND VGND VPWR VPWR sky130_fd_sc_hd__decap_3
XFILLER_89_355 VGND VGND VPWR VPWR sky130_fd_sc_hd__decap_3
XFILLER_89_399 VGND VGND VPWR VPWR sky130_fd_sc_hd__decap_3
XFILLER_77_517 VGND VGND VPWR VPWR sky130_fd_sc_hd__decap_3
XFILLER_66_35 VGND VGND VPWR VPWR sky130_fd_sc_hd__fill_1
XFILLER_57_241 VGND VGND VPWR VPWR sky130_fd_sc_hd__decap_3
XFILLER_66_68 VGND VGND VPWR VPWR sky130_fd_sc_hd__decap_3
XFILLER_66_79 VGND VGND VPWR VPWR sky130_fd_sc_hd__decap_3
XFILLER_92_509 VGND VGND VPWR VPWR sky130_fd_sc_hd__decap_3
XFILLER_85_550 VGND VGND VPWR VPWR sky130_fd_sc_hd__decap_3
XFILLER_17_116 VGND VGND VPWR VPWR sky130_fd_sc_hd__decap_3
XFILLER_72_211 VGND VGND VPWR VPWR sky130_fd_sc_hd__decap_3
XFILLER_45_458 VGND VGND VPWR VPWR sky130_fd_sc_hd__decap_3
XFILLER_72_244 VGND VGND VPWR VPWR sky130_fd_sc_hd__decap_3
XFILLER_32_119 VGND VGND VPWR VPWR sky130_fd_sc_hd__fill_1
XFILLER_60_406 VGND VGND VPWR VPWR sky130_fd_sc_hd__decap_3
XFILLER_72_288 VGND VGND VPWR VPWR sky130_fd_sc_hd__decap_3
XFILLER_53_491 VGND VGND VPWR VPWR sky130_fd_sc_hd__decap_3
XFILLER_60_439 VGND VGND VPWR VPWR sky130_fd_sc_hd__decap_3
XFILLER_82_78 VGND VGND VPWR VPWR sky130_fd_sc_hd__decap_3
XFILLER_13_377 VGND VGND VPWR VPWR sky130_fd_sc_hd__decap_3
XFILLER_40_141 VGND VGND VPWR VPWR sky130_fd_sc_hd__decap_3
XFILLER_9_337 VGND VGND VPWR VPWR sky130_fd_sc_hd__decap_3
Xclkbuf_leaf_41_CLK clkbuf_leaf_8_CLK/A VGND VGND VPWR VPWR _5115_/CLK sky130_fd_sc_hd__clkbuf_8
Xoutput60 _5147_/Q VGND VGND VPWR VPWR INSTR_ADDR[14] sky130_fd_sc_hd__clkdlybuf4s25_1
XFILLER_68_528 VGND VGND VPWR VPWR sky130_fd_sc_hd__decap_3
XFILLER_68_539 VGND VGND VPWR VPWR sky130_fd_sc_hd__decap_3
Xoutput71 _2463_/A VGND VGND VPWR VPWR INVALID_MEM sky130_fd_sc_hd__clkdlybuf4s25_1
Xoutput82 _2697_/Y VGND VGND VPWR VPWR MEM_ADDR[15] sky130_fd_sc_hd__clkdlybuf4s25_1
Xoutput93 _2806_/X VGND VGND VPWR VPWR MEM_STR_DATA[10] sky130_fd_sc_hd__clkdlybuf4s25_1
XTAP_TAPCELL_ROW_91_1065 VGND VPWR sky130_fd_sc_hd__tapvpwrvgnd_1
XFILLER_0_281 VGND VGND VPWR VPWR sky130_fd_sc_hd__decap_3
XFILLER_63_200 VGND VGND VPWR VPWR sky130_fd_sc_hd__decap_3
XFILLER_63_211 VGND VGND VPWR VPWR sky130_fd_sc_hd__decap_3
XFILLER_36_469 VGND VGND VPWR VPWR sky130_fd_sc_hd__decap_3
XFILLER_16_160 VGND VGND VPWR VPWR sky130_fd_sc_hd__fill_1
XFILLER_23_119 VGND VGND VPWR VPWR sky130_fd_sc_hd__decap_3
X_4980_ _5119_/CLK _4980_/D VGND VGND VPWR VPWR _4980_/Q sky130_fd_sc_hd__dfxtp_2
X_3931_ _4048_/A _4048_/B _3930_/B _2613_/A VGND VGND VPWR VPWR _3932_/C sky130_fd_sc_hd__o211ai_2
X_3862_ _5154_/Q _4404_/S _3861_/X VGND VGND VPWR VPWR _4297_/A sky130_fd_sc_hd__o21a_2
X_2813_ _2811_/X _2812_/X _5133_/Q VGND VGND VPWR VPWR _2813_/X sky130_fd_sc_hd__mux2_1
X_3793_ _4464_/B _3885_/B VGND VGND VPWR VPWR _3793_/Y sky130_fd_sc_hd__nand2_2
X_2744_ _4887_/Q _4871_/Q _5095_/Q _5079_/Q _2812_/S0 _2848_/S1 VGND VGND VPWR VPWR
+ _2744_/X sky130_fd_sc_hd__mux4_2
X_2675_ _5162_/Q _4432_/B VGND VGND VPWR VPWR _2678_/A sky130_fd_sc_hd__nand2_2
X_4414_ _4414_/A VGND VGND VPWR VPWR _4414_/Y sky130_fd_sc_hd__inv_2
Xclkbuf_leaf_32_CLK clkload1/A VGND VGND VPWR VPWR _5085_/CLK sky130_fd_sc_hd__clkbuf_8
X_4345_ _4155_/A _4339_/Y _4344_/X _4155_/B _4200_/Y VGND VGND VPWR VPWR _4345_/X
+ sky130_fd_sc_hd__o32a_2
XFILLER_59_517 VGND VGND VPWR VPWR sky130_fd_sc_hd__decap_3
XFILLER_86_303 VGND VGND VPWR VPWR sky130_fd_sc_hd__decap_3
XFILLER_59_539 VGND VGND VPWR VPWR sky130_fd_sc_hd__decap_3
X_4276_ _4275_/B _4275_/C _4285_/B VGND VGND VPWR VPWR _4277_/C sky130_fd_sc_hd__a21oi_2
XFILLER_86_336 VGND VGND VPWR VPWR sky130_fd_sc_hd__decap_3
XFILLER_67_550 VGND VGND VPWR VPWR sky130_fd_sc_hd__decap_3
XFILLER_74_509 VGND VGND VPWR VPWR sky130_fd_sc_hd__decap_3
X_3227_ _5258_/Q _5259_/Q _4168_/A _3227_/D VGND VGND VPWR VPWR _3227_/X sky130_fd_sc_hd__or4_2
XFILLER_54_200 VGND VGND VPWR VPWR sky130_fd_sc_hd__fill_1
X_3158_ _2906_/X _3170_/A2 _3170_/B1 _5062_/Q VGND VGND VPWR VPWR _5062_/D sky130_fd_sc_hd__a22o_2
XFILLER_82_531 VGND VGND VPWR VPWR sky130_fd_sc_hd__fill_1
XFILLER_42_406 VGND VGND VPWR VPWR sky130_fd_sc_hd__decap_3
X_3089_ _2922_/X _3080_/B _3096_/B1 _5003_/Q VGND VGND VPWR VPWR _5003_/D sky130_fd_sc_hd__a22o_2
XFILLER_35_480 VGND VGND VPWR VPWR sky130_fd_sc_hd__decap_3
XFILLER_54_299 VGND VGND VPWR VPWR sky130_fd_sc_hd__fill_1
XFILLER_22_141 VGND VGND VPWR VPWR sky130_fd_sc_hd__fill_2
XFILLER_22_152 VGND VGND VPWR VPWR sky130_fd_sc_hd__decap_3
XFILLER_10_303 VGND VGND VPWR VPWR sky130_fd_sc_hd__decap_3
XFILLER_50_472 VGND VGND VPWR VPWR sky130_fd_sc_hd__decap_3
XFILLER_50_483 VGND VGND VPWR VPWR sky130_fd_sc_hd__decap_3
XFILLER_6_329 VGND VGND VPWR VPWR sky130_fd_sc_hd__decap_3
Xclkbuf_leaf_23_CLK clkload2/A VGND VGND VPWR VPWR _5109_/CLK sky130_fd_sc_hd__clkbuf_8
XFILLER_89_174 VGND VGND VPWR VPWR sky130_fd_sc_hd__decap_3
XFILLER_77_45 VGND VGND VPWR VPWR sky130_fd_sc_hd__decap_3
XFILLER_77_314 VGND VGND VPWR VPWR sky130_fd_sc_hd__decap_3
XFILLER_77_67 VGND VGND VPWR VPWR sky130_fd_sc_hd__decap_3
XFILLER_77_369 VGND VGND VPWR VPWR sky130_fd_sc_hd__decap_3
XFILLER_92_317 VGND VGND VPWR VPWR sky130_fd_sc_hd__decap_3
XFILLER_33_417 VGND VGND VPWR VPWR sky130_fd_sc_hd__decap_3
XFILLER_45_266 VGND VGND VPWR VPWR sky130_fd_sc_hd__decap_3
XFILLER_60_203 VGND VGND VPWR VPWR sky130_fd_sc_hd__fill_1
XTAP_TAPCELL_ROW_28_464 VGND VPWR sky130_fd_sc_hd__tapvpwrvgnd_1
XFILLER_93_77 VGND VGND VPWR VPWR sky130_fd_sc_hd__decap_3
XFILLER_60_269 VGND VGND VPWR VPWR sky130_fd_sc_hd__decap_3
XFILLER_13_185 VGND VGND VPWR VPWR sky130_fd_sc_hd__decap_3
XFILLER_9_134 VGND VGND VPWR VPWR sky130_fd_sc_hd__fill_2
XFILLER_5_340 VGND VGND VPWR VPWR sky130_fd_sc_hd__decap_3
Xclkbuf_leaf_14_CLK clkload0/A VGND VGND VPWR VPWR _5164_/CLK sky130_fd_sc_hd__clkbuf_8
X_2460_ _3457_/C _2459_/Y _5179_/Q _5178_/Q _5177_/Q VGND VGND VPWR VPWR _2460_/X
+ sky130_fd_sc_hd__a2111o_2
X_4130_ _4346_/A _3963_/X _4129_/X VGND VGND VPWR VPWR _4142_/C sky130_fd_sc_hd__o21a_2
XFILLER_68_347 VGND VGND VPWR VPWR sky130_fd_sc_hd__decap_3
X_4061_ _4255_/A _4061_/B VGND VGND VPWR VPWR _4088_/A sky130_fd_sc_hd__nor2_2
XFILLER_36_200 VGND VGND VPWR VPWR sky130_fd_sc_hd__fill_2
X_3012_ _2913_/X _3006_/B _3006_/Y _4936_/Q VGND VGND VPWR VPWR _4936_/D sky130_fd_sc_hd__a22o_2
XFILLER_64_542 VGND VGND VPWR VPWR sky130_fd_sc_hd__decap_3
XFILLER_76_380 VGND VGND VPWR VPWR sky130_fd_sc_hd__decap_3
XFILLER_36_277 VGND VGND VPWR VPWR sky130_fd_sc_hd__decap_3
XFILLER_17_480 VGND VGND VPWR VPWR sky130_fd_sc_hd__decap_3
X_4963_ _5112_/CLK _4963_/D VGND VGND VPWR VPWR _4963_/Q sky130_fd_sc_hd__dfxtp_2
XFILLER_51_258 VGND VGND VPWR VPWR sky130_fd_sc_hd__decap_3
X_3914_ _4360_/A _3916_/A VGND VGND VPWR VPWR _3914_/X sky130_fd_sc_hd__or2_2
XFILLER_32_461 VGND VGND VPWR VPWR sky130_fd_sc_hd__decap_3
X_4894_ _5118_/CLK _4894_/D VGND VGND VPWR VPWR _4894_/Q sky130_fd_sc_hd__dfxtp_2
XTAP_TAPCELL_ROW_62_787 VGND VPWR sky130_fd_sc_hd__tapvpwrvgnd_1
X_3845_ _4040_/A _4091_/A _3845_/C VGND VGND VPWR VPWR _3847_/C sky130_fd_sc_hd__or3_2
X_3776_ _3770_/X _3772_/X _3775_/X _2432_/Y VGND VGND VPWR VPWR _3910_/B sky130_fd_sc_hd__a22o_2
X_2727_ _4885_/Q _4869_/Q _5093_/Q _5077_/Q _2812_/S0 _2848_/S1 VGND VGND VPWR VPWR
+ _2727_/X sky130_fd_sc_hd__mux4_2
X_2658_ _5118_/Q _5006_/Q _4990_/Q _4974_/Q _2658_/S0 _2671_/S1 VGND VGND VPWR VPWR
+ _2658_/X sky130_fd_sc_hd__mux4_2
XFILLER_59_303 VGND VGND VPWR VPWR sky130_fd_sc_hd__decap_3
X_2589_ _5125_/Q _2586_/X _5126_/Q VGND VGND VPWR VPWR _2589_/X sky130_fd_sc_hd__o21a_2
X_4328_ _4246_/A _4326_/Y _4327_/X VGND VGND VPWR VPWR _4328_/Y sky130_fd_sc_hd__o21ai_2
XFILLER_47_37 VGND VGND VPWR VPWR sky130_fd_sc_hd__decap_3
XFILLER_59_358 VGND VGND VPWR VPWR sky130_fd_sc_hd__decap_3
X_4259_ _4115_/A _2877_/B _4253_/X _4258_/X VGND VGND VPWR VPWR _4259_/Y sky130_fd_sc_hd__o211ai_2
XFILLER_86_144 VGND VGND VPWR VPWR sky130_fd_sc_hd__fill_1
XFILLER_86_188 VGND VGND VPWR VPWR sky130_fd_sc_hd__decap_3
XFILLER_82_394 VGND VGND VPWR VPWR sky130_fd_sc_hd__decap_3
XFILLER_63_69 VGND VGND VPWR VPWR sky130_fd_sc_hd__decap_3
XFILLER_10_188 VGND VGND VPWR VPWR sky130_fd_sc_hd__decap_3
XFILLER_88_55 VGND VGND VPWR VPWR sky130_fd_sc_hd__decap_3
XFILLER_88_99 VGND VGND VPWR VPWR sky130_fd_sc_hd__decap_3
XFILLER_77_122 VGND VGND VPWR VPWR sky130_fd_sc_hd__decap_3
XFILLER_19_9 VGND VGND VPWR VPWR sky130_fd_sc_hd__fill_1
XFILLER_65_306 VGND VGND VPWR VPWR sky130_fd_sc_hd__decap_3
XFILLER_77_177 VGND VGND VPWR VPWR sky130_fd_sc_hd__decap_3
XFILLER_58_380 VGND VGND VPWR VPWR sky130_fd_sc_hd__decap_3
XFILLER_33_203 VGND VGND VPWR VPWR sky130_fd_sc_hd__decap_3
XFILLER_73_350 VGND VGND VPWR VPWR sky130_fd_sc_hd__decap_3
XFILLER_80_309 VGND VGND VPWR VPWR sky130_fd_sc_hd__decap_3
XFILLER_33_225 VGND VGND VPWR VPWR sky130_fd_sc_hd__decap_3
XFILLER_61_523 VGND VGND VPWR VPWR sky130_fd_sc_hd__decap_3
XFILLER_61_545 VGND VGND VPWR VPWR sky130_fd_sc_hd__decap_3
Xclkbuf_leaf_3_CLK clkbuf_leaf_8_CLK/A VGND VGND VPWR VPWR clkload3/A sky130_fd_sc_hd__clkbuf_8
XFILLER_14_494 VGND VGND VPWR VPWR sky130_fd_sc_hd__fill_1
X_3630_ _3628_/Y _3629_/X _4063_/A VGND VGND VPWR VPWR _3631_/A sky130_fd_sc_hd__mux2_1
X_3561_ _3561_/A _3561_/B VGND VGND VPWR VPWR _3563_/A sky130_fd_sc_hd__nand2_2
X_2512_ _4471_/B VGND VGND VPWR VPWR _4453_/B sky130_fd_sc_hd__inv_2
X_3492_ _5155_/Q _5136_/Q VGND VGND VPWR VPWR _3496_/A sky130_fd_sc_hd__nand2_2
X_5231_ _5253_/CLK _5231_/D VGND VGND VPWR VPWR _5231_/Q sky130_fd_sc_hd__dfxtp_2
X_2443_ _3867_/A _4171_/A VGND VGND VPWR VPWR _2443_/Y sky130_fd_sc_hd__nor2_2
XFILLER_88_409 VGND VGND VPWR VPWR sky130_fd_sc_hd__decap_3
X_5162_ _5200_/CLK _5162_/D VGND VGND VPWR VPWR _5162_/Q sky130_fd_sc_hd__dfxtp_2
XFILLER_68_133 VGND VGND VPWR VPWR sky130_fd_sc_hd__decap_3
X_4113_ _4095_/A _3893_/X _4112_/X VGND VGND VPWR VPWR _4113_/Y sky130_fd_sc_hd__a21oi_2
X_5093_ _5094_/CLK _5093_/D VGND VGND VPWR VPWR _5093_/Q sky130_fd_sc_hd__dfxtp_2
XFILLER_68_166 VGND VGND VPWR VPWR sky130_fd_sc_hd__decap_3
XTAP_TAPCELL_ROW_67_835 VGND VPWR sky130_fd_sc_hd__tapvpwrvgnd_1
XFILLER_83_103 VGND VGND VPWR VPWR sky130_fd_sc_hd__decap_3
XFILLER_37_520 VGND VGND VPWR VPWR sky130_fd_sc_hd__decap_3
XFILLER_49_391 VGND VGND VPWR VPWR sky130_fd_sc_hd__fill_1
X_4044_ _4067_/A _4523_/S _4421_/B VGND VGND VPWR VPWR _4044_/X sky130_fd_sc_hd__o21a_2
XFILLER_83_125 VGND VGND VPWR VPWR sky130_fd_sc_hd__fill_1
XFILLER_52_501 VGND VGND VPWR VPWR sky130_fd_sc_hd__decap_3
XFILLER_71_309 VGND VGND VPWR VPWR sky130_fd_sc_hd__decap_3
XFILLER_83_169 VGND VGND VPWR VPWR sky130_fd_sc_hd__decap_3
XFILLER_24_203 VGND VGND VPWR VPWR sky130_fd_sc_hd__decap_3
XFILLER_24_247 VGND VGND VPWR VPWR sky130_fd_sc_hd__decap_3
X_4946_ _5122_/CLK _4946_/D VGND VGND VPWR VPWR _4946_/Q sky130_fd_sc_hd__dfxtp_2
XTAP_TAPCELL_ROW_22_415 VGND VPWR sky130_fd_sc_hd__tapvpwrvgnd_1
X_4877_ _5085_/CLK _4877_/D VGND VGND VPWR VPWR _4877_/Q sky130_fd_sc_hd__dfxtp_2
X_3828_ _4608_/B _4611_/S VGND VGND VPWR VPWR _4091_/A sky130_fd_sc_hd__nor2_2
X_3759_ _5129_/Q _3759_/B VGND VGND VPWR VPWR _3759_/X sky130_fd_sc_hd__or2_2
XFILLER_58_25 VGND VGND VPWR VPWR sky130_fd_sc_hd__decap_3
XFILLER_59_111 VGND VGND VPWR VPWR sky130_fd_sc_hd__fill_1
XFILLER_87_420 VGND VGND VPWR VPWR sky130_fd_sc_hd__decap_3
XFILLER_59_155 VGND VGND VPWR VPWR sky130_fd_sc_hd__decap_3
XFILLER_47_306 VGND VGND VPWR VPWR sky130_fd_sc_hd__fill_1
XFILLER_87_486 VGND VGND VPWR VPWR sky130_fd_sc_hd__decap_3
XFILLER_62_309 VGND VGND VPWR VPWR sky130_fd_sc_hd__decap_3
XFILLER_74_158 VGND VGND VPWR VPWR sky130_fd_sc_hd__decap_3
XFILLER_74_46 VGND VGND VPWR VPWR sky130_fd_sc_hd__decap_3
XFILLER_15_225 VGND VGND VPWR VPWR sky130_fd_sc_hd__decap_3
XFILLER_70_342 VGND VGND VPWR VPWR sky130_fd_sc_hd__decap_3
XFILLER_30_206 VGND VGND VPWR VPWR sky130_fd_sc_hd__fill_1
XFILLER_70_386 VGND VGND VPWR VPWR sky130_fd_sc_hd__decap_3
XPHY_EDGE_ROW_4_Left_98 VGND VGND VPWR VPWR sky130_fd_sc_hd__decap_3
XFILLER_7_413 VGND VGND VPWR VPWR sky130_fd_sc_hd__fill_1
XFILLER_11_497 VGND VGND VPWR VPWR sky130_fd_sc_hd__decap_3
XFILLER_23_83 VGND VGND VPWR VPWR sky130_fd_sc_hd__decap_3
XFILLER_7_446 VGND VGND VPWR VPWR sky130_fd_sc_hd__fill_2
XFILLER_78_453 VGND VGND VPWR VPWR sky130_fd_sc_hd__fill_2
XFILLER_38_317 VGND VGND VPWR VPWR sky130_fd_sc_hd__decap_3
XFILLER_93_401 VGND VGND VPWR VPWR sky130_fd_sc_hd__decap_3
XFILLER_78_475 VGND VGND VPWR VPWR sky130_fd_sc_hd__fill_1
XTAP_TAPCELL_ROW_88_1037 VGND VPWR sky130_fd_sc_hd__tapvpwrvgnd_1
XFILLER_93_445 VGND VGND VPWR VPWR sky130_fd_sc_hd__decap_3
XFILLER_65_169 VGND VGND VPWR VPWR sky130_fd_sc_hd__decap_3
XTAP_TAPCELL_ROW_64_805 VGND VPWR sky130_fd_sc_hd__tapvpwrvgnd_1
XFILLER_93_489 VGND VGND VPWR VPWR sky130_fd_sc_hd__decap_3
XFILLER_93_467 VGND VGND VPWR VPWR sky130_fd_sc_hd__decap_3
XFILLER_73_180 VGND VGND VPWR VPWR sky130_fd_sc_hd__decap_3
XFILLER_61_353 VGND VGND VPWR VPWR sky130_fd_sc_hd__decap_3
X_4800_ _5237_/Q _4800_/B VGND VGND VPWR VPWR _4800_/Y sky130_fd_sc_hd__nand2_2
XFILLER_21_228 VGND VGND VPWR VPWR sky130_fd_sc_hd__fill_2
X_2992_ _2910_/X _2987_/B _2987_/Y _4919_/Q VGND VGND VPWR VPWR _4919_/D sky130_fd_sc_hd__a22o_2
XTAP_TAPCELL_ROW_72_882 VGND VPWR sky130_fd_sc_hd__tapvpwrvgnd_1
X_4731_ _2678_/A _3874_/D _4275_/B _3847_/A _4730_/X VGND VGND VPWR VPWR _4731_/X
+ sky130_fd_sc_hd__o221a_2
X_4662_ _4662_/A _4662_/B VGND VGND VPWR VPWR _4666_/B sky130_fd_sc_hd__nand2_2
X_3613_ _5108_/Q _4996_/Q _4980_/Q _4964_/Q _3834_/S0 _3834_/S1 VGND VGND VPWR VPWR
+ _3613_/X sky130_fd_sc_hd__mux4_2
X_4593_ _4333_/B _2585_/B _4662_/A _3809_/B _4592_/X VGND VGND VPWR VPWR _4593_/X
+ sky130_fd_sc_hd__a221o_2
X_3544_ _5162_/Q _5143_/Q VGND VGND VPWR VPWR _3546_/A sky130_fd_sc_hd__nand2_2
X_3475_ _5190_/Q _4850_/B _3585_/A _3474_/Y VGND VGND VPWR VPWR _3476_/B sky130_fd_sc_hd__o2bb2a_2
XFILLER_69_420 VGND VGND VPWR VPWR sky130_fd_sc_hd__fill_1
X_5214_ _5253_/CLK _5214_/D VGND VGND VPWR VPWR _5214_/Q sky130_fd_sc_hd__dfxtp_2
X_2426_ _5181_/Q VGND VGND VPWR VPWR _2889_/A sky130_fd_sc_hd__inv_2
XFILLER_56_103 VGND VGND VPWR VPWR sky130_fd_sc_hd__decap_3
X_5145_ _5164_/CLK _5145_/D VGND VGND VPWR VPWR _5145_/Q sky130_fd_sc_hd__dfxtp_2
X_5076_ _5092_/CLK _5076_/D VGND VGND VPWR VPWR _5076_/Q sky130_fd_sc_hd__dfxtp_2
XFILLER_25_501 VGND VGND VPWR VPWR sky130_fd_sc_hd__decap_3
XFILLER_44_309 VGND VGND VPWR VPWR sky130_fd_sc_hd__decap_3
X_4027_ _3649_/Y _3628_/Y _4063_/A VGND VGND VPWR VPWR _4027_/X sky130_fd_sc_hd__mux2_1
XFILLER_84_489 VGND VGND VPWR VPWR sky130_fd_sc_hd__decap_3
XFILLER_71_128 VGND VGND VPWR VPWR sky130_fd_sc_hd__fill_2
XFILLER_44_27 VGND VGND VPWR VPWR sky130_fd_sc_hd__fill_1
XFILLER_44_38 VGND VGND VPWR VPWR sky130_fd_sc_hd__decap_3
XFILLER_52_342 VGND VGND VPWR VPWR sky130_fd_sc_hd__decap_3
XFILLER_64_191 VGND VGND VPWR VPWR sky130_fd_sc_hd__decap_3
XFILLER_52_397 VGND VGND VPWR VPWR sky130_fd_sc_hd__decap_3
X_4929_ _5106_/CLK _4929_/D VGND VGND VPWR VPWR _4929_/Q sky130_fd_sc_hd__dfxtp_2
XFILLER_60_59 VGND VGND VPWR VPWR sky130_fd_sc_hd__decap_3
XFILLER_4_427 VGND VGND VPWR VPWR sky130_fd_sc_hd__decap_3
XFILLER_69_57 VGND VGND VPWR VPWR sky130_fd_sc_hd__decap_3
XFILLER_79_239 VGND VGND VPWR VPWR sky130_fd_sc_hd__decap_3
XFILLER_79_228 VGND VGND VPWR VPWR sky130_fd_sc_hd__decap_3
XTAP_TAPCELL_ROW_7_265 VGND VPWR sky130_fd_sc_hd__tapvpwrvgnd_1
XFILLER_75_401 VGND VGND VPWR VPWR sky130_fd_sc_hd__decap_3
XFILLER_87_250 VGND VGND VPWR VPWR sky130_fd_sc_hd__decap_3
XFILLER_85_34 VGND VGND VPWR VPWR sky130_fd_sc_hd__fill_1
XFILLER_85_12 VGND VGND VPWR VPWR sky130_fd_sc_hd__decap_3
XFILLER_90_404 VGND VGND VPWR VPWR sky130_fd_sc_hd__decap_3
XFILLER_18_94 VGND VGND VPWR VPWR sky130_fd_sc_hd__decap_3
XFILLER_62_128 VGND VGND VPWR VPWR sky130_fd_sc_hd__fill_1
XFILLER_16_545 VGND VGND VPWR VPWR sky130_fd_sc_hd__decap_3
XFILLER_55_191 VGND VGND VPWR VPWR sky130_fd_sc_hd__decap_3
XFILLER_43_375 VGND VGND VPWR VPWR sky130_fd_sc_hd__decap_3
XFILLER_86_9 VGND VGND VPWR VPWR sky130_fd_sc_hd__decap_3
XFILLER_11_261 VGND VGND VPWR VPWR sky130_fd_sc_hd__decap_3
XTAP_TAPCELL_ROW_41_587 VGND VPWR sky130_fd_sc_hd__tapvpwrvgnd_1
X_3260_ _5152_/Q _3403_/B VGND VGND VPWR VPWR _3406_/B sky130_fd_sc_hd__nand2_2
X_3191_ _2891_/X _3203_/A2 _3203_/B1 _5091_/Q VGND VGND VPWR VPWR _5091_/D sky130_fd_sc_hd__a22o_2
XFILLER_15_3 VGND VGND VPWR VPWR sky130_fd_sc_hd__decap_3
XFILLER_66_445 VGND VGND VPWR VPWR sky130_fd_sc_hd__decap_3
XTAP_TAPCELL_ROW_77_930 VGND VPWR sky130_fd_sc_hd__tapvpwrvgnd_1
XFILLER_26_309 VGND VGND VPWR VPWR sky130_fd_sc_hd__decap_3
XFILLER_66_467 VGND VGND VPWR VPWR sky130_fd_sc_hd__fill_2
XTAP_TAPCELL_ROW_49_665 VGND VPWR sky130_fd_sc_hd__tapvpwrvgnd_1
XFILLER_93_264 VGND VGND VPWR VPWR sky130_fd_sc_hd__fill_1
XFILLER_46_180 VGND VGND VPWR VPWR sky130_fd_sc_hd__decap_3
XFILLER_22_504 VGND VGND VPWR VPWR sky130_fd_sc_hd__decap_3
XFILLER_61_183 VGND VGND VPWR VPWR sky130_fd_sc_hd__decap_3
XTAP_TAPCELL_ROW_32_510 VGND VPWR sky130_fd_sc_hd__tapvpwrvgnd_1
X_4714_ _4714_/A _4714_/B VGND VGND VPWR VPWR _5230_/D sky130_fd_sc_hd__nor2_2
X_2975_ _2916_/X _2984_/A2 _2968_/Y _4905_/Q VGND VGND VPWR VPWR _4905_/D sky130_fd_sc_hd__a22o_2
XFILLER_30_29 VGND VGND VPWR VPWR sky130_fd_sc_hd__decap_3
X_4645_ _4641_/X _4643_/Y _4644_/X _4687_/A VGND VGND VPWR VPWR _4650_/D sky130_fd_sc_hd__a22o_2
X_4576_ _4476_/X _4532_/X _4575_/X _4371_/B VGND VGND VPWR VPWR _4576_/X sky130_fd_sc_hd__a31o_2
X_3527_ _5197_/Q _4800_/B _3585_/A _3526_/Y VGND VGND VPWR VPWR _3528_/B sky130_fd_sc_hd__o2bb2a_2
XFILLER_89_548 VGND VGND VPWR VPWR sky130_fd_sc_hd__decap_3
XFILLER_89_526 VGND VGND VPWR VPWR sky130_fd_sc_hd__fill_1
X_3458_ _4850_/A _3458_/B _3473_/B VGND VGND VPWR VPWR _3458_/X sky130_fd_sc_hd__or3b_2
XFILLER_29_103 VGND VGND VPWR VPWR sky130_fd_sc_hd__decap_3
X_3389_ _3378_/A _3378_/B _3375_/X _3377_/B _3387_/X VGND VGND VPWR VPWR _3389_/Y
+ sky130_fd_sc_hd__o311ai_2
XFILLER_29_125 VGND VGND VPWR VPWR sky130_fd_sc_hd__decap_3
XFILLER_57_445 VGND VGND VPWR VPWR sky130_fd_sc_hd__decap_3
X_5128_ clkload7/A _5128_/D VGND VGND VPWR VPWR _5128_/Q sky130_fd_sc_hd__dfxtp_4
XTAP_TAPCELL_ROW_4_235 VGND VPWR sky130_fd_sc_hd__tapvpwrvgnd_1
XFILLER_29_169 VGND VGND VPWR VPWR sky130_fd_sc_hd__fill_2
XFILLER_57_478 VGND VGND VPWR VPWR sky130_fd_sc_hd__decap_3
XFILLER_84_253 VGND VGND VPWR VPWR sky130_fd_sc_hd__fill_1
XFILLER_84_231 VGND VGND VPWR VPWR sky130_fd_sc_hd__decap_3
XFILLER_55_37 VGND VGND VPWR VPWR sky130_fd_sc_hd__decap_3
XFILLER_72_415 VGND VGND VPWR VPWR sky130_fd_sc_hd__decap_3
X_5059_ _5094_/CLK _5059_/D VGND VGND VPWR VPWR _5059_/Q sky130_fd_sc_hd__dfxtp_2
XFILLER_44_139 VGND VGND VPWR VPWR sky130_fd_sc_hd__fill_1
XTAP_TAPCELL_ROW_83_988 VGND VPWR sky130_fd_sc_hd__tapvpwrvgnd_1
XFILLER_40_312 VGND VGND VPWR VPWR sky130_fd_sc_hd__decap_3
XFILLER_71_47 VGND VGND VPWR VPWR sky130_fd_sc_hd__decap_3
XFILLER_80_492 VGND VGND VPWR VPWR sky130_fd_sc_hd__decap_3
XFILLER_20_40 VGND VGND VPWR VPWR sky130_fd_sc_hd__decap_3
XFILLER_0_430 VGND VGND VPWR VPWR sky130_fd_sc_hd__decap_3
XFILLER_0_452 VGND VGND VPWR VPWR sky130_fd_sc_hd__decap_3
XFILLER_48_401 VGND VGND VPWR VPWR sky130_fd_sc_hd__decap_3
XFILLER_48_434 VGND VGND VPWR VPWR sky130_fd_sc_hd__decap_3
XFILLER_29_82 VGND VGND VPWR VPWR sky130_fd_sc_hd__decap_3
XTAP_TAPCELL_ROW_74_900 VGND VPWR sky130_fd_sc_hd__tapvpwrvgnd_1
XFILLER_63_415 VGND VGND VPWR VPWR sky130_fd_sc_hd__decap_3
XTAP_TAPCELL_ROW_85_1007 VGND VPWR sky130_fd_sc_hd__tapvpwrvgnd_1
XFILLER_16_331 VGND VGND VPWR VPWR sky130_fd_sc_hd__fill_1
XFILLER_35_139 VGND VGND VPWR VPWR sky130_fd_sc_hd__decap_3
XTAP_TAPCELL_ROW_46_635 VGND VPWR sky130_fd_sc_hd__tapvpwrvgnd_1
XFILLER_16_353 VGND VGND VPWR VPWR sky130_fd_sc_hd__decap_3
XFILLER_45_81 VGND VGND VPWR VPWR sky130_fd_sc_hd__fill_2
XFILLER_43_172 VGND VGND VPWR VPWR sky130_fd_sc_hd__decap_3
XFILLER_71_481 VGND VGND VPWR VPWR sky130_fd_sc_hd__fill_2
XFILLER_71_492 VGND VGND VPWR VPWR sky130_fd_sc_hd__decap_3
XFILLER_84_6 VGND VGND VPWR VPWR sky130_fd_sc_hd__decap_3
X_2760_ _2754_/X _2756_/X _2759_/X _2437_/Y VGND VGND VPWR VPWR _3292_/B sky130_fd_sc_hd__a22o_2
X_2691_ _2887_/B _2696_/B VGND VGND VPWR VPWR _2695_/B sky130_fd_sc_hd__nand2b_2
XANTENNA_2 _4796_/X VGND VGND VPWR VPWR sky130_fd_sc_hd__diode_2
XFILLER_6_20 VGND VGND VPWR VPWR sky130_fd_sc_hd__decap_3
X_4430_ _4469_/A _4500_/A VGND VGND VPWR VPWR _4434_/A sky130_fd_sc_hd__and2b_2
XFILLER_6_75 VGND VGND VPWR VPWR sky130_fd_sc_hd__decap_3
XFILLER_6_97 VGND VGND VPWR VPWR sky130_fd_sc_hd__decap_3
X_4361_ _4361_/A _4361_/B VGND VGND VPWR VPWR _4361_/Y sky130_fd_sc_hd__nand2_2
X_4292_ _4292_/A _4312_/B VGND VGND VPWR VPWR _4311_/C sky130_fd_sc_hd__nor2_2
X_3312_ _5159_/Q _3312_/B VGND VGND VPWR VPWR _3313_/B sky130_fd_sc_hd__or2_2
X_3243_ _5260_/Q _3442_/B input7/X VGND VGND VPWR VPWR _3243_/X sky130_fd_sc_hd__and3_2
XFILLER_66_220 VGND VGND VPWR VPWR sky130_fd_sc_hd__decap_3
XFILLER_39_445 VGND VGND VPWR VPWR sky130_fd_sc_hd__decap_3
XFILLER_39_467 VGND VGND VPWR VPWR sky130_fd_sc_hd__decap_3
XFILLER_66_253 VGND VGND VPWR VPWR sky130_fd_sc_hd__decap_3
X_3174_ _2900_/X _3185_/A2 _3185_/B1 _5076_/Q VGND VGND VPWR VPWR _5076_/D sky130_fd_sc_hd__a22o_2
XFILLER_54_415 VGND VGND VPWR VPWR sky130_fd_sc_hd__decap_3
XFILLER_54_448 VGND VGND VPWR VPWR sky130_fd_sc_hd__decap_3
XFILLER_34_150 VGND VGND VPWR VPWR sky130_fd_sc_hd__decap_3
XFILLER_22_323 VGND VGND VPWR VPWR sky130_fd_sc_hd__decap_3
XTAP_TAPCELL_ROW_80_958 VGND VPWR sky130_fd_sc_hd__tapvpwrvgnd_1
XFILLER_22_389 VGND VGND VPWR VPWR sky130_fd_sc_hd__decap_3
X_2958_ _2926_/X _2961_/A2 _2961_/B1 _4892_/Q VGND VGND VPWR VPWR _4892_/D sky130_fd_sc_hd__a22o_2
X_4628_ _4642_/A _4628_/B VGND VGND VPWR VPWR _4628_/X sky130_fd_sc_hd__or2_2
X_2889_ _2889_/A _5180_/Q _2889_/C VGND VGND VPWR VPWR _3458_/B sky130_fd_sc_hd__and3_2
X_4559_ _4573_/A _4513_/Y _4558_/X VGND VGND VPWR VPWR _4559_/X sky130_fd_sc_hd__o21a_2
XFILLER_89_378 VGND VGND VPWR VPWR sky130_fd_sc_hd__decap_3
XFILLER_57_253 VGND VGND VPWR VPWR sky130_fd_sc_hd__decap_3
XFILLER_57_275 VGND VGND VPWR VPWR sky130_fd_sc_hd__decap_3
XFILLER_17_128 VGND VGND VPWR VPWR sky130_fd_sc_hd__decap_3
XFILLER_45_437 VGND VGND VPWR VPWR sky130_fd_sc_hd__decap_3
XFILLER_60_418 VGND VGND VPWR VPWR sky130_fd_sc_hd__fill_2
XFILLER_72_267 VGND VGND VPWR VPWR sky130_fd_sc_hd__decap_3
XFILLER_82_35 VGND VGND VPWR VPWR sky130_fd_sc_hd__decap_3
XFILLER_13_323 VGND VGND VPWR VPWR sky130_fd_sc_hd__decap_3
XFILLER_15_73 VGND VGND VPWR VPWR sky130_fd_sc_hd__decap_3
XFILLER_40_131 VGND VGND VPWR VPWR sky130_fd_sc_hd__decap_3
XFILLER_13_389 VGND VGND VPWR VPWR sky130_fd_sc_hd__decap_3
XTAP_TAPCELL_ROW_51_682 VGND VPWR sky130_fd_sc_hd__tapvpwrvgnd_1
Xoutput50 _2700_/Y VGND VGND VPWR VPWR DEVICES_LDH sky130_fd_sc_hd__clkdlybuf4s25_1
Xoutput61 _5148_/Q VGND VGND VPWR VPWR INSTR_ADDR[15] sky130_fd_sc_hd__clkdlybuf4s25_1
Xoutput72 _2694_/Y VGND VGND VPWR VPWR MAIN_LDH sky130_fd_sc_hd__clkdlybuf4s25_1
Xoutput83 _2856_/Y VGND VGND VPWR VPWR MEM_ADDR[1] sky130_fd_sc_hd__clkdlybuf4s25_1
Xoutput94 _2815_/X VGND VGND VPWR VPWR MEM_STR_DATA[11] sky130_fd_sc_hd__clkdlybuf4s25_1
XTAP_TAPCELL_ROW_91_1066 VGND VPWR sky130_fd_sc_hd__tapvpwrvgnd_1
XFILLER_0_271 VGND VGND VPWR VPWR sky130_fd_sc_hd__decap_3
XFILLER_0_293 VGND VGND VPWR VPWR sky130_fd_sc_hd__decap_3
XFILLER_48_242 VGND VGND VPWR VPWR sky130_fd_sc_hd__decap_3
XFILLER_48_253 VGND VGND VPWR VPWR sky130_fd_sc_hd__fill_1
XFILLER_76_551 VGND VGND VPWR VPWR sky130_fd_sc_hd__fill_2
XFILLER_36_404 VGND VGND VPWR VPWR sky130_fd_sc_hd__decap_3
XFILLER_48_264 VGND VGND VPWR VPWR sky130_fd_sc_hd__decap_3
XTAP_TAPCELL_ROW_59_760 VGND VPWR sky130_fd_sc_hd__tapvpwrvgnd_1
XFILLER_91_521 VGND VGND VPWR VPWR sky130_fd_sc_hd__fill_2
XFILLER_36_437 VGND VGND VPWR VPWR sky130_fd_sc_hd__decap_3
XFILLER_56_80 VGND VGND VPWR VPWR sky130_fd_sc_hd__decap_3
XFILLER_56_91 VGND VGND VPWR VPWR sky130_fd_sc_hd__decap_3
XFILLER_63_245 VGND VGND VPWR VPWR sky130_fd_sc_hd__decap_3
XFILLER_63_278 VGND VGND VPWR VPWR sky130_fd_sc_hd__fill_2
X_3930_ _3930_/A _3930_/B VGND VGND VPWR VPWR _3930_/Y sky130_fd_sc_hd__nand2_2
X_3861_ _4403_/A _4408_/S VGND VGND VPWR VPWR _3861_/X sky130_fd_sc_hd__or2_2
XFILLER_31_153 VGND VGND VPWR VPWR sky130_fd_sc_hd__fill_1
XFILLER_31_175 VGND VGND VPWR VPWR sky130_fd_sc_hd__decap_3
X_3792_ _4464_/B _3885_/B VGND VGND VPWR VPWR _3794_/B sky130_fd_sc_hd__and2_2
X_2812_ _4958_/Q _4942_/Q _4926_/Q _4910_/Q _2812_/S0 _2848_/S1 VGND VGND VPWR VPWR
+ _2812_/X sky130_fd_sc_hd__mux4_2
XFILLER_82_3 VGND VGND VPWR VPWR sky130_fd_sc_hd__decap_3
X_2743_ _2851_/A _3269_/B VGND VGND VPWR VPWR _2743_/X sky130_fd_sc_hd__and2_2
X_2674_ _2667_/X _2669_/X _2672_/X _2435_/Y VGND VGND VPWR VPWR _4432_/B sky130_fd_sc_hd__a22o_2
X_4413_ _4471_/B _4523_/S _4342_/A VGND VGND VPWR VPWR _4414_/A sky130_fd_sc_hd__o21a_2
X_4344_ _4340_/A _4342_/Y _4343_/Y _4339_/A _4340_/Y VGND VGND VPWR VPWR _4344_/X
+ sky130_fd_sc_hd__o311a_2
X_4275_ _4285_/B _4275_/B _4275_/C VGND VGND VPWR VPWR _4277_/B sky130_fd_sc_hd__and3_2
XFILLER_86_348 VGND VGND VPWR VPWR sky130_fd_sc_hd__decap_3
XFILLER_86_315 VGND VGND VPWR VPWR sky130_fd_sc_hd__decap_3
X_3226_ _5258_/Q _5259_/Q _4168_/A _3227_/D VGND VGND VPWR VPWR _3226_/Y sky130_fd_sc_hd__nor4_4
XFILLER_54_212 VGND VGND VPWR VPWR sky130_fd_sc_hd__decap_3
X_3157_ _2903_/X _3170_/A2 _3170_/B1 _5061_/Q VGND VGND VPWR VPWR _5061_/D sky130_fd_sc_hd__a22o_2
XPHY_EDGE_ROW_6_Left_100 VGND VGND VPWR VPWR sky130_fd_sc_hd__decap_3
XFILLER_82_543 VGND VGND VPWR VPWR sky130_fd_sc_hd__decap_3
XFILLER_42_418 VGND VGND VPWR VPWR sky130_fd_sc_hd__fill_2
XFILLER_54_256 VGND VGND VPWR VPWR sky130_fd_sc_hd__decap_3
X_3088_ _2919_/X _3093_/A2 _3096_/B1 _5002_/Q VGND VGND VPWR VPWR _5002_/D sky130_fd_sc_hd__a22o_2
XFILLER_54_289 VGND VGND VPWR VPWR sky130_fd_sc_hd__decap_3
XFILLER_22_120 VGND VGND VPWR VPWR sky130_fd_sc_hd__decap_3
XFILLER_52_38 VGND VGND VPWR VPWR sky130_fd_sc_hd__decap_3
XFILLER_22_164 VGND VGND VPWR VPWR sky130_fd_sc_hd__decap_3
XTAP_TAPCELL_ROW_20_387 VGND VPWR sky130_fd_sc_hd__tapvpwrvgnd_1
XFILLER_77_337 VGND VGND VPWR VPWR sky130_fd_sc_hd__decap_3
XFILLER_77_326 VGND VGND VPWR VPWR sky130_fd_sc_hd__decap_3
XFILLER_58_551 VGND VGND VPWR VPWR sky130_fd_sc_hd__fill_2
XFILLER_92_307 VGND VGND VPWR VPWR sky130_fd_sc_hd__fill_1
XFILLER_93_12 VGND VGND VPWR VPWR sky130_fd_sc_hd__decap_3
XFILLER_85_370 VGND VGND VPWR VPWR sky130_fd_sc_hd__decap_3
XFILLER_45_245 VGND VGND VPWR VPWR sky130_fd_sc_hd__decap_3
XFILLER_73_532 VGND VGND VPWR VPWR sky130_fd_sc_hd__decap_3
XTAP_TAPCELL_ROW_56_730 VGND VPWR sky130_fd_sc_hd__tapvpwrvgnd_1
XFILLER_45_278 VGND VGND VPWR VPWR sky130_fd_sc_hd__fill_2
XTAP_TAPCELL_ROW_28_465 VGND VPWR sky130_fd_sc_hd__tapvpwrvgnd_1
XFILLER_26_83 VGND VGND VPWR VPWR sky130_fd_sc_hd__fill_1
XFILLER_60_215 VGND VGND VPWR VPWR sky130_fd_sc_hd__decap_3
XFILLER_60_248 VGND VGND VPWR VPWR sky130_fd_sc_hd__decap_3
XFILLER_41_484 VGND VGND VPWR VPWR sky130_fd_sc_hd__decap_3
XFILLER_9_113 VGND VGND VPWR VPWR sky130_fd_sc_hd__decap_3
XFILLER_13_197 VGND VGND VPWR VPWR sky130_fd_sc_hd__fill_1
XFILLER_42_71 VGND VGND VPWR VPWR sky130_fd_sc_hd__decap_3
XTAP_TAPCELL_ROW_11_310 VGND VPWR sky130_fd_sc_hd__tapvpwrvgnd_1
XFILLER_5_352 VGND VGND VPWR VPWR sky130_fd_sc_hd__decap_3
XFILLER_5_396 VGND VGND VPWR VPWR sky130_fd_sc_hd__decap_3
XFILLER_3_21 VGND VGND VPWR VPWR sky130_fd_sc_hd__decap_3
XFILLER_68_304 VGND VGND VPWR VPWR sky130_fd_sc_hd__decap_3
XPHY_EDGE_ROW_79_Left_173 VGND VGND VPWR VPWR sky130_fd_sc_hd__decap_3
X_4060_ _4059_/X _4058_/X _4107_/B VGND VGND VPWR VPWR _4061_/B sky130_fd_sc_hd__mux2_1
X_3011_ _2910_/X _3006_/B _3006_/Y _4935_/Q VGND VGND VPWR VPWR _4935_/D sky130_fd_sc_hd__a22o_2
XFILLER_83_329 VGND VGND VPWR VPWR sky130_fd_sc_hd__decap_3
XFILLER_83_307 VGND VGND VPWR VPWR sky130_fd_sc_hd__decap_3
XFILLER_64_521 VGND VGND VPWR VPWR sky130_fd_sc_hd__decap_3
XFILLER_76_392 VGND VGND VPWR VPWR sky130_fd_sc_hd__decap_3
XFILLER_36_256 VGND VGND VPWR VPWR sky130_fd_sc_hd__decap_3
XFILLER_17_492 VGND VGND VPWR VPWR sky130_fd_sc_hd__decap_3
XFILLER_36_289 VGND VGND VPWR VPWR sky130_fd_sc_hd__decap_3
X_4962_ _5122_/CLK _4962_/D VGND VGND VPWR VPWR _4962_/Q sky130_fd_sc_hd__dfxtp_2
X_4893_ _5085_/CLK _4893_/D VGND VGND VPWR VPWR _4893_/Q sky130_fd_sc_hd__dfxtp_2
X_3913_ _3849_/C _3908_/Y _3912_/Y _3781_/B _3910_/Y VGND VGND VPWR VPWR _3916_/A
+ sky130_fd_sc_hd__a221o_2
XFILLER_32_473 VGND VGND VPWR VPWR sky130_fd_sc_hd__decap_3
X_3844_ _4196_/A _4218_/A _3727_/X VGND VGND VPWR VPWR _3844_/X sky130_fd_sc_hd__or3b_2
XTAP_TAPCELL_ROW_62_788 VGND VPWR sky130_fd_sc_hd__tapvpwrvgnd_1
XPHY_EDGE_ROW_88_Left_182 VGND VGND VPWR VPWR sky130_fd_sc_hd__decap_3
X_3775_ _3773_/X _3774_/X _3831_/A VGND VGND VPWR VPWR _3775_/X sky130_fd_sc_hd__mux2_1
X_2726_ _5061_/Q _5045_/Q _5029_/Q _5013_/Q _2812_/S0 _2848_/S1 VGND VGND VPWR VPWR
+ _2726_/X sky130_fd_sc_hd__mux4_2
X_2657_ _4958_/Q _4942_/Q _4926_/Q _4910_/Q _2658_/S0 _2671_/S1 VGND VGND VPWR VPWR
+ _2657_/X sky130_fd_sc_hd__mux4_2
X_2588_ _2667_/A _2588_/B VGND VGND VPWR VPWR _2588_/X sky130_fd_sc_hd__or2_2
XFILLER_59_315 VGND VGND VPWR VPWR sky130_fd_sc_hd__fill_2
XFILLER_59_337 VGND VGND VPWR VPWR sky130_fd_sc_hd__decap_3
X_4327_ _4115_/A _2885_/B _4324_/X VGND VGND VPWR VPWR _4327_/X sky130_fd_sc_hd__o21ba_2
X_4258_ _4256_/X _4258_/B _4258_/C _4258_/D VGND VGND VPWR VPWR _4258_/X sky130_fd_sc_hd__and4b_2
XFILLER_27_201 VGND VGND VPWR VPWR sky130_fd_sc_hd__decap_3
XFILLER_47_49 VGND VGND VPWR VPWR sky130_fd_sc_hd__decap_3
X_3209_ _2891_/X _3221_/A2 _3208_/Y _5107_/Q VGND VGND VPWR VPWR _5107_/D sky130_fd_sc_hd__a22o_2
XFILLER_86_167 VGND VGND VPWR VPWR sky130_fd_sc_hd__decap_3
XFILLER_55_521 VGND VGND VPWR VPWR sky130_fd_sc_hd__decap_3
X_4189_ _4187_/X _4189_/B _4189_/C VGND VGND VPWR VPWR _4189_/X sky130_fd_sc_hd__and3b_2
XFILLER_82_362 VGND VGND VPWR VPWR sky130_fd_sc_hd__fill_2
XFILLER_82_351 VGND VGND VPWR VPWR sky130_fd_sc_hd__fill_2
XFILLER_42_215 VGND VGND VPWR VPWR sky130_fd_sc_hd__decap_3
XFILLER_82_373 VGND VGND VPWR VPWR sky130_fd_sc_hd__decap_3
XTAP_TAPCELL_ROW_25_435 VGND VPWR sky130_fd_sc_hd__tapvpwrvgnd_1
XFILLER_10_112 VGND VGND VPWR VPWR sky130_fd_sc_hd__decap_3
XFILLER_10_178 VGND VGND VPWR VPWR sky130_fd_sc_hd__fill_1
XFILLER_12_85 VGND VGND VPWR VPWR sky130_fd_sc_hd__decap_3
XFILLER_46_510 VGND VGND VPWR VPWR sky130_fd_sc_hd__decap_3
XFILLER_77_189 VGND VGND VPWR VPWR sky130_fd_sc_hd__fill_1
XFILLER_37_60 VGND VGND VPWR VPWR sky130_fd_sc_hd__decap_3
XFILLER_18_256 VGND VGND VPWR VPWR sky130_fd_sc_hd__decap_3
XFILLER_73_340 VGND VGND VPWR VPWR sky130_fd_sc_hd__decap_3
XPHY_EDGE_ROW_16_Right_16 VGND VGND VPWR VPWR sky130_fd_sc_hd__decap_3
XFILLER_61_535 VGND VGND VPWR VPWR sky130_fd_sc_hd__fill_1
XFILLER_33_248 VGND VGND VPWR VPWR sky130_fd_sc_hd__decap_3
XFILLER_14_451 VGND VGND VPWR VPWR sky130_fd_sc_hd__decap_3
XFILLER_53_70 VGND VGND VPWR VPWR sky130_fd_sc_hd__decap_3
XFILLER_41_281 VGND VGND VPWR VPWR sky130_fd_sc_hd__decap_3
XFILLER_53_92 VGND VGND VPWR VPWR sky130_fd_sc_hd__decap_3
X_3560_ _5164_/Q _5145_/Q VGND VGND VPWR VPWR _3561_/B sky130_fd_sc_hd__or2_2
XPHY_EDGE_ROW_25_Right_25 VGND VGND VPWR VPWR sky130_fd_sc_hd__decap_3
X_2511_ _2505_/X _2507_/X _2510_/X _2435_/Y VGND VGND VPWR VPWR _4471_/B sky130_fd_sc_hd__a22o_2
X_5230_ _5252_/CLK _5230_/D VGND VGND VPWR VPWR _5230_/Q sky130_fd_sc_hd__dfxtp_2
X_3491_ _5193_/Q _4850_/B VGND VGND VPWR VPWR _3491_/Y sky130_fd_sc_hd__nand2_2
X_2442_ _5178_/Q _5177_/Q _3999_/A VGND VGND VPWR VPWR _4171_/A sky130_fd_sc_hd__or3_2
X_5161_ _5200_/CLK _5161_/D VGND VGND VPWR VPWR _5161_/Q sky130_fd_sc_hd__dfxtp_2
XFILLER_68_123 VGND VGND VPWR VPWR sky130_fd_sc_hd__decap_3
X_4112_ _4112_/A _4246_/A VGND VGND VPWR VPWR _4112_/X sky130_fd_sc_hd__or2_2
X_5092_ _5092_/CLK _5092_/D VGND VGND VPWR VPWR _5092_/Q sky130_fd_sc_hd__dfxtp_2
XFILLER_56_307 VGND VGND VPWR VPWR sky130_fd_sc_hd__fill_1
XFILLER_56_318 VGND VGND VPWR VPWR sky130_fd_sc_hd__decap_3
XFILLER_68_178 VGND VGND VPWR VPWR sky130_fd_sc_hd__fill_1
X_4043_ _4449_/B _4523_/S VGND VGND VPWR VPWR _4421_/B sky130_fd_sc_hd__nand2_2
XFILLER_37_543 VGND VGND VPWR VPWR sky130_fd_sc_hd__decap_3
XFILLER_49_370 VGND VGND VPWR VPWR sky130_fd_sc_hd__decap_3
XTAP_TAPCELL_ROW_67_836 VGND VPWR sky130_fd_sc_hd__tapvpwrvgnd_1
XPHY_EDGE_ROW_34_Right_34 VGND VGND VPWR VPWR sky130_fd_sc_hd__decap_3
XFILLER_83_137 VGND VGND VPWR VPWR sky130_fd_sc_hd__decap_3
XFILLER_64_351 VGND VGND VPWR VPWR sky130_fd_sc_hd__decap_3
XFILLER_24_226 VGND VGND VPWR VPWR sky130_fd_sc_hd__decap_3
XFILLER_52_513 VGND VGND VPWR VPWR sky130_fd_sc_hd__decap_3
X_4945_ _5103_/CLK _4945_/D VGND VGND VPWR VPWR _4945_/Q sky130_fd_sc_hd__dfxtp_2
XFILLER_20_432 VGND VGND VPWR VPWR sky130_fd_sc_hd__decap_3
X_4876_ _5114_/CLK _4876_/D VGND VGND VPWR VPWR _4876_/Q sky130_fd_sc_hd__dfxtp_2
X_3827_ _3827_/A VGND VGND VPWR VPWR _3827_/Y sky130_fd_sc_hd__inv_2
XPHY_EDGE_ROW_43_Right_43 VGND VGND VPWR VPWR sky130_fd_sc_hd__decap_3
X_3758_ _4897_/Q _4881_/Q _5105_/Q _5089_/Q _5127_/Q _5128_/Q VGND VGND VPWR VPWR
+ _3759_/B sky130_fd_sc_hd__mux4_2
XTAP_TAPCELL_ROW_30_482 VGND VPWR sky130_fd_sc_hd__tapvpwrvgnd_1
X_2709_ _5059_/Q _5043_/Q _5027_/Q _5011_/Q _2812_/S0 _2848_/S1 VGND VGND VPWR VPWR
+ _2709_/X sky130_fd_sc_hd__mux4_2
X_3689_ _3687_/X _3688_/X _3831_/A VGND VGND VPWR VPWR _3689_/X sky130_fd_sc_hd__mux2_1
XFILLER_87_432 VGND VGND VPWR VPWR sky130_fd_sc_hd__decap_3
XFILLER_59_178 VGND VGND VPWR VPWR sky130_fd_sc_hd__decap_3
XPHY_EDGE_ROW_52_Right_52 VGND VGND VPWR VPWR sky130_fd_sc_hd__decap_3
XFILLER_87_465 VGND VGND VPWR VPWR sky130_fd_sc_hd__decap_3
XFILLER_74_126 VGND VGND VPWR VPWR sky130_fd_sc_hd__decap_3
XFILLER_43_502 VGND VGND VPWR VPWR sky130_fd_sc_hd__fill_2
XFILLER_55_340 VGND VGND VPWR VPWR sky130_fd_sc_hd__decap_3
XFILLER_15_204 VGND VGND VPWR VPWR sky130_fd_sc_hd__decap_3
XFILLER_55_373 VGND VGND VPWR VPWR sky130_fd_sc_hd__decap_3
XFILLER_70_321 VGND VGND VPWR VPWR sky130_fd_sc_hd__decap_3
XFILLER_74_69 VGND VGND VPWR VPWR sky130_fd_sc_hd__fill_2
XTAP_TAPCELL_ROW_38_560 VGND VPWR sky130_fd_sc_hd__tapvpwrvgnd_1
XFILLER_15_237 VGND VGND VPWR VPWR sky130_fd_sc_hd__fill_2
XFILLER_43_546 VGND VGND VPWR VPWR sky130_fd_sc_hd__decap_3
XFILLER_70_354 VGND VGND VPWR VPWR sky130_fd_sc_hd__decap_3
XFILLER_82_192 VGND VGND VPWR VPWR sky130_fd_sc_hd__decap_3
XFILLER_30_218 VGND VGND VPWR VPWR sky130_fd_sc_hd__fill_2
XFILLER_70_365 VGND VGND VPWR VPWR sky130_fd_sc_hd__decap_3
XFILLER_90_35 VGND VGND VPWR VPWR sky130_fd_sc_hd__decap_3
XFILLER_23_281 VGND VGND VPWR VPWR sky130_fd_sc_hd__decap_3
XFILLER_70_398 VGND VGND VPWR VPWR sky130_fd_sc_hd__decap_3
XPHY_EDGE_ROW_61_Right_61 VGND VGND VPWR VPWR sky130_fd_sc_hd__decap_3
XFILLER_23_95 VGND VGND VPWR VPWR sky130_fd_sc_hd__decap_3
XFILLER_2_141 VGND VGND VPWR VPWR sky130_fd_sc_hd__decap_3
XFILLER_31_9 VGND VGND VPWR VPWR sky130_fd_sc_hd__fill_2
XPHY_EDGE_ROW_70_Right_70 VGND VGND VPWR VPWR sky130_fd_sc_hd__decap_3
XFILLER_78_421 VGND VGND VPWR VPWR sky130_fd_sc_hd__decap_3
XFILLER_38_307 VGND VGND VPWR VPWR sky130_fd_sc_hd__fill_1
XFILLER_93_413 VGND VGND VPWR VPWR sky130_fd_sc_hd__decap_3
XFILLER_78_487 VGND VGND VPWR VPWR sky130_fd_sc_hd__decap_3
XFILLER_19_532 VGND VGND VPWR VPWR sky130_fd_sc_hd__decap_3
XFILLER_38_329 VGND VGND VPWR VPWR sky130_fd_sc_hd__decap_3
XFILLER_48_81 VGND VGND VPWR VPWR sky130_fd_sc_hd__decap_3
XTAP_TAPCELL_ROW_88_1038 VGND VPWR sky130_fd_sc_hd__tapvpwrvgnd_1
XFILLER_93_424 VGND VGND VPWR VPWR sky130_fd_sc_hd__decap_3
XFILLER_46_351 VGND VGND VPWR VPWR sky130_fd_sc_hd__decap_3
XTAP_TAPCELL_ROW_64_806 VGND VPWR sky130_fd_sc_hd__tapvpwrvgnd_1
XFILLER_0_55 VGND VGND VPWR VPWR sky130_fd_sc_hd__fill_1
XFILLER_0_66 VGND VGND VPWR VPWR sky130_fd_sc_hd__decap_3
XFILLER_34_502 VGND VGND VPWR VPWR sky130_fd_sc_hd__decap_3
XFILLER_0_88 VGND VGND VPWR VPWR sky130_fd_sc_hd__decap_3
XFILLER_46_395 VGND VGND VPWR VPWR sky130_fd_sc_hd__decap_3
XFILLER_64_91 VGND VGND VPWR VPWR sky130_fd_sc_hd__decap_3
XFILLER_73_192 VGND VGND VPWR VPWR sky130_fd_sc_hd__decap_3
XFILLER_61_365 VGND VGND VPWR VPWR sky130_fd_sc_hd__fill_1
X_2991_ _2906_/X _2987_/B _2987_/Y _4918_/Q VGND VGND VPWR VPWR _4918_/D sky130_fd_sc_hd__a22o_2
XTAP_TAPCELL_ROW_72_883 VGND VPWR sky130_fd_sc_hd__tapvpwrvgnd_1
X_4730_ _3457_/A _4546_/A _4730_/S VGND VGND VPWR VPWR _4730_/X sky130_fd_sc_hd__mux2_1
X_4661_ _4661_/A VGND VGND VPWR VPWR _4661_/Y sky130_fd_sc_hd__inv_2
X_3612_ _3831_/A _3611_/X _5130_/Q VGND VGND VPWR VPWR _3612_/X sky130_fd_sc_hd__o21a_2
X_4592_ _2449_/Y _4110_/A _4592_/S VGND VGND VPWR VPWR _4592_/X sky130_fd_sc_hd__mux2_1
X_3543_ _4714_/A _3543_/B VGND VGND VPWR VPWR _5199_/D sky130_fd_sc_hd__nor2_2
X_3474_ _5152_/Q _5149_/Q VGND VGND VPWR VPWR _3474_/Y sky130_fd_sc_hd__xnor2_2
X_5213_ _5263_/CLK _5213_/D VGND VGND VPWR VPWR _5213_/Q sky130_fd_sc_hd__dfxtp_2
X_2425_ _5185_/Q VGND VGND VPWR VPWR _2425_/Y sky130_fd_sc_hd__inv_2
XFILLER_88_229 VGND VGND VPWR VPWR sky130_fd_sc_hd__decap_3
X_5144_ _5200_/CLK _5144_/D VGND VGND VPWR VPWR _5144_/Q sky130_fd_sc_hd__dfxtp_2
XFILLER_28_29 VGND VGND VPWR VPWR sky130_fd_sc_hd__decap_3
XFILLER_84_402 VGND VGND VPWR VPWR sky130_fd_sc_hd__decap_3
X_5075_ _5109_/CLK _5075_/D VGND VGND VPWR VPWR _5075_/Q sky130_fd_sc_hd__dfxtp_2
XFILLER_37_340 VGND VGND VPWR VPWR sky130_fd_sc_hd__decap_3
X_4026_ _4024_/X _4346_/B _4107_/B VGND VGND VPWR VPWR _4255_/B sky130_fd_sc_hd__mux2_1
XFILLER_84_468 VGND VGND VPWR VPWR sky130_fd_sc_hd__decap_3
XFILLER_37_384 VGND VGND VPWR VPWR sky130_fd_sc_hd__decap_3
XFILLER_64_170 VGND VGND VPWR VPWR sky130_fd_sc_hd__decap_3
XFILLER_25_546 VGND VGND VPWR VPWR sky130_fd_sc_hd__decap_3
XFILLER_52_321 VGND VGND VPWR VPWR sky130_fd_sc_hd__decap_3
XTAP_TAPCELL_ROW_35_530 VGND VPWR sky130_fd_sc_hd__tapvpwrvgnd_1
XFILLER_40_527 VGND VGND VPWR VPWR sky130_fd_sc_hd__decap_3
XFILLER_52_354 VGND VGND VPWR VPWR sky130_fd_sc_hd__decap_3
XFILLER_52_365 VGND VGND VPWR VPWR sky130_fd_sc_hd__decap_3
X_4928_ _5115_/CLK _4928_/D VGND VGND VPWR VPWR _4928_/Q sky130_fd_sc_hd__dfxtp_2
XFILLER_20_240 VGND VGND VPWR VPWR sky130_fd_sc_hd__fill_1
XFILLER_60_38 VGND VGND VPWR VPWR sky130_fd_sc_hd__decap_3
X_4859_ _5168_/Q _3252_/C _3228_/Y _3229_/X VGND VGND VPWR VPWR _5168_/D sky130_fd_sc_hd__o22a_2
XFILLER_4_417 VGND VGND VPWR VPWR sky130_fd_sc_hd__decap_3
XFILLER_4_439 VGND VGND VPWR VPWR sky130_fd_sc_hd__decap_3
XFILLER_69_25 VGND VGND VPWR VPWR sky130_fd_sc_hd__decap_3
XFILLER_69_69 VGND VGND VPWR VPWR sky130_fd_sc_hd__decap_3
XFILLER_79_207 VGND VGND VPWR VPWR sky130_fd_sc_hd__decap_3
XTAP_TAPCELL_ROW_7_266 VGND VPWR sky130_fd_sc_hd__tapvpwrvgnd_1
XFILLER_75_413 VGND VGND VPWR VPWR sky130_fd_sc_hd__decap_3
XFILLER_87_262 VGND VGND VPWR VPWR sky130_fd_sc_hd__decap_3
XFILLER_47_126 VGND VGND VPWR VPWR sky130_fd_sc_hd__decap_3
XFILLER_87_284 VGND VGND VPWR VPWR sky130_fd_sc_hd__decap_3
XFILLER_75_446 VGND VGND VPWR VPWR sky130_fd_sc_hd__fill_2
XFILLER_47_148 VGND VGND VPWR VPWR sky130_fd_sc_hd__decap_3
XFILLER_75_479 VGND VGND VPWR VPWR sky130_fd_sc_hd__decap_3
XFILLER_16_502 VGND VGND VPWR VPWR sky130_fd_sc_hd__fill_2
XFILLER_28_362 VGND VGND VPWR VPWR sky130_fd_sc_hd__fill_2
XFILLER_28_373 VGND VGND VPWR VPWR sky130_fd_sc_hd__decap_3
XFILLER_43_321 VGND VGND VPWR VPWR sky130_fd_sc_hd__decap_3
XFILLER_43_343 VGND VGND VPWR VPWR sky130_fd_sc_hd__decap_3
XFILLER_31_505 VGND VGND VPWR VPWR sky130_fd_sc_hd__fill_2
XFILLER_34_72 VGND VGND VPWR VPWR sky130_fd_sc_hd__fill_1
XFILLER_34_94 VGND VGND VPWR VPWR sky130_fd_sc_hd__decap_3
XFILLER_11_273 VGND VGND VPWR VPWR sky130_fd_sc_hd__decap_3
XTAP_TAPCELL_ROW_41_588 VGND VPWR sky130_fd_sc_hd__tapvpwrvgnd_1
XFILLER_7_222 VGND VGND VPWR VPWR sky130_fd_sc_hd__fill_2
XFILLER_11_295 VGND VGND VPWR VPWR sky130_fd_sc_hd__decap_3
XFILLER_7_299 VGND VGND VPWR VPWR sky130_fd_sc_hd__fill_2
XFILLER_3_472 VGND VGND VPWR VPWR sky130_fd_sc_hd__decap_3
X_3190_ _4866_/A _3190_/B VGND VGND VPWR VPWR _3190_/Y sky130_fd_sc_hd__nor2_2
XFILLER_78_262 VGND VGND VPWR VPWR sky130_fd_sc_hd__decap_3
XFILLER_38_126 VGND VGND VPWR VPWR sky130_fd_sc_hd__decap_3
XFILLER_66_413 VGND VGND VPWR VPWR sky130_fd_sc_hd__fill_2
XFILLER_66_424 VGND VGND VPWR VPWR sky130_fd_sc_hd__decap_3
XTAP_TAPCELL_ROW_77_931 VGND VPWR sky130_fd_sc_hd__tapvpwrvgnd_1
XFILLER_78_284 VGND VGND VPWR VPWR sky130_fd_sc_hd__decap_3
XFILLER_19_340 VGND VGND VPWR VPWR sky130_fd_sc_hd__decap_3
XFILLER_66_457 VGND VGND VPWR VPWR sky130_fd_sc_hd__fill_1
XTAP_TAPCELL_ROW_49_666 VGND VPWR sky130_fd_sc_hd__tapvpwrvgnd_1
XFILLER_93_243 VGND VGND VPWR VPWR sky130_fd_sc_hd__fill_1
XFILLER_81_405 VGND VGND VPWR VPWR sky130_fd_sc_hd__decap_3
XFILLER_19_362 VGND VGND VPWR VPWR sky130_fd_sc_hd__fill_2
XFILLER_93_287 VGND VGND VPWR VPWR sky130_fd_sc_hd__decap_3
XFILLER_93_276 VGND VGND VPWR VPWR sky130_fd_sc_hd__decap_3
XFILLER_81_427 VGND VGND VPWR VPWR sky130_fd_sc_hd__decap_3
XFILLER_75_90 VGND VGND VPWR VPWR sky130_fd_sc_hd__decap_3
XFILLER_34_343 VGND VGND VPWR VPWR sky130_fd_sc_hd__decap_3
XFILLER_81_449 VGND VGND VPWR VPWR sky130_fd_sc_hd__decap_3
XFILLER_22_516 VGND VGND VPWR VPWR sky130_fd_sc_hd__decap_3
XFILLER_34_365 VGND VGND VPWR VPWR sky130_fd_sc_hd__decap_3
XFILLER_34_376 VGND VGND VPWR VPWR sky130_fd_sc_hd__fill_2
XFILLER_34_387 VGND VGND VPWR VPWR sky130_fd_sc_hd__decap_3
X_2974_ _2913_/X _2984_/A2 _2968_/Y _4904_/Q VGND VGND VPWR VPWR _4904_/D sky130_fd_sc_hd__a22o_2
X_4713_ _5230_/Q _4800_/B _4136_/Y _4712_/X VGND VGND VPWR VPWR _4714_/B sky130_fd_sc_hd__o2bb2a_2
X_4644_ _4424_/X _4412_/X _4686_/S VGND VGND VPWR VPWR _4644_/X sky130_fd_sc_hd__mux2_1
XPHY_EDGE_ROW_15_Left_109 VGND VGND VPWR VPWR sky130_fd_sc_hd__decap_3
X_4575_ _4453_/B _4532_/A _4474_/Y _4477_/C VGND VGND VPWR VPWR _4575_/X sky130_fd_sc_hd__o22a_2
X_3526_ _3526_/A _3526_/B VGND VGND VPWR VPWR _3526_/Y sky130_fd_sc_hd__xnor2_2
XFILLER_89_505 VGND VGND VPWR VPWR sky130_fd_sc_hd__fill_1
X_3457_ _3457_/A _3457_/B _3457_/C VGND VGND VPWR VPWR _3473_/B sky130_fd_sc_hd__or3_2
XFILLER_57_402 VGND VGND VPWR VPWR sky130_fd_sc_hd__decap_3
X_3388_ _3378_/A _3378_/B _3375_/X _3377_/B VGND VGND VPWR VPWR _3388_/X sky130_fd_sc_hd__o31a_2
XFILLER_69_284 VGND VGND VPWR VPWR sky130_fd_sc_hd__decap_3
X_5127_ clkload3/A _5127_/D VGND VGND VPWR VPWR _5127_/Q sky130_fd_sc_hd__dfxtp_4
XTAP_TAPCELL_ROW_4_236 VGND VPWR sky130_fd_sc_hd__tapvpwrvgnd_1
XPHY_EDGE_ROW_24_Left_118 VGND VGND VPWR VPWR sky130_fd_sc_hd__decap_3
X_5058_ _5092_/CLK _5058_/D VGND VGND VPWR VPWR _5058_/Q sky130_fd_sc_hd__dfxtp_2
XPHY_EDGE_ROW_2_Right_2 VGND VGND VPWR VPWR sky130_fd_sc_hd__decap_3
XFILLER_55_49 VGND VGND VPWR VPWR sky130_fd_sc_hd__decap_3
X_4009_ _4429_/B _4471_/B _4010_/S VGND VGND VPWR VPWR _4009_/X sky130_fd_sc_hd__mux2_1
XFILLER_25_310 VGND VGND VPWR VPWR sky130_fd_sc_hd__decap_3
XFILLER_65_490 VGND VGND VPWR VPWR sky130_fd_sc_hd__decap_3
XFILLER_13_505 VGND VGND VPWR VPWR sky130_fd_sc_hd__decap_3
XFILLER_25_354 VGND VGND VPWR VPWR sky130_fd_sc_hd__decap_3
XFILLER_40_302 VGND VGND VPWR VPWR sky130_fd_sc_hd__decap_3
XFILLER_52_162 VGND VGND VPWR VPWR sky130_fd_sc_hd__decap_3
XTAP_TAPCELL_ROW_83_989 VGND VPWR sky130_fd_sc_hd__tapvpwrvgnd_1
XFILLER_40_324 VGND VGND VPWR VPWR sky130_fd_sc_hd__decap_3
XFILLER_71_26 VGND VGND VPWR VPWR sky130_fd_sc_hd__fill_1
XFILLER_40_379 VGND VGND VPWR VPWR sky130_fd_sc_hd__decap_3
XPHY_EDGE_ROW_33_Left_127 VGND VGND VPWR VPWR sky130_fd_sc_hd__decap_3
XPHY_EDGE_ROW_42_Left_136 VGND VGND VPWR VPWR sky130_fd_sc_hd__decap_3
XFILLER_0_486 VGND VGND VPWR VPWR sky130_fd_sc_hd__decap_3
XFILLER_48_413 VGND VGND VPWR VPWR sky130_fd_sc_hd__decap_3
XFILLER_29_94 VGND VGND VPWR VPWR sky130_fd_sc_hd__decap_3
XFILLER_48_446 VGND VGND VPWR VPWR sky130_fd_sc_hd__decap_3
XFILLER_75_287 VGND VGND VPWR VPWR sky130_fd_sc_hd__decap_3
XTAP_TAPCELL_ROW_85_1008 VGND VPWR sky130_fd_sc_hd__tapvpwrvgnd_1
XTAP_TAPCELL_ROW_74_901 VGND VPWR sky130_fd_sc_hd__tapvpwrvgnd_1
XTAP_TAPCELL_ROW_46_636 VGND VPWR sky130_fd_sc_hd__tapvpwrvgnd_1
XFILLER_16_365 VGND VGND VPWR VPWR sky130_fd_sc_hd__decap_3
XFILLER_16_376 VGND VGND VPWR VPWR sky130_fd_sc_hd__decap_3
XFILLER_31_313 VGND VGND VPWR VPWR sky130_fd_sc_hd__decap_3
XPHY_EDGE_ROW_51_Left_145 VGND VGND VPWR VPWR sky130_fd_sc_hd__decap_3
X_2690_ _4361_/A _2690_/B VGND VGND VPWR VPWR _2696_/B sky130_fd_sc_hd__xnor2_2
XFILLER_8_542 VGND VGND VPWR VPWR sky130_fd_sc_hd__decap_3
XFILLER_77_6 VGND VGND VPWR VPWR sky130_fd_sc_hd__decap_3
XANTENNA_3 _4551_/A VGND VGND VPWR VPWR sky130_fd_sc_hd__diode_2
XFILLER_6_32 VGND VGND VPWR VPWR sky130_fd_sc_hd__fill_2
XFILLER_6_43 VGND VGND VPWR VPWR sky130_fd_sc_hd__decap_3
X_4360_ _4360_/A _4360_/B _4360_/C VGND VGND VPWR VPWR _4360_/X sky130_fd_sc_hd__and3_2
X_3311_ _5159_/Q _3312_/B VGND VGND VPWR VPWR _3313_/A sky130_fd_sc_hd__nand2_2
X_4291_ _4291_/A _4291_/B VGND VGND VPWR VPWR _4291_/Y sky130_fd_sc_hd__nor2_2
XPHY_EDGE_ROW_60_Left_154 VGND VGND VPWR VPWR sky130_fd_sc_hd__decap_3
XFILLER_39_402 VGND VGND VPWR VPWR sky130_fd_sc_hd__decap_3
X_3242_ _5166_/Q _3450_/C _3228_/Y _3241_/X VGND VGND VPWR VPWR _5129_/D sky130_fd_sc_hd__o22a_2
XFILLER_86_519 VGND VGND VPWR VPWR sky130_fd_sc_hd__decap_3
XFILLER_39_424 VGND VGND VPWR VPWR sky130_fd_sc_hd__decap_3
X_3173_ _2891_/X _3185_/A2 _3185_/B1 _5075_/Q VGND VGND VPWR VPWR _5075_/D sky130_fd_sc_hd__a22o_2
XFILLER_66_232 VGND VGND VPWR VPWR sky130_fd_sc_hd__decap_3
XFILLER_39_479 VGND VGND VPWR VPWR sky130_fd_sc_hd__decap_3
XFILLER_54_427 VGND VGND VPWR VPWR sky130_fd_sc_hd__decap_3
XFILLER_66_265 VGND VGND VPWR VPWR sky130_fd_sc_hd__decap_3
XFILLER_19_192 VGND VGND VPWR VPWR sky130_fd_sc_hd__decap_3
XFILLER_66_298 VGND VGND VPWR VPWR sky130_fd_sc_hd__decap_3
XFILLER_81_279 VGND VGND VPWR VPWR sky130_fd_sc_hd__fill_1
XFILLER_62_482 VGND VGND VPWR VPWR sky130_fd_sc_hd__decap_3
XTAP_TAPCELL_ROW_80_959 VGND VPWR sky130_fd_sc_hd__tapvpwrvgnd_1
XTAP_TAPCELL_ROW_17_360 VGND VPWR sky130_fd_sc_hd__tapvpwrvgnd_1
XFILLER_22_335 VGND VGND VPWR VPWR sky130_fd_sc_hd__decap_3
XFILLER_34_195 VGND VGND VPWR VPWR sky130_fd_sc_hd__fill_1
X_2957_ _2922_/X _2948_/B _2948_/Y _4891_/Q VGND VGND VPWR VPWR _4891_/D sky130_fd_sc_hd__a22o_2
X_2888_ _3457_/A _4546_/A _2887_/B VGND VGND VPWR VPWR _2888_/Y sky130_fd_sc_hd__a21oi_2
X_4627_ _4687_/A _4621_/Y _4626_/X _4641_/B VGND VGND VPWR VPWR _4628_/B sky130_fd_sc_hd__o22a_2
X_4558_ _4558_/A _4558_/B _4558_/C _4558_/D VGND VGND VPWR VPWR _4558_/X sky130_fd_sc_hd__and4_2
XFILLER_89_313 VGND VGND VPWR VPWR sky130_fd_sc_hd__decap_3
XFILLER_1_228 VGND VGND VPWR VPWR sky130_fd_sc_hd__decap_3
X_4489_ _4489_/A _4489_/B VGND VGND VPWR VPWR _4569_/A sky130_fd_sc_hd__or2_2
X_3509_ _5157_/Q _5138_/Q VGND VGND VPWR VPWR _3510_/B sky130_fd_sc_hd__and2_2
XFILLER_89_346 VGND VGND VPWR VPWR sky130_fd_sc_hd__decap_3
XFILLER_77_508 VGND VGND VPWR VPWR sky130_fd_sc_hd__decap_3
XFILLER_57_210 VGND VGND VPWR VPWR sky130_fd_sc_hd__decap_3
XFILLER_57_232 VGND VGND VPWR VPWR sky130_fd_sc_hd__decap_3
XFILLER_45_405 VGND VGND VPWR VPWR sky130_fd_sc_hd__decap_3
XFILLER_72_202 VGND VGND VPWR VPWR sky130_fd_sc_hd__decap_3
XFILLER_45_449 VGND VGND VPWR VPWR sky130_fd_sc_hd__decap_3
XFILLER_72_235 VGND VGND VPWR VPWR sky130_fd_sc_hd__decap_3
XFILLER_72_279 VGND VGND VPWR VPWR sky130_fd_sc_hd__decap_3
XTAP_TAPCELL_ROW_43_606 VGND VPWR sky130_fd_sc_hd__tapvpwrvgnd_1
XFILLER_82_47 VGND VGND VPWR VPWR sky130_fd_sc_hd__decap_3
XFILLER_13_302 VGND VGND VPWR VPWR sky130_fd_sc_hd__decap_3
XFILLER_25_162 VGND VGND VPWR VPWR sky130_fd_sc_hd__decap_3
XFILLER_40_110 VGND VGND VPWR VPWR sky130_fd_sc_hd__decap_3
XFILLER_53_482 VGND VGND VPWR VPWR sky130_fd_sc_hd__decap_3
XFILLER_82_69 VGND VGND VPWR VPWR sky130_fd_sc_hd__decap_3
XFILLER_13_335 VGND VGND VPWR VPWR sky130_fd_sc_hd__fill_1
XTAP_TAPCELL_ROW_51_683 VGND VPWR sky130_fd_sc_hd__tapvpwrvgnd_1
XFILLER_40_187 VGND VGND VPWR VPWR sky130_fd_sc_hd__decap_3
XFILLER_5_534 VGND VGND VPWR VPWR sky130_fd_sc_hd__fill_2
Xoutput51 _2701_/Y VGND VGND VPWR VPWR DEVICES_LDW sky130_fd_sc_hd__clkdlybuf4s25_1
XFILLER_68_519 VGND VGND VPWR VPWR sky130_fd_sc_hd__decap_3
Xoutput62 _5150_/Q VGND VGND VPWR VPWR INSTR_ADDR[1] sky130_fd_sc_hd__clkdlybuf4s25_1
Xoutput73 _2695_/Y VGND VGND VPWR VPWR MAIN_LDW sky130_fd_sc_hd__clkdlybuf4s25_1
Xoutput84 _2858_/Y VGND VGND VPWR VPWR MEM_ADDR[2] sky130_fd_sc_hd__clkdlybuf4s25_1
XTAP_TAPCELL_ROW_91_1067 VGND VPWR sky130_fd_sc_hd__tapvpwrvgnd_1
Xoutput95 _2824_/X VGND VGND VPWR VPWR MEM_STR_DATA[12] sky130_fd_sc_hd__clkdlybuf4s25_1
XFILLER_48_221 VGND VGND VPWR VPWR sky130_fd_sc_hd__decap_3
XFILLER_88_390 VGND VGND VPWR VPWR sky130_fd_sc_hd__fill_1
XFILLER_36_416 VGND VGND VPWR VPWR sky130_fd_sc_hd__decap_3
XFILLER_48_276 VGND VGND VPWR VPWR sky130_fd_sc_hd__decap_3
XTAP_TAPCELL_ROW_59_761 VGND VPWR sky130_fd_sc_hd__tapvpwrvgnd_1
XFILLER_91_544 VGND VGND VPWR VPWR sky130_fd_sc_hd__decap_3
XFILLER_63_268 VGND VGND VPWR VPWR sky130_fd_sc_hd__decap_3
XFILLER_31_121 VGND VGND VPWR VPWR sky130_fd_sc_hd__fill_2
X_3860_ _4421_/C _4340_/A VGND VGND VPWR VPWR _3864_/B sky130_fd_sc_hd__or2_2
XTAP_TAPCELL_ROW_14_330 VGND VPWR sky130_fd_sc_hd__tapvpwrvgnd_1
XFILLER_31_165 VGND VGND VPWR VPWR sky130_fd_sc_hd__decap_3
XFILLER_72_91 VGND VGND VPWR VPWR sky130_fd_sc_hd__decap_3
X_3791_ _3794_/A VGND VGND VPWR VPWR _3791_/Y sky130_fd_sc_hd__inv_2
X_2811_ _5118_/Q _5006_/Q _4990_/Q _4974_/Q _2812_/S0 _2848_/S1 VGND VGND VPWR VPWR
+ _2811_/X sky130_fd_sc_hd__mux4_2
XFILLER_75_3 VGND VGND VPWR VPWR sky130_fd_sc_hd__decap_3
X_2742_ _5134_/Q _2737_/X _2739_/X _2741_/X VGND VGND VPWR VPWR _3269_/B sky130_fd_sc_hd__a22o_2
X_4412_ _4409_/Y _4411_/Y _4624_/A VGND VGND VPWR VPWR _4412_/X sky130_fd_sc_hd__mux2_1
X_2673_ _2667_/X _2669_/X _2672_/X _2435_/Y VGND VGND VPWR VPWR _3917_/B sky130_fd_sc_hd__a22oi_2
X_4343_ _4551_/A _4523_/S VGND VGND VPWR VPWR _4343_/Y sky130_fd_sc_hd__nor2_2
XFILLER_59_508 VGND VGND VPWR VPWR sky130_fd_sc_hd__decap_3
X_4274_ _4273_/X _4274_/B _4274_/C VGND VGND VPWR VPWR _4274_/X sky130_fd_sc_hd__and3b_2
X_3225_ _5262_/Q _5257_/Q VGND VGND VPWR VPWR _3227_/D sky130_fd_sc_hd__or2_2
XFILLER_86_327 VGND VGND VPWR VPWR sky130_fd_sc_hd__decap_3
XFILLER_67_541 VGND VGND VPWR VPWR sky130_fd_sc_hd__decap_3
X_3156_ _2900_/X _3170_/A2 _3170_/B1 _5060_/Q VGND VGND VPWR VPWR _5060_/D sky130_fd_sc_hd__a22o_2
XFILLER_39_287 VGND VGND VPWR VPWR sky130_fd_sc_hd__decap_3
X_3087_ _2916_/X _3093_/A2 _3096_/B1 _5001_/Q VGND VGND VPWR VPWR _5001_/D sky130_fd_sc_hd__a22o_2
XFILLER_82_533 VGND VGND VPWR VPWR sky130_fd_sc_hd__decap_3
XFILLER_82_522 VGND VGND VPWR VPWR sky130_fd_sc_hd__decap_3
XFILLER_22_132 VGND VGND VPWR VPWR sky130_fd_sc_hd__decap_3
XFILLER_50_430 VGND VGND VPWR VPWR sky130_fd_sc_hd__decap_3
XFILLER_22_176 VGND VGND VPWR VPWR sky130_fd_sc_hd__fill_2
X_3989_ _5178_/Q _3989_/B VGND VGND VPWR VPWR _4224_/A sky130_fd_sc_hd__or2_2
XFILLER_6_309 VGND VGND VPWR VPWR sky130_fd_sc_hd__decap_3
XTAP_TAPCELL_ROW_20_388 VGND VPWR sky130_fd_sc_hd__tapvpwrvgnd_1
XFILLER_7_6 VGND VGND VPWR VPWR sky130_fd_sc_hd__decap_3
XFILLER_77_36 VGND VGND VPWR VPWR sky130_fd_sc_hd__decap_3
XFILLER_77_305 VGND VGND VPWR VPWR sky130_fd_sc_hd__decap_3
XFILLER_58_530 VGND VGND VPWR VPWR sky130_fd_sc_hd__fill_2
XFILLER_77_349 VGND VGND VPWR VPWR sky130_fd_sc_hd__decap_3
XFILLER_18_416 VGND VGND VPWR VPWR sky130_fd_sc_hd__decap_3
XFILLER_73_511 VGND VGND VPWR VPWR sky130_fd_sc_hd__decap_3
XFILLER_93_24 VGND VGND VPWR VPWR sky130_fd_sc_hd__decap_3
XFILLER_18_427 VGND VGND VPWR VPWR sky130_fd_sc_hd__decap_3
XFILLER_45_213 VGND VGND VPWR VPWR sky130_fd_sc_hd__decap_3
XFILLER_73_544 VGND VGND VPWR VPWR sky130_fd_sc_hd__decap_3
XTAP_TAPCELL_ROW_56_731 VGND VPWR sky130_fd_sc_hd__tapvpwrvgnd_1
XFILLER_93_57 VGND VGND VPWR VPWR sky130_fd_sc_hd__decap_3
XFILLER_93_35 VGND VGND VPWR VPWR sky130_fd_sc_hd__decap_3
XFILLER_85_393 VGND VGND VPWR VPWR sky130_fd_sc_hd__decap_3
XFILLER_45_257 VGND VGND VPWR VPWR sky130_fd_sc_hd__decap_3
XTAP_TAPCELL_ROW_28_466 VGND VPWR sky130_fd_sc_hd__tapvpwrvgnd_1
XFILLER_26_73 VGND VGND VPWR VPWR sky130_fd_sc_hd__decap_3
XFILLER_26_493 VGND VGND VPWR VPWR sky130_fd_sc_hd__decap_3
XFILLER_41_441 VGND VGND VPWR VPWR sky130_fd_sc_hd__decap_3
XFILLER_53_290 VGND VGND VPWR VPWR sky130_fd_sc_hd__fill_2
XFILLER_42_50 VGND VGND VPWR VPWR sky130_fd_sc_hd__fill_1
XFILLER_42_83 VGND VGND VPWR VPWR sky130_fd_sc_hd__fill_1
XFILLER_42_94 VGND VGND VPWR VPWR sky130_fd_sc_hd__decap_3
XFILLER_9_169 VGND VGND VPWR VPWR sky130_fd_sc_hd__fill_1
XFILLER_5_331 VGND VGND VPWR VPWR sky130_fd_sc_hd__decap_3
XFILLER_3_77 VGND VGND VPWR VPWR sky130_fd_sc_hd__fill_1
X_3010_ _2906_/X _3006_/B _3006_/Y _4934_/Q VGND VGND VPWR VPWR _4934_/D sky130_fd_sc_hd__a22o_2
XFILLER_64_533 VGND VGND VPWR VPWR sky130_fd_sc_hd__decap_3
XFILLER_76_371 VGND VGND VPWR VPWR sky130_fd_sc_hd__decap_3
XFILLER_36_246 VGND VGND VPWR VPWR sky130_fd_sc_hd__decap_3
XFILLER_36_268 VGND VGND VPWR VPWR sky130_fd_sc_hd__decap_3
XFILLER_91_352 VGND VGND VPWR VPWR sky130_fd_sc_hd__fill_1
XFILLER_51_216 VGND VGND VPWR VPWR sky130_fd_sc_hd__decap_3
X_4961_ _5103_/CLK _4961_/D VGND VGND VPWR VPWR _4961_/Q sky130_fd_sc_hd__dfxtp_2
X_4892_ _5100_/CLK _4892_/D VGND VGND VPWR VPWR _4892_/Q sky130_fd_sc_hd__dfxtp_2
X_3912_ _4341_/A _3742_/B _3911_/X VGND VGND VPWR VPWR _3912_/Y sky130_fd_sc_hd__o21ai_2
X_3843_ _3843_/A _4482_/S VGND VGND VPWR VPWR _3845_/C sky130_fd_sc_hd__nor2_2
XTAP_TAPCELL_ROW_62_789 VGND VPWR sky130_fd_sc_hd__tapvpwrvgnd_1
XFILLER_32_485 VGND VGND VPWR VPWR sky130_fd_sc_hd__decap_3
XFILLER_32_496 VGND VGND VPWR VPWR sky130_fd_sc_hd__decap_3
X_3774_ _5122_/Q _5010_/Q _4994_/Q _4978_/Q _5127_/Q _5128_/Q VGND VGND VPWR VPWR
+ _3774_/X sky130_fd_sc_hd__mux4_2
X_2725_ _2851_/A _3259_/B VGND VGND VPWR VPWR _2725_/X sky130_fd_sc_hd__and2_2
X_2656_ _2667_/A _2653_/X _5126_/Q VGND VGND VPWR VPWR _2656_/X sky130_fd_sc_hd__o21a_2
X_2587_ _5060_/Q _5044_/Q _5028_/Q _5012_/Q _5123_/Q _2671_/S1 VGND VGND VPWR VPWR
+ _2588_/B sky130_fd_sc_hd__mux4_2
X_4326_ _4326_/A _4326_/B VGND VGND VPWR VPWR _4326_/Y sky130_fd_sc_hd__xnor2_2
XFILLER_59_349 VGND VGND VPWR VPWR sky130_fd_sc_hd__decap_3
X_4257_ _4285_/C _4380_/B _4136_/B _4242_/A VGND VGND VPWR VPWR _4258_/B sky130_fd_sc_hd__o22a_2
XFILLER_86_135 VGND VGND VPWR VPWR sky130_fd_sc_hd__decap_3
X_4188_ _4191_/A _3898_/X _4246_/A _2869_/B _4115_/A VGND VGND VPWR VPWR _4189_/B
+ sky130_fd_sc_hd__o32a_2
X_3208_ _4866_/A _3208_/B VGND VGND VPWR VPWR _3208_/Y sky130_fd_sc_hd__nor2_2
XFILLER_67_393 VGND VGND VPWR VPWR sky130_fd_sc_hd__decap_3
X_3139_ _2903_/X _3152_/A2 _3136_/Y _5045_/Q VGND VGND VPWR VPWR _5045_/D sky130_fd_sc_hd__a22o_2
XFILLER_82_330 VGND VGND VPWR VPWR sky130_fd_sc_hd__decap_3
XFILLER_42_227 VGND VGND VPWR VPWR sky130_fd_sc_hd__decap_3
XFILLER_63_27 VGND VGND VPWR VPWR sky130_fd_sc_hd__decap_3
XFILLER_63_38 VGND VGND VPWR VPWR sky130_fd_sc_hd__decap_3
XFILLER_70_514 VGND VGND VPWR VPWR sky130_fd_sc_hd__decap_3
XTAP_TAPCELL_ROW_53_701 VGND VPWR sky130_fd_sc_hd__tapvpwrvgnd_1
XFILLER_82_385 VGND VGND VPWR VPWR sky130_fd_sc_hd__decap_3
XFILLER_23_430 VGND VGND VPWR VPWR sky130_fd_sc_hd__decap_3
XFILLER_35_290 VGND VGND VPWR VPWR sky130_fd_sc_hd__decap_3
XFILLER_42_249 VGND VGND VPWR VPWR sky130_fd_sc_hd__decap_3
XTAP_TAPCELL_ROW_25_436 VGND VPWR sky130_fd_sc_hd__tapvpwrvgnd_1
XFILLER_23_452 VGND VGND VPWR VPWR sky130_fd_sc_hd__decap_3
XFILLER_50_282 VGND VGND VPWR VPWR sky130_fd_sc_hd__decap_3
XFILLER_6_139 VGND VGND VPWR VPWR sky130_fd_sc_hd__fill_1
XFILLER_12_97 VGND VGND VPWR VPWR sky130_fd_sc_hd__decap_3
XFILLER_88_35 VGND VGND VPWR VPWR sky130_fd_sc_hd__decap_3
XFILLER_5_3 VGND VGND VPWR VPWR sky130_fd_sc_hd__decap_3
XFILLER_77_113 VGND VGND VPWR VPWR sky130_fd_sc_hd__decap_3
XFILLER_77_102 VGND VGND VPWR VPWR sky130_fd_sc_hd__decap_3
XFILLER_77_146 VGND VGND VPWR VPWR sky130_fd_sc_hd__decap_3
XFILLER_46_522 VGND VGND VPWR VPWR sky130_fd_sc_hd__decap_3
XFILLER_58_371 VGND VGND VPWR VPWR sky130_fd_sc_hd__decap_3
XFILLER_61_503 VGND VGND VPWR VPWR sky130_fd_sc_hd__fill_1
XFILLER_61_514 VGND VGND VPWR VPWR sky130_fd_sc_hd__decap_3
XFILLER_14_430 VGND VGND VPWR VPWR sky130_fd_sc_hd__decap_3
XFILLER_41_293 VGND VGND VPWR VPWR sky130_fd_sc_hd__fill_2
X_3490_ _3483_/Y _3489_/X _4866_/A VGND VGND VPWR VPWR _5192_/D sky130_fd_sc_hd__a21oi_2
X_2510_ _2508_/X _2509_/X _2667_/A VGND VGND VPWR VPWR _2510_/X sky130_fd_sc_hd__mux2_1
XFILLER_5_161 VGND VGND VPWR VPWR sky130_fd_sc_hd__decap_3
XFILLER_5_172 VGND VGND VPWR VPWR sky130_fd_sc_hd__fill_2
X_2441_ _5177_/Q _2446_/B VGND VGND VPWR VPWR _3679_/B sky130_fd_sc_hd__nor2_2
XFILLER_5_194 VGND VGND VPWR VPWR sky130_fd_sc_hd__decap_3
X_5160_ _5164_/CLK _5160_/D VGND VGND VPWR VPWR _5160_/Q sky130_fd_sc_hd__dfxtp_2
X_4111_ _4132_/A _4105_/X _4110_/X _4104_/X VGND VGND VPWR VPWR _4111_/X sky130_fd_sc_hd__a211o_2
X_5091_ _5094_/CLK _5091_/D VGND VGND VPWR VPWR _5091_/Q sky130_fd_sc_hd__dfxtp_2
XFILLER_68_157 VGND VGND VPWR VPWR sky130_fd_sc_hd__decap_3
X_4042_ _4042_/A _4042_/B _4040_/A VGND VGND VPWR VPWR _4042_/X sky130_fd_sc_hd__or3b_2
XFILLER_37_511 VGND VGND VPWR VPWR sky130_fd_sc_hd__decap_3
XFILLER_49_382 VGND VGND VPWR VPWR sky130_fd_sc_hd__decap_3
XFILLER_49_393 VGND VGND VPWR VPWR sky130_fd_sc_hd__decap_3
XTAP_TAPCELL_ROW_67_837 VGND VPWR sky130_fd_sc_hd__tapvpwrvgnd_1
XFILLER_83_116 VGND VGND VPWR VPWR sky130_fd_sc_hd__decap_3
XFILLER_64_330 VGND VGND VPWR VPWR sky130_fd_sc_hd__decap_3
XFILLER_52_525 VGND VGND VPWR VPWR sky130_fd_sc_hd__fill_1
XFILLER_52_536 VGND VGND VPWR VPWR sky130_fd_sc_hd__fill_2
XFILLER_64_374 VGND VGND VPWR VPWR sky130_fd_sc_hd__decap_3
XFILLER_24_238 VGND VGND VPWR VPWR sky130_fd_sc_hd__decap_3
X_4944_ _5122_/CLK _4944_/D VGND VGND VPWR VPWR _4944_/Q sky130_fd_sc_hd__dfxtp_2
XTAP_TAPCELL_ROW_22_406 VGND VPWR sky130_fd_sc_hd__tapvpwrvgnd_1
X_4875_ _5121_/CLK _4875_/D VGND VGND VPWR VPWR _4875_/Q sky130_fd_sc_hd__dfxtp_2
X_3826_ _4493_/A _4397_/A VGND VGND VPWR VPWR _3827_/A sky130_fd_sc_hd__nand2_2
XFILLER_20_477 VGND VGND VPWR VPWR sky130_fd_sc_hd__decap_3
X_3757_ _4326_/A _4291_/A VGND VGND VPWR VPWR _3781_/A sky130_fd_sc_hd__nor2_2
X_2708_ _4883_/Q _4867_/Q _5091_/Q _5075_/Q _2812_/S0 _2848_/S1 VGND VGND VPWR VPWR
+ _2708_/X sky130_fd_sc_hd__mux4_2
XTAP_TAPCELL_ROW_30_483 VGND VPWR sky130_fd_sc_hd__tapvpwrvgnd_1
X_3688_ _5115_/Q _5003_/Q _4987_/Q _4971_/Q _5127_/Q _5128_/Q VGND VGND VPWR VPWR
+ _3688_/X sky130_fd_sc_hd__mux4_2
X_2639_ _5161_/Q _4468_/A VGND VGND VPWR VPWR _4223_/A sky130_fd_sc_hd__xnor2_2
XFILLER_59_102 VGND VGND VPWR VPWR sky130_fd_sc_hd__decap_3
XFILLER_87_411 VGND VGND VPWR VPWR sky130_fd_sc_hd__decap_3
XFILLER_59_146 VGND VGND VPWR VPWR sky130_fd_sc_hd__decap_3
X_4309_ _4326_/A _4309_/B VGND VGND VPWR VPWR _4310_/B sky130_fd_sc_hd__xnor2_2
XFILLER_87_455 VGND VGND VPWR VPWR sky130_fd_sc_hd__decap_3
XFILLER_87_444 VGND VGND VPWR VPWR sky130_fd_sc_hd__decap_3
XFILLER_87_477 VGND VGND VPWR VPWR sky130_fd_sc_hd__decap_3
XFILLER_28_511 VGND VGND VPWR VPWR sky130_fd_sc_hd__decap_3
XFILLER_28_544 VGND VGND VPWR VPWR sky130_fd_sc_hd__decap_3
XFILLER_55_330 VGND VGND VPWR VPWR sky130_fd_sc_hd__fill_1
XFILLER_74_149 VGND VGND VPWR VPWR sky130_fd_sc_hd__decap_3
XFILLER_43_514 VGND VGND VPWR VPWR sky130_fd_sc_hd__decap_3
XTAP_TAPCELL_ROW_38_561 VGND VPWR sky130_fd_sc_hd__tapvpwrvgnd_1
XFILLER_82_160 VGND VGND VPWR VPWR sky130_fd_sc_hd__decap_3
XFILLER_43_536 VGND VGND VPWR VPWR sky130_fd_sc_hd__fill_2
XFILLER_55_396 VGND VGND VPWR VPWR sky130_fd_sc_hd__decap_3
XFILLER_70_333 VGND VGND VPWR VPWR sky130_fd_sc_hd__decap_3
XFILLER_70_377 VGND VGND VPWR VPWR sky130_fd_sc_hd__decap_3
XFILLER_23_271 VGND VGND VPWR VPWR sky130_fd_sc_hd__decap_3
XFILLER_11_488 VGND VGND VPWR VPWR sky130_fd_sc_hd__decap_3
XFILLER_23_74 VGND VGND VPWR VPWR sky130_fd_sc_hd__decap_3
XFILLER_2_197 VGND VGND VPWR VPWR sky130_fd_sc_hd__decap_3
XFILLER_78_444 VGND VGND VPWR VPWR sky130_fd_sc_hd__decap_3
XFILLER_24_9 VGND VGND VPWR VPWR sky130_fd_sc_hd__decap_3
XFILLER_65_116 VGND VGND VPWR VPWR sky130_fd_sc_hd__decap_3
XFILLER_65_138 VGND VGND VPWR VPWR sky130_fd_sc_hd__decap_3
XTAP_TAPCELL_ROW_88_1039 VGND VPWR sky130_fd_sc_hd__tapvpwrvgnd_1
XFILLER_93_436 VGND VGND VPWR VPWR sky130_fd_sc_hd__decap_3
XFILLER_0_12 VGND VGND VPWR VPWR sky130_fd_sc_hd__decap_3
XFILLER_0_23 VGND VGND VPWR VPWR sky130_fd_sc_hd__decap_3
XFILLER_46_341 VGND VGND VPWR VPWR sky130_fd_sc_hd__fill_1
XTAP_TAPCELL_ROW_64_807 VGND VPWR sky130_fd_sc_hd__tapvpwrvgnd_1
XFILLER_93_458 VGND VGND VPWR VPWR sky130_fd_sc_hd__decap_3
XFILLER_34_514 VGND VGND VPWR VPWR sky130_fd_sc_hd__decap_3
XFILLER_46_363 VGND VGND VPWR VPWR sky130_fd_sc_hd__fill_1
XFILLER_73_160 VGND VGND VPWR VPWR sky130_fd_sc_hd__decap_3
XFILLER_34_547 VGND VGND VPWR VPWR sky130_fd_sc_hd__decap_3
XFILLER_61_377 VGND VGND VPWR VPWR sky130_fd_sc_hd__decap_3
X_2990_ _2903_/X _2987_/B _2987_/Y _4917_/Q VGND VGND VPWR VPWR _4917_/D sky130_fd_sc_hd__a22o_2
XTAP_TAPCELL_ROW_72_884 VGND VPWR sky130_fd_sc_hd__tapvpwrvgnd_1
X_4660_ _4722_/B _4545_/A _4804_/A VGND VGND VPWR VPWR _4661_/A sky130_fd_sc_hd__mux2_1
XFILLER_9_65 VGND VGND VPWR VPWR sky130_fd_sc_hd__decap_3
X_3611_ _5060_/Q _5044_/Q _5028_/Q _5012_/Q _3834_/S0 _3834_/S1 VGND VGND VPWR VPWR
+ _3611_/X sky130_fd_sc_hd__mux4_2
X_4591_ _2585_/A _3678_/X _2585_/B _4547_/A VGND VGND VPWR VPWR _4591_/X sky130_fd_sc_hd__o2bb2a_2
X_3542_ _5199_/Q _4800_/B _3585_/A _3541_/Y VGND VGND VPWR VPWR _3543_/B sky130_fd_sc_hd__o2bb2a_2
X_3473_ _4850_/B _3473_/B VGND VGND VPWR VPWR _3585_/A sky130_fd_sc_hd__or2_2
X_5212_ _5241_/CLK _5212_/D VGND VGND VPWR VPWR _5212_/Q sky130_fd_sc_hd__dfxtp_2
X_2424_ _5191_/Q VGND VGND VPWR VPWR _2424_/Y sky130_fd_sc_hd__inv_2
XFILLER_88_219 VGND VGND VPWR VPWR sky130_fd_sc_hd__decap_3
XFILLER_69_444 VGND VGND VPWR VPWR sky130_fd_sc_hd__decap_3
X_5143_ _5200_/CLK _5143_/D VGND VGND VPWR VPWR _5143_/Q sky130_fd_sc_hd__dfxtp_2
XFILLER_29_308 VGND VGND VPWR VPWR sky130_fd_sc_hd__fill_1
XFILLER_56_138 VGND VGND VPWR VPWR sky130_fd_sc_hd__fill_2
X_5074_ _5092_/CLK _5074_/D VGND VGND VPWR VPWR _5074_/Q sky130_fd_sc_hd__dfxtp_2
XFILLER_84_447 VGND VGND VPWR VPWR sky130_fd_sc_hd__decap_3
X_4025_ _4063_/A _4025_/B VGND VGND VPWR VPWR _4346_/B sky130_fd_sc_hd__nand2b_2
XFILLER_37_352 VGND VGND VPWR VPWR sky130_fd_sc_hd__decap_3
XFILLER_52_300 VGND VGND VPWR VPWR sky130_fd_sc_hd__decap_3
XFILLER_71_119 VGND VGND VPWR VPWR sky130_fd_sc_hd__decap_3
XFILLER_52_333 VGND VGND VPWR VPWR sky130_fd_sc_hd__decap_3
XFILLER_64_182 VGND VGND VPWR VPWR sky130_fd_sc_hd__fill_2
XTAP_TAPCELL_ROW_35_531 VGND VPWR sky130_fd_sc_hd__tapvpwrvgnd_1
XFILLER_92_480 VGND VGND VPWR VPWR sky130_fd_sc_hd__decap_3
XFILLER_52_388 VGND VGND VPWR VPWR sky130_fd_sc_hd__decap_3
X_4927_ clkload9/A _4927_/D VGND VGND VPWR VPWR _4927_/Q sky130_fd_sc_hd__dfxtp_2
X_4858_ _5167_/Q _3429_/C _3228_/Y _3243_/X VGND VGND VPWR VPWR _5167_/D sky130_fd_sc_hd__o22a_2
X_3809_ _4592_/S _3809_/B VGND VGND VPWR VPWR _4040_/A sky130_fd_sc_hd__nor2_2
X_4789_ _4804_/A _4789_/B VGND VGND VPWR VPWR _4789_/Y sky130_fd_sc_hd__nor2_2
XTAP_TAPCELL_ROW_7_267 VGND VPWR sky130_fd_sc_hd__tapvpwrvgnd_1
XFILLER_85_25 VGND VGND VPWR VPWR sky130_fd_sc_hd__decap_3
XFILLER_47_105 VGND VGND VPWR VPWR sky130_fd_sc_hd__decap_3
XFILLER_47_116 VGND VGND VPWR VPWR sky130_fd_sc_hd__fill_2
XFILLER_87_296 VGND VGND VPWR VPWR sky130_fd_sc_hd__decap_3
XFILLER_75_425 VGND VGND VPWR VPWR sky130_fd_sc_hd__decap_3
XFILLER_75_458 VGND VGND VPWR VPWR sky130_fd_sc_hd__decap_3
XFILLER_18_85 VGND VGND VPWR VPWR sky130_fd_sc_hd__decap_3
XFILLER_43_333 VGND VGND VPWR VPWR sky130_fd_sc_hd__decap_3
XFILLER_55_182 VGND VGND VPWR VPWR sky130_fd_sc_hd__decap_3
XFILLER_83_480 VGND VGND VPWR VPWR sky130_fd_sc_hd__decap_3
XFILLER_43_366 VGND VGND VPWR VPWR sky130_fd_sc_hd__decap_3
XFILLER_70_152 VGND VGND VPWR VPWR sky130_fd_sc_hd__decap_3
XFILLER_43_399 VGND VGND VPWR VPWR sky130_fd_sc_hd__decap_3
XFILLER_11_252 VGND VGND VPWR VPWR sky130_fd_sc_hd__decap_3
XTAP_TAPCELL_ROW_41_589 VGND VPWR sky130_fd_sc_hd__tapvpwrvgnd_1
XFILLER_50_50 VGND VGND VPWR VPWR sky130_fd_sc_hd__decap_3
XFILLER_22_6 VGND VGND VPWR VPWR sky130_fd_sc_hd__decap_3
XFILLER_66_436 VGND VGND VPWR VPWR sky130_fd_sc_hd__decap_3
XTAP_TAPCELL_ROW_77_932 VGND VPWR sky130_fd_sc_hd__tapvpwrvgnd_1
XFILLER_93_200 VGND VGND VPWR VPWR sky130_fd_sc_hd__decap_3
XFILLER_19_330 VGND VGND VPWR VPWR sky130_fd_sc_hd__decap_3
XTAP_TAPCELL_ROW_49_667 VGND VPWR sky130_fd_sc_hd__tapvpwrvgnd_1
XFILLER_19_352 VGND VGND VPWR VPWR sky130_fd_sc_hd__fill_2
XFILLER_53_108 VGND VGND VPWR VPWR sky130_fd_sc_hd__decap_3
XFILLER_19_396 VGND VGND VPWR VPWR sky130_fd_sc_hd__decap_3
XFILLER_93_299 VGND VGND VPWR VPWR sky130_fd_sc_hd__decap_3
XFILLER_34_355 VGND VGND VPWR VPWR sky130_fd_sc_hd__decap_3
XFILLER_34_399 VGND VGND VPWR VPWR sky130_fd_sc_hd__decap_3
XFILLER_61_174 VGND VGND VPWR VPWR sky130_fd_sc_hd__decap_3
X_2973_ _2910_/X _2984_/A2 _2968_/Y _4903_/Q VGND VGND VPWR VPWR _4903_/D sky130_fd_sc_hd__a22o_2
XTAP_TAPCELL_ROW_32_501 VGND VPWR sky130_fd_sc_hd__tapvpwrvgnd_1
X_4712_ _4712_/A _4712_/B _4712_/C _4712_/D VGND VGND VPWR VPWR _4712_/X sky130_fd_sc_hd__and4_2
X_4643_ _4416_/X _4671_/B VGND VGND VPWR VPWR _4643_/Y sky130_fd_sc_hd__nand2b_2
X_4574_ _4573_/A _4573_/B _4573_/Y _4002_/Y VGND VGND VPWR VPWR _4574_/Y sky130_fd_sc_hd__o211ai_2
X_3525_ _3518_/A _3516_/B _3518_/B _3514_/X VGND VGND VPWR VPWR _3526_/B sky130_fd_sc_hd__a31o_2
X_3456_ _4850_/B _3456_/B VGND VGND VPWR VPWR _3456_/X sky130_fd_sc_hd__or2_2
X_3387_ _3387_/A _3387_/B VGND VGND VPWR VPWR _3387_/X sky130_fd_sc_hd__and2_2
XFILLER_29_116 VGND VGND VPWR VPWR sky130_fd_sc_hd__decap_3
XFILLER_57_414 VGND VGND VPWR VPWR sky130_fd_sc_hd__decap_3
XFILLER_69_274 VGND VGND VPWR VPWR sky130_fd_sc_hd__decap_3
X_5126_ clkload3/A _5126_/D VGND VGND VPWR VPWR _5126_/Q sky130_fd_sc_hd__dfxtp_2
XTAP_TAPCELL_ROW_4_237 VGND VPWR sky130_fd_sc_hd__tapvpwrvgnd_1
XFILLER_84_200 VGND VGND VPWR VPWR sky130_fd_sc_hd__decap_3
X_5057_ clkload6/A _5057_/D VGND VGND VPWR VPWR _5057_/Q sky130_fd_sc_hd__dfxtp_2
XFILLER_84_222 VGND VGND VPWR VPWR sky130_fd_sc_hd__decap_3
XFILLER_55_28 VGND VGND VPWR VPWR sky130_fd_sc_hd__decap_3
X_4008_ _4007_/X _4614_/A _4077_/S VGND VGND VPWR VPWR _4008_/X sky130_fd_sc_hd__mux2_1
XFILLER_84_277 VGND VGND VPWR VPWR sky130_fd_sc_hd__decap_3
XFILLER_52_130 VGND VGND VPWR VPWR sky130_fd_sc_hd__decap_3
XFILLER_52_141 VGND VGND VPWR VPWR sky130_fd_sc_hd__decap_3
XFILLER_80_461 VGND VGND VPWR VPWR sky130_fd_sc_hd__decap_3
XFILLER_13_528 VGND VGND VPWR VPWR sky130_fd_sc_hd__decap_3
XFILLER_71_38 VGND VGND VPWR VPWR sky130_fd_sc_hd__decap_3
XFILLER_40_336 VGND VGND VPWR VPWR sky130_fd_sc_hd__decap_3
XFILLER_21_550 VGND VGND VPWR VPWR sky130_fd_sc_hd__decap_3
XFILLER_20_64 VGND VGND VPWR VPWR sky130_fd_sc_hd__decap_3
XFILLER_0_421 VGND VGND VPWR VPWR sky130_fd_sc_hd__decap_3
XFILLER_0_443 VGND VGND VPWR VPWR sky130_fd_sc_hd__decap_3
XFILLER_88_550 VGND VGND VPWR VPWR sky130_fd_sc_hd__decap_3
XFILLER_0_498 VGND VGND VPWR VPWR sky130_fd_sc_hd__decap_3
XFILLER_29_73 VGND VGND VPWR VPWR sky130_fd_sc_hd__decap_3
XFILLER_35_119 VGND VGND VPWR VPWR sky130_fd_sc_hd__decap_3
XTAP_TAPCELL_ROW_85_1009 VGND VPWR sky130_fd_sc_hd__tapvpwrvgnd_1
XTAP_TAPCELL_ROW_74_902 VGND VPWR sky130_fd_sc_hd__tapvpwrvgnd_1
XFILLER_56_480 VGND VGND VPWR VPWR sky130_fd_sc_hd__decap_3
XTAP_TAPCELL_ROW_46_637 VGND VPWR sky130_fd_sc_hd__tapvpwrvgnd_1
XFILLER_12_550 VGND VGND VPWR VPWR sky130_fd_sc_hd__decap_3
XFILLER_61_60 VGND VGND VPWR VPWR sky130_fd_sc_hd__decap_3
XFILLER_8_510 VGND VGND VPWR VPWR sky130_fd_sc_hd__decap_3
XFILLER_61_93 VGND VGND VPWR VPWR sky130_fd_sc_hd__fill_2
XANTENNA_4 _4471_/B VGND VGND VPWR VPWR sky130_fd_sc_hd__diode_2
XFILLER_6_88 VGND VGND VPWR VPWR sky130_fd_sc_hd__decap_3
X_3310_ _5139_/Q _3265_/B _3306_/Y _3309_/X _3448_/B VGND VGND VPWR VPWR _5139_/D
+ sky130_fd_sc_hd__o221a_2
XFILLER_3_270 VGND VGND VPWR VPWR sky130_fd_sc_hd__fill_2
XFILLER_3_281 VGND VGND VPWR VPWR sky130_fd_sc_hd__decap_3
X_4290_ _4291_/A _4291_/B VGND VGND VPWR VPWR _4290_/X sky130_fd_sc_hd__and2_2
X_3241_ _5260_/Q _3448_/B input6/X VGND VGND VPWR VPWR _3241_/X sky130_fd_sc_hd__and3_2
XFILLER_20_3 VGND VGND VPWR VPWR sky130_fd_sc_hd__decap_3
XFILLER_66_211 VGND VGND VPWR VPWR sky130_fd_sc_hd__decap_3
X_3172_ _4866_/A _3172_/B VGND VGND VPWR VPWR _3172_/Y sky130_fd_sc_hd__nor2_2
XFILLER_39_436 VGND VGND VPWR VPWR sky130_fd_sc_hd__decap_3
XFILLER_39_458 VGND VGND VPWR VPWR sky130_fd_sc_hd__decap_3
XTAP_TAPCELL_ROW_1_207 VGND VPWR sky130_fd_sc_hd__tapvpwrvgnd_1
XFILLER_86_90 VGND VGND VPWR VPWR sky130_fd_sc_hd__decap_3
XFILLER_54_406 VGND VGND VPWR VPWR sky130_fd_sc_hd__decap_3
XFILLER_66_277 VGND VGND VPWR VPWR sky130_fd_sc_hd__decap_3
XFILLER_81_203 VGND VGND VPWR VPWR sky130_fd_sc_hd__decap_3
XFILLER_54_439 VGND VGND VPWR VPWR sky130_fd_sc_hd__decap_3
XFILLER_81_225 VGND VGND VPWR VPWR sky130_fd_sc_hd__decap_3
XFILLER_34_130 VGND VGND VPWR VPWR sky130_fd_sc_hd__decap_3
XFILLER_34_141 VGND VGND VPWR VPWR sky130_fd_sc_hd__decap_3
XFILLER_81_258 VGND VGND VPWR VPWR sky130_fd_sc_hd__decap_3
XTAP_TAPCELL_ROW_17_361 VGND VPWR sky130_fd_sc_hd__tapvpwrvgnd_1
X_2956_ _2919_/X _2961_/A2 _2961_/B1 _4890_/Q VGND VGND VPWR VPWR _4890_/D sky130_fd_sc_hd__a22o_2
XFILLER_30_391 VGND VGND VPWR VPWR sky130_fd_sc_hd__decap_3
X_2887_ _2887_/A _2887_/B _4333_/C VGND VGND VPWR VPWR _2887_/Y sky130_fd_sc_hd__nor3b_2
X_4626_ _4686_/S _4625_/Y _4623_/X _4622_/Y VGND VGND VPWR VPWR _4626_/X sky130_fd_sc_hd__o2bb2a_2
Xclkbuf_leaf_35_CLK clkload1/A VGND VGND VPWR VPWR _5098_/CLK sky130_fd_sc_hd__clkbuf_8
X_4557_ _4537_/X _4545_/Y _4556_/X VGND VGND VPWR VPWR _4558_/D sky130_fd_sc_hd__o21ba_2
X_4488_ _4379_/Y _4487_/X _4866_/A VGND VGND VPWR VPWR _5222_/D sky130_fd_sc_hd__a21oi_2
X_3508_ _3510_/A VGND VGND VPWR VPWR _3518_/A sky130_fd_sc_hd__inv_2
XFILLER_89_325 VGND VGND VPWR VPWR sky130_fd_sc_hd__decap_3
X_3439_ _5177_/Q _3450_/C _3228_/Y _3438_/X VGND VGND VPWR VPWR _5177_/D sky130_fd_sc_hd__o22a_2
XFILLER_85_520 VGND VGND VPWR VPWR sky130_fd_sc_hd__decap_3
XFILLER_57_244 VGND VGND VPWR VPWR sky130_fd_sc_hd__decap_3
X_5109_ _5109_/CLK _5109_/D VGND VGND VPWR VPWR _5109_/Q sky130_fd_sc_hd__dfxtp_2
XFILLER_17_119 VGND VGND VPWR VPWR sky130_fd_sc_hd__decap_3
XFILLER_38_480 VGND VGND VPWR VPWR sky130_fd_sc_hd__decap_3
XFILLER_72_214 VGND VGND VPWR VPWR sky130_fd_sc_hd__decap_3
XFILLER_72_225 VGND VGND VPWR VPWR sky130_fd_sc_hd__fill_1
XFILLER_60_409 VGND VGND VPWR VPWR sky130_fd_sc_hd__decap_3
XFILLER_72_247 VGND VGND VPWR VPWR sky130_fd_sc_hd__decap_3
XTAP_TAPCELL_ROW_43_607 VGND VPWR sky130_fd_sc_hd__tapvpwrvgnd_1
XFILLER_15_20 VGND VGND VPWR VPWR sky130_fd_sc_hd__decap_3
XFILLER_53_461 VGND VGND VPWR VPWR sky130_fd_sc_hd__decap_3
XFILLER_53_494 VGND VGND VPWR VPWR sky130_fd_sc_hd__decap_3
XFILLER_13_358 VGND VGND VPWR VPWR sky130_fd_sc_hd__decap_3
XFILLER_15_64 VGND VGND VPWR VPWR sky130_fd_sc_hd__decap_3
XFILLER_40_144 VGND VGND VPWR VPWR sky130_fd_sc_hd__decap_3
XTAP_TAPCELL_ROW_51_684 VGND VPWR sky130_fd_sc_hd__tapvpwrvgnd_1
XFILLER_5_502 VGND VGND VPWR VPWR sky130_fd_sc_hd__fill_2
XFILLER_5_513 VGND VGND VPWR VPWR sky130_fd_sc_hd__decap_3
Xclkbuf_leaf_26_CLK clkload2/A VGND VGND VPWR VPWR _5111_/CLK sky130_fd_sc_hd__clkbuf_8
Xoutput52 _2698_/Y VGND VGND VPWR VPWR DEVICES_STRH sky130_fd_sc_hd__clkdlybuf4s25_1
Xoutput63 _5135_/Q VGND VGND VPWR VPWR INSTR_ADDR[2] sky130_fd_sc_hd__clkdlybuf4s25_1
Xoutput74 _2692_/Y VGND VGND VPWR VPWR MAIN_STRH sky130_fd_sc_hd__clkdlybuf4s25_1
Xoutput85 _2860_/Y VGND VGND VPWR VPWR MEM_ADDR[3] sky130_fd_sc_hd__clkdlybuf4s25_1
XTAP_TAPCELL_ROW_91_1068 VGND VPWR sky130_fd_sc_hd__tapvpwrvgnd_1
XFILLER_0_240 VGND VGND VPWR VPWR sky130_fd_sc_hd__decap_3
XFILLER_0_262 VGND VGND VPWR VPWR sky130_fd_sc_hd__decap_3
XFILLER_48_200 VGND VGND VPWR VPWR sky130_fd_sc_hd__decap_3
Xoutput96 _2833_/X VGND VGND VPWR VPWR MEM_STR_DATA[13] sky130_fd_sc_hd__clkdlybuf4s25_1
XFILLER_0_284 VGND VGND VPWR VPWR sky130_fd_sc_hd__decap_3
XFILLER_48_233 VGND VGND VPWR VPWR sky130_fd_sc_hd__decap_3
XFILLER_76_542 VGND VGND VPWR VPWR sky130_fd_sc_hd__decap_3
XTAP_TAPCELL_ROW_59_762 VGND VPWR sky130_fd_sc_hd__tapvpwrvgnd_1
XFILLER_91_512 VGND VGND VPWR VPWR sky130_fd_sc_hd__decap_3
XFILLER_29_480 VGND VGND VPWR VPWR sky130_fd_sc_hd__decap_3
XFILLER_36_428 VGND VGND VPWR VPWR sky130_fd_sc_hd__decap_3
XFILLER_48_288 VGND VGND VPWR VPWR sky130_fd_sc_hd__decap_3
XFILLER_56_71 VGND VGND VPWR VPWR sky130_fd_sc_hd__decap_3
XFILLER_63_214 VGND VGND VPWR VPWR sky130_fd_sc_hd__fill_1
XFILLER_63_225 VGND VGND VPWR VPWR sky130_fd_sc_hd__fill_2
XFILLER_44_472 VGND VGND VPWR VPWR sky130_fd_sc_hd__decap_3
XFILLER_44_494 VGND VGND VPWR VPWR sky130_fd_sc_hd__decap_3
XTAP_TAPCELL_ROW_14_331 VGND VPWR sky130_fd_sc_hd__tapvpwrvgnd_1
X_3790_ _4464_/B _3885_/B VGND VGND VPWR VPWR _3794_/A sky130_fd_sc_hd__nor2_2
X_2810_ _2831_/S _2809_/X _5134_/Q VGND VGND VPWR VPWR _2810_/X sky130_fd_sc_hd__o21a_2
X_2741_ _2831_/S _2740_/X _2437_/Y VGND VGND VPWR VPWR _2741_/X sky130_fd_sc_hd__o21a_2
Xclkbuf_leaf_17_CLK clkload0/A VGND VGND VPWR VPWR _5252_/CLK sky130_fd_sc_hd__clkbuf_8
XFILLER_8_362 VGND VGND VPWR VPWR sky130_fd_sc_hd__fill_2
XFILLER_68_3 VGND VGND VPWR VPWR sky130_fd_sc_hd__decap_3
X_4411_ _4411_/A VGND VGND VPWR VPWR _4411_/Y sky130_fd_sc_hd__inv_2
X_2672_ _2670_/X _2671_/X _5125_/Q VGND VGND VPWR VPWR _2672_/X sky130_fd_sc_hd__mux2_1
X_4342_ _4342_/A VGND VGND VPWR VPWR _4342_/Y sky130_fd_sc_hd__inv_2
X_4273_ _3922_/A _4000_/X _4002_/Y _2665_/A _4800_/B VGND VGND VPWR VPWR _4273_/X
+ sky130_fd_sc_hd__a221o_2
X_3224_ _2944_/X _3208_/B _3208_/Y _5122_/Q VGND VGND VPWR VPWR _5122_/D sky130_fd_sc_hd__a22o_2
XFILLER_86_339 VGND VGND VPWR VPWR sky130_fd_sc_hd__decap_3
XFILLER_86_306 VGND VGND VPWR VPWR sky130_fd_sc_hd__fill_2
.ends
