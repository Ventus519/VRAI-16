* NGSPICE file created from VRAI_SYNC_CORE.ext - technology: sky130A

* Black-box entry subcircuit for sky130_fd_sc_hd__decap_3 abstract view
.subckt sky130_fd_sc_hd__decap_3 VGND VNB VPB VPWR
.ends

* Black-box entry subcircuit for sky130_fd_sc_hd__fill_1 abstract view
.subckt sky130_fd_sc_hd__fill_1 VGND VNB VPB VPWR
.ends

* Black-box entry subcircuit for sky130_fd_sc_hd__a22o_2 abstract view
.subckt sky130_fd_sc_hd__a22o_2 A1 A2 B1 B2 VGND VNB VPB VPWR X
.ends

* Black-box entry subcircuit for sky130_fd_sc_hd__a211o_2 abstract view
.subckt sky130_fd_sc_hd__a211o_2 A1 A2 B1 C1 VGND VNB VPB VPWR X
.ends

* Black-box entry subcircuit for sky130_fd_sc_hd__tapvpwrvgnd_1 abstract view
.subckt sky130_fd_sc_hd__tapvpwrvgnd_1 VGND VPWR
.ends

* Black-box entry subcircuit for sky130_fd_sc_hd__fill_2 abstract view
.subckt sky130_fd_sc_hd__fill_2 VGND VNB VPB VPWR
.ends

* Black-box entry subcircuit for sky130_fd_sc_hd__clkbuf_8 abstract view
.subckt sky130_fd_sc_hd__clkbuf_8 A VGND VNB VPB VPWR X
.ends

* Black-box entry subcircuit for sky130_fd_sc_hd__dfxtp_2 abstract view
.subckt sky130_fd_sc_hd__dfxtp_2 CLK D VGND VNB VPB VPWR Q
.ends

* Black-box entry subcircuit for sky130_fd_sc_hd__o311a_2 abstract view
.subckt sky130_fd_sc_hd__o311a_2 A1 A2 A3 B1 C1 VGND VNB VPB VPWR X
.ends

* Black-box entry subcircuit for sky130_fd_sc_hd__and2_2 abstract view
.subckt sky130_fd_sc_hd__and2_2 A B VGND VNB VPB VPWR X
.ends

* Black-box entry subcircuit for sky130_fd_sc_hd__or4_2 abstract view
.subckt sky130_fd_sc_hd__or4_2 A B C D VGND VNB VPB VPWR X
.ends

* Black-box entry subcircuit for sky130_fd_sc_hd__mux4_2 abstract view
.subckt sky130_fd_sc_hd__mux4_2 A0 A1 A2 A3 S0 S1 VGND VNB VPB VPWR X
.ends

* Black-box entry subcircuit for sky130_fd_sc_hd__or2_2 abstract view
.subckt sky130_fd_sc_hd__or2_2 A B VGND VNB VPB VPWR X
.ends

* Black-box entry subcircuit for sky130_fd_sc_hd__or3_2 abstract view
.subckt sky130_fd_sc_hd__or3_2 A B C VGND VNB VPB VPWR X
.ends

* Black-box entry subcircuit for sky130_fd_sc_hd__a211oi_2 abstract view
.subckt sky130_fd_sc_hd__a211oi_2 A1 A2 B1 C1 VGND VNB VPB VPWR Y
.ends

* Black-box entry subcircuit for sky130_fd_sc_hd__o221a_2 abstract view
.subckt sky130_fd_sc_hd__o221a_2 A1 A2 B1 B2 C1 VGND VNB VPB VPWR X
.ends

* Black-box entry subcircuit for sky130_fd_sc_hd__nor2_4 abstract view
.subckt sky130_fd_sc_hd__nor2_4 A B VGND VNB VPB VPWR Y
.ends

* Black-box entry subcircuit for sky130_fd_sc_hd__nor2_2 abstract view
.subckt sky130_fd_sc_hd__nor2_2 A B VGND VNB VPB VPWR Y
.ends

* Black-box entry subcircuit for sky130_fd_sc_hd__a31o_2 abstract view
.subckt sky130_fd_sc_hd__a31o_2 A1 A2 A3 B1 VGND VNB VPB VPWR X
.ends

* Black-box entry subcircuit for sky130_fd_sc_hd__a21o_2 abstract view
.subckt sky130_fd_sc_hd__a21o_2 A1 A2 B1 VGND VNB VPB VPWR X
.ends

* Black-box entry subcircuit for sky130_fd_sc_hd__nand2b_2 abstract view
.subckt sky130_fd_sc_hd__nand2b_2 A_N B VGND VNB VPB VPWR Y
.ends

* Black-box entry subcircuit for sky130_fd_sc_hd__and4_2 abstract view
.subckt sky130_fd_sc_hd__and4_2 A B C D VGND VNB VPB VPWR X
.ends

* Black-box entry subcircuit for sky130_fd_sc_hd__mux2_1 abstract view
.subckt sky130_fd_sc_hd__mux2_1 A0 A1 S VGND VNB VPB VPWR X
.ends

* Black-box entry subcircuit for sky130_fd_sc_hd__o22a_2 abstract view
.subckt sky130_fd_sc_hd__o22a_2 A1 A2 B1 B2 VGND VNB VPB VPWR X
.ends

* Black-box entry subcircuit for sky130_fd_sc_hd__nor3_2 abstract view
.subckt sky130_fd_sc_hd__nor3_2 A B C VGND VNB VPB VPWR Y
.ends

* Black-box entry subcircuit for sky130_fd_sc_hd__inv_2 abstract view
.subckt sky130_fd_sc_hd__inv_2 A VGND VNB VPB VPWR Y
.ends

* Black-box entry subcircuit for sky130_fd_sc_hd__o21ai_2 abstract view
.subckt sky130_fd_sc_hd__o21ai_2 A1 A2 B1 VGND VNB VPB VPWR Y
.ends

* Black-box entry subcircuit for sky130_fd_sc_hd__o21a_2 abstract view
.subckt sky130_fd_sc_hd__o21a_2 A1 A2 B1 VGND VNB VPB VPWR X
.ends

* Black-box entry subcircuit for sky130_fd_sc_hd__xnor2_2 abstract view
.subckt sky130_fd_sc_hd__xnor2_2 A B VGND VNB VPB VPWR Y
.ends

* Black-box entry subcircuit for sky130_fd_sc_hd__buf_6 abstract view
.subckt sky130_fd_sc_hd__buf_6 A VGND VNB VPB VPWR X
.ends

* Black-box entry subcircuit for sky130_fd_sc_hd__buf_4 abstract view
.subckt sky130_fd_sc_hd__buf_4 A VGND VNB VPB VPWR X
.ends

* Black-box entry subcircuit for sky130_fd_sc_hd__nand2_2 abstract view
.subckt sky130_fd_sc_hd__nand2_2 A B VGND VNB VPB VPWR Y
.ends

* Black-box entry subcircuit for sky130_fd_sc_hd__o211a_2 abstract view
.subckt sky130_fd_sc_hd__o211a_2 A1 A2 B1 C1 VGND VNB VPB VPWR X
.ends

* Black-box entry subcircuit for sky130_fd_sc_hd__o32a_2 abstract view
.subckt sky130_fd_sc_hd__o32a_2 A1 A2 A3 B1 B2 VGND VNB VPB VPWR X
.ends

* Black-box entry subcircuit for sky130_fd_sc_hd__o31ai_2 abstract view
.subckt sky130_fd_sc_hd__o31ai_2 A1 A2 A3 B1 VGND VNB VPB VPWR Y
.ends

* Black-box entry subcircuit for sky130_fd_sc_hd__clkdlybuf4s25_1 abstract view
.subckt sky130_fd_sc_hd__clkdlybuf4s25_1 A VGND VNB VPB VPWR X
.ends

* Black-box entry subcircuit for sky130_fd_sc_hd__o2bb2a_2 abstract view
.subckt sky130_fd_sc_hd__o2bb2a_2 A1_N A2_N B1 B2 VGND VNB VPB VPWR X
.ends

* Black-box entry subcircuit for sky130_fd_sc_hd__clkbuf_16 abstract view
.subckt sky130_fd_sc_hd__clkbuf_16 A VGND VNB VPB VPWR X
.ends

* Black-box entry subcircuit for sky130_fd_sc_hd__a21oi_2 abstract view
.subckt sky130_fd_sc_hd__a21oi_2 A1 A2 B1 VGND VNB VPB VPWR Y
.ends

* Black-box entry subcircuit for sky130_fd_sc_hd__a21boi_2 abstract view
.subckt sky130_fd_sc_hd__a21boi_2 A1 A2 B1_N VGND VNB VPB VPWR Y
.ends

* Black-box entry subcircuit for sky130_fd_sc_hd__o31a_2 abstract view
.subckt sky130_fd_sc_hd__o31a_2 A1 A2 A3 B1 VGND VNB VPB VPWR X
.ends

* Black-box entry subcircuit for sky130_fd_sc_hd__a22oi_2 abstract view
.subckt sky130_fd_sc_hd__a22oi_2 A1 A2 B1 B2 VGND VNB VPB VPWR Y
.ends

* Black-box entry subcircuit for sky130_fd_sc_hd__a221oi_2 abstract view
.subckt sky130_fd_sc_hd__a221oi_2 A1 A2 B1 B2 C1 VGND VNB VPB VPWR Y
.ends

* Black-box entry subcircuit for sky130_fd_sc_hd__and2b_2 abstract view
.subckt sky130_fd_sc_hd__and2b_2 A_N B VGND VNB VPB VPWR X
.ends

* Black-box entry subcircuit for sky130_fd_sc_hd__buf_8 abstract view
.subckt sky130_fd_sc_hd__buf_8 A VGND VNB VPB VPWR X
.ends

* Black-box entry subcircuit for sky130_fd_sc_hd__or3b_2 abstract view
.subckt sky130_fd_sc_hd__or3b_2 A B C_N VGND VNB VPB VPWR X
.ends

* Black-box entry subcircuit for sky130_fd_sc_hd__o2111a_2 abstract view
.subckt sky130_fd_sc_hd__o2111a_2 A1 A2 B1 C1 D1 VGND VNB VPB VPWR X
.ends

* Black-box entry subcircuit for sky130_fd_sc_hd__a221o_2 abstract view
.subckt sky130_fd_sc_hd__a221o_2 A1 A2 B1 B2 C1 VGND VNB VPB VPWR X
.ends

* Black-box entry subcircuit for sky130_fd_sc_hd__o211ai_2 abstract view
.subckt sky130_fd_sc_hd__o211ai_2 A1 A2 B1 C1 VGND VNB VPB VPWR Y
.ends

* Black-box entry subcircuit for sky130_fd_sc_hd__or4b_2 abstract view
.subckt sky130_fd_sc_hd__or4b_2 A B C D_N VGND VNB VPB VPWR X
.ends

* Black-box entry subcircuit for sky130_fd_sc_hd__and3_2 abstract view
.subckt sky130_fd_sc_hd__and3_2 A B C VGND VNB VPB VPWR X
.ends

* Black-box entry subcircuit for sky130_fd_sc_hd__a311o_2 abstract view
.subckt sky130_fd_sc_hd__a311o_2 A1 A2 A3 B1 C1 VGND VNB VPB VPWR X
.ends

* Black-box entry subcircuit for sky130_fd_sc_hd__nand3_2 abstract view
.subckt sky130_fd_sc_hd__nand3_2 A B C VGND VNB VPB VPWR Y
.ends

* Black-box entry subcircuit for sky130_fd_sc_hd__clkbuf_4 abstract view
.subckt sky130_fd_sc_hd__clkbuf_4 A VGND VNB VPB VPWR X
.ends

* Black-box entry subcircuit for sky130_fd_sc_hd__xor2_2 abstract view
.subckt sky130_fd_sc_hd__xor2_2 A B VGND VNB VPB VPWR X
.ends

* Black-box entry subcircuit for sky130_fd_sc_hd__and4b_2 abstract view
.subckt sky130_fd_sc_hd__and4b_2 A_N B C D VGND VNB VPB VPWR X
.ends

* Black-box entry subcircuit for sky130_fd_sc_hd__o31ai_4 abstract view
.subckt sky130_fd_sc_hd__o31ai_4 A1 A2 A3 B1 VGND VNB VPB VPWR Y
.ends

* Black-box entry subcircuit for sky130_fd_sc_hd__nand4_2 abstract view
.subckt sky130_fd_sc_hd__nand4_2 A B C D VGND VNB VPB VPWR Y
.ends

* Black-box entry subcircuit for sky130_fd_sc_hd__and3b_2 abstract view
.subckt sky130_fd_sc_hd__and3b_2 A_N B C VGND VNB VPB VPWR X
.ends

* Black-box entry subcircuit for sky130_fd_sc_hd__inv_6 abstract view
.subckt sky130_fd_sc_hd__inv_6 A VGND VNB VPB VPWR Y
.ends

* Black-box entry subcircuit for sky130_fd_sc_hd__a32o_2 abstract view
.subckt sky130_fd_sc_hd__a32o_2 A1 A2 A3 B1 B2 VGND VNB VPB VPWR X
.ends

* Black-box entry subcircuit for sky130_fd_sc_hd__inv_12 abstract view
.subckt sky130_fd_sc_hd__inv_12 A VGND VNB VPB VPWR Y
.ends

* Black-box entry subcircuit for sky130_fd_sc_hd__o21ba_2 abstract view
.subckt sky130_fd_sc_hd__o21ba_2 A1 A2 B1_N VGND VNB VPB VPWR X
.ends

* Black-box entry subcircuit for sky130_fd_sc_hd__bufinv_16 abstract view
.subckt sky130_fd_sc_hd__bufinv_16 A VGND VNB VPB VPWR Y
.ends

* Black-box entry subcircuit for sky130_fd_sc_hd__clkinv_2 abstract view
.subckt sky130_fd_sc_hd__clkinv_2 A VGND VNB VPB VPWR Y
.ends

* Black-box entry subcircuit for sky130_fd_sc_hd__o221ai_2 abstract view
.subckt sky130_fd_sc_hd__o221ai_2 A1 A2 B1 B2 C1 VGND VNB VPB VPWR Y
.ends

* Black-box entry subcircuit for sky130_fd_sc_hd__or4bb_2 abstract view
.subckt sky130_fd_sc_hd__or4bb_2 A B C_N D_N VGND VNB VPB VPWR X
.ends

* Black-box entry subcircuit for sky130_fd_sc_hd__clkinv_4 abstract view
.subckt sky130_fd_sc_hd__clkinv_4 A VGND VNB VPB VPWR Y
.ends

* Black-box entry subcircuit for sky130_fd_sc_hd__a2bb2o_2 abstract view
.subckt sky130_fd_sc_hd__a2bb2o_2 A1_N A2_N B1 B2 VGND VNB VPB VPWR X
.ends

* Black-box entry subcircuit for sky130_fd_sc_hd__a21bo_2 abstract view
.subckt sky130_fd_sc_hd__a21bo_2 A1 A2 B1_N VGND VNB VPB VPWR X
.ends

* Black-box entry subcircuit for sky130_fd_sc_hd__and4bb_2 abstract view
.subckt sky130_fd_sc_hd__and4bb_2 A_N B_N C D VGND VNB VPB VPWR X
.ends

* Black-box entry subcircuit for sky130_fd_sc_hd__buf_12 abstract view
.subckt sky130_fd_sc_hd__buf_12 A VGND VNB VPB VPWR X
.ends

* Black-box entry subcircuit for sky130_fd_sc_hd__dfxtp_4 abstract view
.subckt sky130_fd_sc_hd__dfxtp_4 CLK D VGND VNB VPB VPWR Q
.ends

* Black-box entry subcircuit for sky130_fd_sc_hd__mux2_4 abstract view
.subckt sky130_fd_sc_hd__mux2_4 A0 A1 S VGND VNB VPB VPWR X
.ends

* Black-box entry subcircuit for sky130_fd_sc_hd__a31oi_2 abstract view
.subckt sky130_fd_sc_hd__a31oi_2 A1 A2 A3 B1 VGND VNB VPB VPWR Y
.ends

* Black-box entry subcircuit for sky130_fd_sc_hd__mux2_2 abstract view
.subckt sky130_fd_sc_hd__mux2_2 A0 A1 S VGND VNB VPB VPWR X
.ends

* Black-box entry subcircuit for sky130_fd_sc_hd__o2111ai_2 abstract view
.subckt sky130_fd_sc_hd__o2111ai_2 A1 A2 B1 C1 D1 VGND VNB VPB VPWR Y
.ends

* Black-box entry subcircuit for sky130_fd_sc_hd__clkbuf_2 abstract view
.subckt sky130_fd_sc_hd__clkbuf_2 A VGND VNB VPB VPWR X
.ends

* Black-box entry subcircuit for sky130_fd_sc_hd__nor4_2 abstract view
.subckt sky130_fd_sc_hd__nor4_2 A B C D VGND VNB VPB VPWR Y
.ends

* Black-box entry subcircuit for sky130_fd_sc_hd__nand2_8 abstract view
.subckt sky130_fd_sc_hd__nand2_8 A B VGND VNB VPB VPWR Y
.ends

* Black-box entry subcircuit for sky130_fd_sc_hd__a41o_2 abstract view
.subckt sky130_fd_sc_hd__a41o_2 A1 A2 A3 A4 B1 VGND VNB VPB VPWR X
.ends

* Black-box entry subcircuit for sky130_fd_sc_hd__and2_4 abstract view
.subckt sky130_fd_sc_hd__and2_4 A B VGND VNB VPB VPWR X
.ends

* Black-box entry subcircuit for sky130_fd_sc_hd__a2111o_2 abstract view
.subckt sky130_fd_sc_hd__a2111o_2 A1 A2 B1 C1 D1 VGND VNB VPB VPWR X
.ends

* Black-box entry subcircuit for sky130_fd_sc_hd__nand3b_2 abstract view
.subckt sky130_fd_sc_hd__nand3b_2 A_N B C VGND VNB VPB VPWR Y
.ends

* Black-box entry subcircuit for sky130_fd_sc_hd__nor4b_4 abstract view
.subckt sky130_fd_sc_hd__nor4b_4 A B C D_N VGND VNB VPB VPWR Y
.ends

.subckt VRAI_SYNC_CORE CLK DEVICES_LDH DEVICES_LDW DEVICES_STRH DEVICES_STRW EX_HALT
+ INSTR_ADDR[0] INSTR_ADDR[10] INSTR_ADDR[11] INSTR_ADDR[12] INSTR_ADDR[13] INSTR_ADDR[14]
+ INSTR_ADDR[15] INSTR_ADDR[1] INSTR_ADDR[2] INSTR_ADDR[3] INSTR_ADDR[4] INSTR_ADDR[5]
+ INSTR_ADDR[6] INSTR_ADDR[7] INSTR_ADDR[8] INSTR_ADDR[9] INSTR_STREAM[0] INSTR_STREAM[10]
+ INSTR_STREAM[11] INSTR_STREAM[12] INSTR_STREAM[13] INSTR_STREAM[14] INSTR_STREAM[15]
+ INSTR_STREAM[16] INSTR_STREAM[17] INSTR_STREAM[18] INSTR_STREAM[19] INSTR_STREAM[1]
+ INSTR_STREAM[20] INSTR_STREAM[21] INSTR_STREAM[22] INSTR_STREAM[23] INSTR_STREAM[24]
+ INSTR_STREAM[25] INSTR_STREAM[26] INSTR_STREAM[27] INSTR_STREAM[28] INSTR_STREAM[29]
+ INSTR_STREAM[2] INSTR_STREAM[30] INSTR_STREAM[31] INSTR_STREAM[3] INSTR_STREAM[4]
+ INSTR_STREAM[5] INSTR_STREAM[6] INSTR_STREAM[7] INSTR_STREAM[8] INSTR_STREAM[9]
+ INVALID_MEM MAIN_LDH MAIN_LDW MAIN_STRH MAIN_STRW MEM_ADDR[0] MEM_ADDR[10] MEM_ADDR[11]
+ MEM_ADDR[12] MEM_ADDR[13] MEM_ADDR[14] MEM_ADDR[15] MEM_ADDR[1] MEM_ADDR[2] MEM_ADDR[3]
+ MEM_ADDR[4] MEM_ADDR[5] MEM_ADDR[6] MEM_ADDR[7] MEM_ADDR[8] MEM_ADDR[9] MEM_LD_DATA[0]
+ MEM_LD_DATA[10] MEM_LD_DATA[11] MEM_LD_DATA[12] MEM_LD_DATA[13] MEM_LD_DATA[14]
+ MEM_LD_DATA[15] MEM_LD_DATA[1] MEM_LD_DATA[2] MEM_LD_DATA[3] MEM_LD_DATA[4] MEM_LD_DATA[5]
+ MEM_LD_DATA[6] MEM_LD_DATA[7] MEM_LD_DATA[8] MEM_LD_DATA[9] MEM_STR_DATA[0] MEM_STR_DATA[10]
+ MEM_STR_DATA[11] MEM_STR_DATA[12] MEM_STR_DATA[13] MEM_STR_DATA[14] MEM_STR_DATA[15]
+ MEM_STR_DATA[1] MEM_STR_DATA[2] MEM_STR_DATA[3] MEM_STR_DATA[4] MEM_STR_DATA[5]
+ MEM_STR_DATA[6] MEM_STR_DATA[7] MEM_STR_DATA[8] MEM_STR_DATA[9] RESET VGND VPWR
XFILLER_39_211 VGND VGND VPWR VPWR sky130_fd_sc_hd__decap_3
XFILLER_67_542 VGND VGND VPWR VPWR sky130_fd_sc_hd__decap_3
XFILLER_67_553 VGND VGND VPWR VPWR sky130_fd_sc_hd__decap_3
XFILLER_79_391 VGND VGND VPWR VPWR sky130_fd_sc_hd__fill_1
XFILLER_36_19 VGND VGND VPWR VPWR sky130_fd_sc_hd__decap_3
X_3155_ _2950_/X _3155_/A2 _3139_/Y _5062_/Q VGND VGND VPWR VPWR _5062_/D sky130_fd_sc_hd__a22o_2
XFILLER_27_428 VGND VGND VPWR VPWR sky130_fd_sc_hd__decap_3
X_3086_ _2905_/X _3100_/A2 _3084_/Y _5000_/Q VGND VGND VPWR VPWR _5000_/D sky130_fd_sc_hd__a22o_2
XFILLER_35_461 VGND VGND VPWR VPWR sky130_fd_sc_hd__decap_3
XFILLER_22_133 VGND VGND VPWR VPWR sky130_fd_sc_hd__decap_3
XFILLER_35_494 VGND VGND VPWR VPWR sky130_fd_sc_hd__decap_3
XFILLER_22_144 VGND VGND VPWR VPWR sky130_fd_sc_hd__decap_3
XFILLER_50_475 VGND VGND VPWR VPWR sky130_fd_sc_hd__fill_1
X_3988_ _4078_/B _3537_/X _4225_/A _3987_/Y VGND VGND VPWR VPWR _3988_/X sky130_fd_sc_hd__a211o_2
X_2939_ _5277_/Q _5254_/Q _5222_/Q _5276_/Q VGND VGND VPWR VPWR _2941_/A sky130_fd_sc_hd__a22o_2
XTAP_TAPCELL_ROW_20_389 VGND VPWR sky130_fd_sc_hd__tapvpwrvgnd_1
X_4609_ _4427_/Y _4437_/X _4608_/X _4666_/A VGND VGND VPWR VPWR _4609_/X sky130_fd_sc_hd__a22o_2
XFILLER_2_527 VGND VGND VPWR VPWR sky130_fd_sc_hd__decap_3
XFILLER_89_122 VGND VGND VPWR VPWR sky130_fd_sc_hd__fill_1
XFILLER_89_111 VGND VGND VPWR VPWR sky130_fd_sc_hd__fill_1
XFILLER_77_37 VGND VGND VPWR VPWR sky130_fd_sc_hd__fill_2
XFILLER_77_317 VGND VGND VPWR VPWR sky130_fd_sc_hd__decap_3
XFILLER_92_309 VGND VGND VPWR VPWR sky130_fd_sc_hd__decap_3
XFILLER_85_350 VGND VGND VPWR VPWR sky130_fd_sc_hd__decap_3
XFILLER_45_225 VGND VGND VPWR VPWR sky130_fd_sc_hd__fill_1
XFILLER_73_523 VGND VGND VPWR VPWR sky130_fd_sc_hd__decap_3
XTAP_TAPCELL_ROW_56_732 VGND VPWR sky130_fd_sc_hd__tapvpwrvgnd_1
XFILLER_85_383 VGND VGND VPWR VPWR sky130_fd_sc_hd__decap_3
XFILLER_85_372 VGND VGND VPWR VPWR sky130_fd_sc_hd__fill_2
XFILLER_73_556 VGND VGND VPWR VPWR sky130_fd_sc_hd__fill_2
XFILLER_93_69 VGND VGND VPWR VPWR sky130_fd_sc_hd__decap_3
XFILLER_26_472 VGND VGND VPWR VPWR sky130_fd_sc_hd__decap_3
XFILLER_26_74 VGND VGND VPWR VPWR sky130_fd_sc_hd__decap_3
XFILLER_60_217 VGND VGND VPWR VPWR sky130_fd_sc_hd__decap_3
XTAP_TAPCELL_ROW_28_467 VGND VPWR sky130_fd_sc_hd__tapvpwrvgnd_1
XFILLER_41_420 VGND VGND VPWR VPWR sky130_fd_sc_hd__decap_3
XFILLER_41_464 VGND VGND VPWR VPWR sky130_fd_sc_hd__decap_3
XFILLER_5_343 VGND VGND VPWR VPWR sky130_fd_sc_hd__decap_3
XFILLER_5_387 VGND VGND VPWR VPWR sky130_fd_sc_hd__decap_3
XFILLER_68_306 VGND VGND VPWR VPWR sky130_fd_sc_hd__fill_2
Xclkbuf_leaf_6_CLK clkload1/A VGND VGND VPWR VPWR _5216_/CLK sky130_fd_sc_hd__clkbuf_8
XFILLER_76_383 VGND VGND VPWR VPWR sky130_fd_sc_hd__decap_3
X_4960_ _4994_/CLK _4960_/D VGND VGND VPWR VPWR _4960_/Q sky130_fd_sc_hd__dfxtp_2
X_4891_ _5099_/CLK _4891_/D VGND VGND VPWR VPWR _4891_/Q sky130_fd_sc_hd__dfxtp_2
X_3911_ _3778_/D _3848_/Y _3849_/Y _3871_/X _3910_/Y VGND VGND VPWR VPWR _3911_/X
+ sky130_fd_sc_hd__o311a_2
XFILLER_32_475 VGND VGND VPWR VPWR sky130_fd_sc_hd__fill_1
X_3842_ _3842_/A _3842_/B VGND VGND VPWR VPWR _3844_/A sky130_fd_sc_hd__and2_2
X_3773_ _3773_/A _5182_/Q _5181_/Q _3884_/D VGND VGND VPWR VPWR _3778_/D sky130_fd_sc_hd__or4_2
X_2724_ _5064_/Q _5048_/Q _5032_/Q _5016_/Q _2851_/S0 _2854_/S1 VGND VGND VPWR VPWR
+ _2724_/X sky130_fd_sc_hd__mux4_2
XFILLER_8_181 VGND VGND VPWR VPWR sky130_fd_sc_hd__decap_3
X_2655_ _5164_/Q _4397_/B VGND VGND VPWR VPWR _2656_/B sky130_fd_sc_hd__or2_2
X_4325_ _4393_/C _4393_/D _4325_/C VGND VGND VPWR VPWR _4327_/B sky130_fd_sc_hd__or3_2
X_2586_ _2579_/X _2581_/X _2584_/X _2433_/Y VGND VGND VPWR VPWR _4357_/A sky130_fd_sc_hd__a22o_2
XFILLER_59_317 VGND VGND VPWR VPWR sky130_fd_sc_hd__decap_3
X_4256_ _4275_/B _4254_/X _4255_/Y _4692_/A VGND VGND VPWR VPWR _5224_/D sky130_fd_sc_hd__a211oi_2
XFILLER_86_147 VGND VGND VPWR VPWR sky130_fd_sc_hd__decap_3
XFILLER_55_501 VGND VGND VPWR VPWR sky130_fd_sc_hd__decap_3
X_4187_ _5221_/Q _4847_/B _4168_/X _4186_/X _3366_/A VGND VGND VPWR VPWR _5221_/D
+ sky130_fd_sc_hd__o221a_2
X_3207_ _2944_/X _3192_/Y _3193_/Y _5108_/Q VGND VGND VPWR VPWR _5108_/D sky130_fd_sc_hd__a22o_2
XFILLER_27_203 VGND VGND VPWR VPWR sky130_fd_sc_hd__decap_3
XFILLER_55_523 VGND VGND VPWR VPWR sky130_fd_sc_hd__decap_3
X_3138_ _3138_/A _3156_/B VGND VGND VPWR VPWR _3139_/B sky130_fd_sc_hd__nor2_4
XFILLER_55_556 VGND VGND VPWR VPWR sky130_fd_sc_hd__fill_2
X_3069_ _2908_/X _3065_/Y _3066_/Y _4985_/Q VGND VGND VPWR VPWR _4985_/D sky130_fd_sc_hd__a22o_2
XTAP_TAPCELL_ROW_53_702 VGND VPWR sky130_fd_sc_hd__tapvpwrvgnd_1
XFILLER_82_386 VGND VGND VPWR VPWR sky130_fd_sc_hd__decap_3
XTAP_TAPCELL_ROW_25_437 VGND VPWR sky130_fd_sc_hd__tapvpwrvgnd_1
XFILLER_23_442 VGND VGND VPWR VPWR sky130_fd_sc_hd__decap_3
XFILLER_50_250 VGND VGND VPWR VPWR sky130_fd_sc_hd__fill_2
XFILLER_50_272 VGND VGND VPWR VPWR sky130_fd_sc_hd__fill_2
XFILLER_50_294 VGND VGND VPWR VPWR sky130_fd_sc_hd__decap_3
XFILLER_6_107 VGND VGND VPWR VPWR sky130_fd_sc_hd__decap_3
XFILLER_12_65 VGND VGND VPWR VPWR sky130_fd_sc_hd__fill_1
XFILLER_88_25 VGND VGND VPWR VPWR sky130_fd_sc_hd__decap_3
XFILLER_88_58 VGND VGND VPWR VPWR sky130_fd_sc_hd__fill_2
XFILLER_77_147 VGND VGND VPWR VPWR sky130_fd_sc_hd__decap_3
XFILLER_77_125 VGND VGND VPWR VPWR sky130_fd_sc_hd__decap_3
XFILLER_77_169 VGND VGND VPWR VPWR sky130_fd_sc_hd__decap_3
XFILLER_33_228 VGND VGND VPWR VPWR sky130_fd_sc_hd__decap_3
XFILLER_53_50 VGND VGND VPWR VPWR sky130_fd_sc_hd__decap_3
XFILLER_14_475 VGND VGND VPWR VPWR sky130_fd_sc_hd__fill_1
X_2440_ _3773_/A _4069_/A VGND VGND VPWR VPWR _3562_/A sky130_fd_sc_hd__nor2_2
X_4110_ _3776_/B _3827_/X _3832_/X _4686_/B1 VGND VGND VPWR VPWR _4110_/X sky130_fd_sc_hd__a31o_2
X_5090_ clkload7/A _5090_/D VGND VGND VPWR VPWR _5090_/Q sky130_fd_sc_hd__dfxtp_2
XFILLER_78_91 VGND VGND VPWR VPWR sky130_fd_sc_hd__decap_3
XFILLER_56_309 VGND VGND VPWR VPWR sky130_fd_sc_hd__decap_3
X_4041_ _4062_/A _3804_/B _4261_/C VGND VGND VPWR VPWR _4041_/X sky130_fd_sc_hd__a21o_2
XFILLER_49_361 VGND VGND VPWR VPWR sky130_fd_sc_hd__decap_3
XTAP_TAPCELL_ROW_67_838 VGND VPWR sky130_fd_sc_hd__tapvpwrvgnd_1
XFILLER_37_556 VGND VGND VPWR VPWR sky130_fd_sc_hd__fill_2
X_4943_ clkload4/A _4943_/D VGND VGND VPWR VPWR _4943_/Q sky130_fd_sc_hd__dfxtp_2
XTAP_TAPCELL_ROW_22_407 VGND VPWR sky130_fd_sc_hd__tapvpwrvgnd_1
X_4874_ _5099_/CLK _4874_/D VGND VGND VPWR VPWR _4874_/Q sky130_fd_sc_hd__dfxtp_2
XFILLER_20_434 VGND VGND VPWR VPWR sky130_fd_sc_hd__fill_2
X_3825_ _5163_/Q _3825_/B VGND VGND VPWR VPWR _3825_/Y sky130_fd_sc_hd__nand2b_2
XFILLER_20_489 VGND VGND VPWR VPWR sky130_fd_sc_hd__decap_3
X_3756_ _4310_/A _4103_/B VGND VGND VPWR VPWR _4051_/A sky130_fd_sc_hd__or2_2
X_2707_ _2894_/A _4168_/A _2707_/C _2707_/D VGND VGND VPWR VPWR _2707_/X sky130_fd_sc_hd__and4_2
XTAP_TAPCELL_ROW_30_484 VGND VPWR sky130_fd_sc_hd__tapvpwrvgnd_1
X_3687_ _3834_/B _3788_/B VGND VGND VPWR VPWR _4619_/S sky130_fd_sc_hd__and2_2
X_2638_ _2636_/X _2637_/X _2677_/S VGND VGND VPWR VPWR _2638_/X sky130_fd_sc_hd__mux2_1
X_2569_ _5066_/Q _5050_/Q _5034_/Q _5018_/Q _2676_/S0 _2676_/S1 VGND VGND VPWR VPWR
+ _2570_/B sky130_fd_sc_hd__mux4_2
X_4308_ _4307_/Y _4305_/Y _4515_/B VGND VGND VPWR VPWR _4308_/X sky130_fd_sc_hd__mux2_1
XFILLER_59_147 VGND VGND VPWR VPWR sky130_fd_sc_hd__decap_3
XFILLER_59_169 VGND VGND VPWR VPWR sky130_fd_sc_hd__decap_3
X_4239_ _4239_/A _4239_/B VGND VGND VPWR VPWR _4261_/D sky130_fd_sc_hd__nor2_2
XFILLER_28_512 VGND VGND VPWR VPWR sky130_fd_sc_hd__decap_3
XFILLER_74_139 VGND VGND VPWR VPWR sky130_fd_sc_hd__fill_1
XFILLER_87_489 VGND VGND VPWR VPWR sky130_fd_sc_hd__decap_3
XFILLER_28_545 VGND VGND VPWR VPWR sky130_fd_sc_hd__decap_3
XFILLER_74_27 VGND VGND VPWR VPWR sky130_fd_sc_hd__fill_1
XFILLER_74_38 VGND VGND VPWR VPWR sky130_fd_sc_hd__decap_3
XFILLER_43_515 VGND VGND VPWR VPWR sky130_fd_sc_hd__decap_3
XFILLER_55_364 VGND VGND VPWR VPWR sky130_fd_sc_hd__decap_3
XFILLER_70_312 VGND VGND VPWR VPWR sky130_fd_sc_hd__decap_3
XTAP_TAPCELL_ROW_38_562 VGND VPWR sky130_fd_sc_hd__tapvpwrvgnd_1
XFILLER_82_150 VGND VGND VPWR VPWR sky130_fd_sc_hd__decap_3
XFILLER_15_228 VGND VGND VPWR VPWR sky130_fd_sc_hd__decap_3
XFILLER_43_548 VGND VGND VPWR VPWR sky130_fd_sc_hd__fill_2
XFILLER_82_194 VGND VGND VPWR VPWR sky130_fd_sc_hd__fill_2
XFILLER_70_378 VGND VGND VPWR VPWR sky130_fd_sc_hd__decap_3
XFILLER_90_26 VGND VGND VPWR VPWR sky130_fd_sc_hd__fill_2
XFILLER_23_272 VGND VGND VPWR VPWR sky130_fd_sc_hd__decap_3
XFILLER_11_445 VGND VGND VPWR VPWR sky130_fd_sc_hd__decap_3
XFILLER_11_478 VGND VGND VPWR VPWR sky130_fd_sc_hd__decap_3
XFILLER_78_412 VGND VGND VPWR VPWR sky130_fd_sc_hd__decap_3
XFILLER_78_445 VGND VGND VPWR VPWR sky130_fd_sc_hd__decap_3
XFILLER_38_309 VGND VGND VPWR VPWR sky130_fd_sc_hd__decap_3
XFILLER_19_523 VGND VGND VPWR VPWR sky130_fd_sc_hd__decap_3
XFILLER_48_72 VGND VGND VPWR VPWR sky130_fd_sc_hd__decap_3
XFILLER_0_24 VGND VGND VPWR VPWR sky130_fd_sc_hd__decap_3
XFILLER_0_35 VGND VGND VPWR VPWR sky130_fd_sc_hd__decap_3
XFILLER_19_556 VGND VGND VPWR VPWR sky130_fd_sc_hd__fill_2
XTAP_TAPCELL_ROW_64_808 VGND VPWR sky130_fd_sc_hd__tapvpwrvgnd_1
XFILLER_0_57 VGND VGND VPWR VPWR sky130_fd_sc_hd__decap_3
XFILLER_34_504 VGND VGND VPWR VPWR sky130_fd_sc_hd__decap_3
XFILLER_34_515 VGND VGND VPWR VPWR sky130_fd_sc_hd__decap_3
XFILLER_73_150 VGND VGND VPWR VPWR sky130_fd_sc_hd__decap_3
XFILLER_46_386 VGND VGND VPWR VPWR sky130_fd_sc_hd__decap_3
XFILLER_61_312 VGND VGND VPWR VPWR sky130_fd_sc_hd__decap_3
XFILLER_64_60 VGND VGND VPWR VPWR sky130_fd_sc_hd__decap_3
XFILLER_61_356 VGND VGND VPWR VPWR sky130_fd_sc_hd__decap_3
XTAP_TAPCELL_ROW_72_885 VGND VPWR sky130_fd_sc_hd__tapvpwrvgnd_1
XFILLER_9_33 VGND VGND VPWR VPWR sky130_fd_sc_hd__fill_1
X_4590_ _4191_/A _2656_/B _3714_/A _3363_/A VGND VGND VPWR VPWR _4594_/A sky130_fd_sc_hd__o22a_2
X_3610_ _4955_/Q _4939_/Q _4923_/Q _4907_/Q _3732_/S0 _3732_/S1 VGND VGND VPWR VPWR
+ _3610_/X sky130_fd_sc_hd__mux4_2
XFILLER_80_81 VGND VGND VPWR VPWR sky130_fd_sc_hd__decap_3
X_3541_ _3539_/Y _3917_/B _3919_/S VGND VGND VPWR VPWR _3989_/B sky130_fd_sc_hd__mux2_1
XFILLER_6_460 VGND VGND VPWR VPWR sky130_fd_sc_hd__decap_3
X_3472_ _3472_/A _3472_/B _3472_/C VGND VGND VPWR VPWR _3472_/Y sky130_fd_sc_hd__nor3_2
X_5211_ _5233_/CLK _5211_/D VGND VGND VPWR VPWR _5211_/Q sky130_fd_sc_hd__dfxtp_2
X_2423_ _5206_/Q VGND VGND VPWR VPWR _2423_/Y sky130_fd_sc_hd__inv_2
XFILLER_88_209 VGND VGND VPWR VPWR sky130_fd_sc_hd__decap_3
X_5142_ _5286_/CLK _5142_/D VGND VGND VPWR VPWR _5142_/Q sky130_fd_sc_hd__dfxtp_2
XFILLER_56_128 VGND VGND VPWR VPWR sky130_fd_sc_hd__decap_3
XFILLER_69_489 VGND VGND VPWR VPWR sky130_fd_sc_hd__fill_2
X_5073_ _5110_/CLK _5073_/D VGND VGND VPWR VPWR _5073_/Q sky130_fd_sc_hd__dfxtp_2
XFILLER_84_437 VGND VGND VPWR VPWR sky130_fd_sc_hd__decap_3
XFILLER_37_320 VGND VGND VPWR VPWR sky130_fd_sc_hd__decap_3
XFILLER_37_342 VGND VGND VPWR VPWR sky130_fd_sc_hd__decap_3
XFILLER_56_139 VGND VGND VPWR VPWR sky130_fd_sc_hd__fill_1
X_4024_ _3828_/Y _3986_/Y _4015_/B VGND VGND VPWR VPWR _4024_/Y sky130_fd_sc_hd__o21ai_2
XFILLER_84_448 VGND VGND VPWR VPWR sky130_fd_sc_hd__decap_3
XFILLER_64_150 VGND VGND VPWR VPWR sky130_fd_sc_hd__decap_3
XFILLER_25_526 VGND VGND VPWR VPWR sky130_fd_sc_hd__fill_2
XFILLER_52_312 VGND VGND VPWR VPWR sky130_fd_sc_hd__decap_3
XFILLER_40_518 VGND VGND VPWR VPWR sky130_fd_sc_hd__decap_3
XTAP_TAPCELL_ROW_35_532 VGND VPWR sky130_fd_sc_hd__tapvpwrvgnd_1
X_4926_ _5118_/CLK _4926_/D VGND VGND VPWR VPWR _4926_/Q sky130_fd_sc_hd__dfxtp_2
X_4857_ _5279_/Q _4856_/X _3366_/A VGND VGND VPWR VPWR _4857_/X sky130_fd_sc_hd__o21a_2
XFILLER_20_253 VGND VGND VPWR VPWR sky130_fd_sc_hd__decap_3
XFILLER_60_29 VGND VGND VPWR VPWR sky130_fd_sc_hd__fill_1
X_3808_ _4378_/B _3808_/B VGND VGND VPWR VPWR _4261_/B sky130_fd_sc_hd__nor2_2
X_4788_ _4815_/A _4788_/B VGND VGND VPWR VPWR _4788_/Y sky130_fd_sc_hd__xnor2_2
XFILLER_4_408 VGND VGND VPWR VPWR sky130_fd_sc_hd__decap_3
X_3739_ _3829_/B _3739_/B VGND VGND VPWR VPWR _3740_/B sky130_fd_sc_hd__and2_2
XFILLER_75_404 VGND VGND VPWR VPWR sky130_fd_sc_hd__decap_3
XTAP_TAPCELL_ROW_7_268 VGND VPWR sky130_fd_sc_hd__tapvpwrvgnd_1
XFILLER_85_15 VGND VGND VPWR VPWR sky130_fd_sc_hd__decap_3
XFILLER_87_264 VGND VGND VPWR VPWR sky130_fd_sc_hd__decap_3
XFILLER_85_48 VGND VGND VPWR VPWR sky130_fd_sc_hd__fill_1
XFILLER_18_53 VGND VGND VPWR VPWR sky130_fd_sc_hd__decap_3
XFILLER_75_459 VGND VGND VPWR VPWR sky130_fd_sc_hd__decap_3
XFILLER_55_161 VGND VGND VPWR VPWR sky130_fd_sc_hd__decap_3
XFILLER_28_386 VGND VGND VPWR VPWR sky130_fd_sc_hd__decap_3
XFILLER_43_323 VGND VGND VPWR VPWR sky130_fd_sc_hd__decap_3
XFILLER_43_367 VGND VGND VPWR VPWR sky130_fd_sc_hd__decap_3
XFILLER_70_153 VGND VGND VPWR VPWR sky130_fd_sc_hd__decap_3
XFILLER_11_253 VGND VGND VPWR VPWR sky130_fd_sc_hd__decap_3
XFILLER_7_213 VGND VGND VPWR VPWR sky130_fd_sc_hd__decap_3
XFILLER_7_202 VGND VGND VPWR VPWR sky130_fd_sc_hd__fill_2
Xwire133 _2973_/Y VGND VGND VPWR VPWR _2974_/B sky130_fd_sc_hd__buf_6
Xwire144 _4350_/B VGND VGND VPWR VPWR _3834_/B sky130_fd_sc_hd__buf_4
XFILLER_7_257 VGND VGND VPWR VPWR sky130_fd_sc_hd__decap_3
XFILLER_3_452 VGND VGND VPWR VPWR sky130_fd_sc_hd__fill_2
XFILLER_59_93 VGND VGND VPWR VPWR sky130_fd_sc_hd__decap_3
XFILLER_78_253 VGND VGND VPWR VPWR sky130_fd_sc_hd__decap_3
XFILLER_78_231 VGND VGND VPWR VPWR sky130_fd_sc_hd__decap_3
XFILLER_66_415 VGND VGND VPWR VPWR sky130_fd_sc_hd__decap_3
XTAP_TAPCELL_ROW_77_933 VGND VPWR sky130_fd_sc_hd__tapvpwrvgnd_1
XFILLER_15_6 VGND VGND VPWR VPWR sky130_fd_sc_hd__decap_3
XFILLER_19_331 VGND VGND VPWR VPWR sky130_fd_sc_hd__decap_3
XFILLER_38_139 VGND VGND VPWR VPWR sky130_fd_sc_hd__fill_1
XFILLER_66_459 VGND VGND VPWR VPWR sky130_fd_sc_hd__fill_1
XTAP_TAPCELL_ROW_49_668 VGND VPWR sky130_fd_sc_hd__tapvpwrvgnd_1
XFILLER_93_278 VGND VGND VPWR VPWR sky130_fd_sc_hd__fill_2
XFILLER_34_312 VGND VGND VPWR VPWR sky130_fd_sc_hd__decap_3
XFILLER_74_470 VGND VGND VPWR VPWR sky130_fd_sc_hd__decap_3
XFILLER_74_492 VGND VGND VPWR VPWR sky130_fd_sc_hd__decap_3
XFILLER_75_92 VGND VGND VPWR VPWR sky130_fd_sc_hd__decap_3
XFILLER_61_153 VGND VGND VPWR VPWR sky130_fd_sc_hd__decap_3
XFILLER_34_378 VGND VGND VPWR VPWR sky130_fd_sc_hd__decap_3
XFILLER_61_175 VGND VGND VPWR VPWR sky130_fd_sc_hd__decap_3
X_2972_ _5191_/Q _5190_/Q VGND VGND VPWR VPWR _3174_/B sky130_fd_sc_hd__nand2_2
XTAP_TAPCELL_ROW_32_502 VGND VPWR sky130_fd_sc_hd__tapvpwrvgnd_1
X_4711_ _5250_/Q _4725_/B VGND VGND VPWR VPWR _4711_/X sky130_fd_sc_hd__or2_2
XFILLER_91_80 VGND VGND VPWR VPWR sky130_fd_sc_hd__fill_1
X_4642_ _4666_/A _4536_/X _4641_/X _4437_/B VGND VGND VPWR VPWR _4642_/X sky130_fd_sc_hd__o22a_2
X_4573_ _4312_/Y _4571_/X _4572_/X _4312_/A VGND VGND VPWR VPWR _4573_/X sky130_fd_sc_hd__a22o_2
X_3524_ _4286_/A _4732_/A _4422_/S VGND VGND VPWR VPWR _3969_/S sky130_fd_sc_hd__mux2_1
XFILLER_6_290 VGND VGND VPWR VPWR sky130_fd_sc_hd__decap_3
X_3455_ _3437_/Y _3440_/B _3446_/B _3438_/A VGND VGND VPWR VPWR _3457_/C sky130_fd_sc_hd__o211a_2
X_3386_ _3458_/A _3384_/X _3385_/Y _4275_/B _2425_/Y VGND VGND VPWR VPWR _3387_/B
+ sky130_fd_sc_hd__o32a_2
XFILLER_57_426 VGND VGND VPWR VPWR sky130_fd_sc_hd__decap_3
XFILLER_69_275 VGND VGND VPWR VPWR sky130_fd_sc_hd__decap_3
X_5125_ clkload6/A _5125_/D VGND VGND VPWR VPWR _5125_/Q sky130_fd_sc_hd__dfxtp_2
XTAP_TAPCELL_ROW_4_238 VGND VPWR sky130_fd_sc_hd__tapvpwrvgnd_1
X_5056_ _5109_/CLK _5056_/D VGND VGND VPWR VPWR _5056_/Q sky130_fd_sc_hd__dfxtp_2
X_4007_ _4686_/B1 _3985_/X _3986_/Y _4006_/X VGND VGND VPWR VPWR _4007_/Y sky130_fd_sc_hd__o31ai_2
XFILLER_25_323 VGND VGND VPWR VPWR sky130_fd_sc_hd__decap_3
XFILLER_37_172 VGND VGND VPWR VPWR sky130_fd_sc_hd__decap_3
XFILLER_65_470 VGND VGND VPWR VPWR sky130_fd_sc_hd__decap_3
XFILLER_25_367 VGND VGND VPWR VPWR sky130_fd_sc_hd__decap_3
XFILLER_13_518 VGND VGND VPWR VPWR sky130_fd_sc_hd__decap_3
XFILLER_25_378 VGND VGND VPWR VPWR sky130_fd_sc_hd__decap_3
XFILLER_80_495 VGND VGND VPWR VPWR sky130_fd_sc_hd__decap_3
XFILLER_52_197 VGND VGND VPWR VPWR sky130_fd_sc_hd__decap_3
XFILLER_71_39 VGND VGND VPWR VPWR sky130_fd_sc_hd__decap_3
X_4909_ _5010_/CLK _4909_/D VGND VGND VPWR VPWR _4909_/Q sky130_fd_sc_hd__dfxtp_2
XFILLER_20_21 VGND VGND VPWR VPWR sky130_fd_sc_hd__decap_3
XFILLER_20_32 VGND VGND VPWR VPWR sky130_fd_sc_hd__decap_3
XFILLER_4_249 VGND VGND VPWR VPWR sky130_fd_sc_hd__decap_3
XFILLER_0_411 VGND VGND VPWR VPWR sky130_fd_sc_hd__decap_3
XFILLER_0_488 VGND VGND VPWR VPWR sky130_fd_sc_hd__decap_3
XFILLER_75_256 VGND VGND VPWR VPWR sky130_fd_sc_hd__decap_3
XTAP_TAPCELL_ROW_74_903 VGND VPWR sky130_fd_sc_hd__tapvpwrvgnd_1
XTAP_TAPCELL_ROW_46_638 VGND VPWR sky130_fd_sc_hd__tapvpwrvgnd_1
XFILLER_16_345 VGND VGND VPWR VPWR sky130_fd_sc_hd__decap_3
XFILLER_31_304 VGND VGND VPWR VPWR sky130_fd_sc_hd__decap_3
XTAP_TAPCELL_ROW_82_980 VGND VPWR sky130_fd_sc_hd__tapvpwrvgnd_1
XFILLER_31_337 VGND VGND VPWR VPWR sky130_fd_sc_hd__decap_3
XFILLER_84_9 VGND VGND VPWR VPWR sky130_fd_sc_hd__decap_3
XFILLER_61_72 VGND VGND VPWR VPWR sky130_fd_sc_hd__fill_1
XFILLER_8_555 VGND VGND VPWR VPWR sky130_fd_sc_hd__decap_3
XFILLER_8_533 VGND VGND VPWR VPWR sky130_fd_sc_hd__decap_3
XFILLER_6_78 VGND VGND VPWR VPWR sky130_fd_sc_hd__decap_3
X_3240_ _5168_/Q _4868_/A2 _3230_/Y _3239_/X VGND VGND VPWR VPWR _5131_/D sky130_fd_sc_hd__o22a_2
X_3171_ _2944_/X _3157_/B _3157_/Y _5076_/Q VGND VGND VPWR VPWR _5076_/D sky130_fd_sc_hd__a22o_2
XFILLER_13_3 VGND VGND VPWR VPWR sky130_fd_sc_hd__decap_3
XFILLER_66_223 VGND VGND VPWR VPWR sky130_fd_sc_hd__decap_3
XFILLER_86_80 VGND VGND VPWR VPWR sky130_fd_sc_hd__decap_3
XTAP_TAPCELL_ROW_1_208 VGND VPWR sky130_fd_sc_hd__tapvpwrvgnd_1
XFILLER_19_172 VGND VGND VPWR VPWR sky130_fd_sc_hd__decap_3
XFILLER_47_470 VGND VGND VPWR VPWR sky130_fd_sc_hd__decap_3
XFILLER_62_440 VGND VGND VPWR VPWR sky130_fd_sc_hd__decap_3
XFILLER_81_248 VGND VGND VPWR VPWR sky130_fd_sc_hd__decap_3
XFILLER_22_315 VGND VGND VPWR VPWR sky130_fd_sc_hd__decap_3
XFILLER_62_473 VGND VGND VPWR VPWR sky130_fd_sc_hd__decap_3
XFILLER_62_484 VGND VGND VPWR VPWR sky130_fd_sc_hd__decap_3
XTAP_TAPCELL_ROW_17_362 VGND VPWR sky130_fd_sc_hd__tapvpwrvgnd_1
XFILLER_34_197 VGND VGND VPWR VPWR sky130_fd_sc_hd__decap_3
X_2955_ _2897_/X _2970_/A2 _2954_/Y _4887_/Q VGND VGND VPWR VPWR _4887_/D sky130_fd_sc_hd__a22o_2
XFILLER_30_370 VGND VGND VPWR VPWR sky130_fd_sc_hd__decap_3
XFILLER_30_392 VGND VGND VPWR VPWR sky130_fd_sc_hd__decap_3
X_2886_ _4174_/B _2886_/B VGND VGND VPWR VPWR _4171_/B sky130_fd_sc_hd__xnor2_2
X_4625_ _5237_/Q _4854_/B VGND VGND VPWR VPWR _4625_/Y sky130_fd_sc_hd__nand2_2
X_4556_ _3600_/A _3866_/B _3549_/Y VGND VGND VPWR VPWR _4556_/Y sky130_fd_sc_hd__o21ai_2
X_3507_ _4889_/Q _4873_/Q _5097_/Q _5081_/Q _3706_/S0 _3706_/S1 VGND VGND VPWR VPWR
+ _3507_/X sky130_fd_sc_hd__mux4_2
X_4487_ _4487_/A _4487_/B VGND VGND VPWR VPWR _4487_/Y sky130_fd_sc_hd__nor2_2
XFILLER_89_315 VGND VGND VPWR VPWR sky130_fd_sc_hd__decap_3
X_3438_ _3438_/A _3438_/B VGND VGND VPWR VPWR _3440_/A sky130_fd_sc_hd__nand2_2
X_3369_ _5183_/Q _3369_/B VGND VGND VPWR VPWR _3369_/Y sky130_fd_sc_hd__xnor2_2
XFILLER_57_223 VGND VGND VPWR VPWR sky130_fd_sc_hd__fill_1
XFILLER_57_245 VGND VGND VPWR VPWR sky130_fd_sc_hd__decap_3
X_5108_ clkload6/A _5108_/D VGND VGND VPWR VPWR _5108_/Q sky130_fd_sc_hd__dfxtp_2
XFILLER_85_554 VGND VGND VPWR VPWR sky130_fd_sc_hd__decap_3
XFILLER_85_521 VGND VGND VPWR VPWR sky130_fd_sc_hd__decap_3
XFILLER_72_204 VGND VGND VPWR VPWR sky130_fd_sc_hd__decap_3
XFILLER_38_492 VGND VGND VPWR VPWR sky130_fd_sc_hd__fill_1
XFILLER_45_429 VGND VGND VPWR VPWR sky130_fd_sc_hd__decap_3
XFILLER_72_215 VGND VGND VPWR VPWR sky130_fd_sc_hd__decap_3
X_5039_ _5103_/CLK _5039_/D VGND VGND VPWR VPWR _5039_/Q sky130_fd_sc_hd__dfxtp_2
XTAP_TAPCELL_ROW_43_608 VGND VPWR sky130_fd_sc_hd__tapvpwrvgnd_1
XFILLER_13_304 VGND VGND VPWR VPWR sky130_fd_sc_hd__decap_3
XFILLER_15_21 VGND VGND VPWR VPWR sky130_fd_sc_hd__decap_3
XFILLER_25_175 VGND VGND VPWR VPWR sky130_fd_sc_hd__decap_3
XFILLER_82_49 VGND VGND VPWR VPWR sky130_fd_sc_hd__decap_3
XFILLER_80_270 VGND VGND VPWR VPWR sky130_fd_sc_hd__decap_3
XFILLER_13_337 VGND VGND VPWR VPWR sky130_fd_sc_hd__decap_3
XFILLER_15_87 VGND VGND VPWR VPWR sky130_fd_sc_hd__decap_3
XFILLER_21_370 VGND VGND VPWR VPWR sky130_fd_sc_hd__fill_2
XFILLER_21_381 VGND VGND VPWR VPWR sky130_fd_sc_hd__decap_3
XTAP_TAPCELL_ROW_51_685 VGND VPWR sky130_fd_sc_hd__tapvpwrvgnd_1
XFILLER_31_75 VGND VGND VPWR VPWR sky130_fd_sc_hd__fill_2
XFILLER_5_536 VGND VGND VPWR VPWR sky130_fd_sc_hd__decap_3
Xoutput53 _2705_/X VGND VGND VPWR VPWR DEVICES_STRW sky130_fd_sc_hd__clkdlybuf4s25_1
Xoutput64 _5140_/Q VGND VGND VPWR VPWR INSTR_ADDR[3] sky130_fd_sc_hd__clkdlybuf4s25_1
Xoutput75 _2699_/X VGND VGND VPWR VPWR MAIN_STRW sky130_fd_sc_hd__clkdlybuf4s25_1
XTAP_TAPCELL_ROW_91_1069 VGND VPWR sky130_fd_sc_hd__tapvpwrvgnd_1
Xoutput86 _2869_/Y VGND VGND VPWR VPWR MEM_ADDR[4] sky130_fd_sc_hd__clkdlybuf4s25_1
Xoutput97 _2848_/X VGND VGND VPWR VPWR MEM_STR_DATA[14] sky130_fd_sc_hd__clkdlybuf4s25_1
XFILLER_0_274 VGND VGND VPWR VPWR sky130_fd_sc_hd__decap_3
XFILLER_76_521 VGND VGND VPWR VPWR sky130_fd_sc_hd__fill_1
XFILLER_48_256 VGND VGND VPWR VPWR sky130_fd_sc_hd__fill_2
XTAP_TAPCELL_ROW_59_763 VGND VPWR sky130_fd_sc_hd__tapvpwrvgnd_1
XFILLER_29_492 VGND VGND VPWR VPWR sky130_fd_sc_hd__decap_3
XFILLER_16_175 VGND VGND VPWR VPWR sky130_fd_sc_hd__decap_3
XFILLER_31_101 VGND VGND VPWR VPWR sky130_fd_sc_hd__decap_3
XFILLER_44_451 VGND VGND VPWR VPWR sky130_fd_sc_hd__decap_3
XFILLER_44_473 VGND VGND VPWR VPWR sky130_fd_sc_hd__decap_3
XFILLER_16_197 VGND VGND VPWR VPWR sky130_fd_sc_hd__decap_3
XFILLER_44_495 VGND VGND VPWR VPWR sky130_fd_sc_hd__decap_3
XFILLER_71_270 VGND VGND VPWR VPWR sky130_fd_sc_hd__decap_3
XFILLER_71_281 VGND VGND VPWR VPWR sky130_fd_sc_hd__decap_3
XFILLER_31_156 VGND VGND VPWR VPWR sky130_fd_sc_hd__decap_3
XTAP_TAPCELL_ROW_14_332 VGND VPWR sky130_fd_sc_hd__tapvpwrvgnd_1
XFILLER_31_178 VGND VGND VPWR VPWR sky130_fd_sc_hd__decap_3
X_2740_ _2857_/A _4738_/B VGND VGND VPWR VPWR _2740_/X sky130_fd_sc_hd__and2_2
XFILLER_82_6 VGND VGND VPWR VPWR sky130_fd_sc_hd__decap_3
X_2671_ _4897_/Q _4881_/Q _5105_/Q _5089_/Q _2672_/S0 _2672_/S1 VGND VGND VPWR VPWR
+ _2671_/X sky130_fd_sc_hd__mux4_2
X_4410_ _4410_/A _4410_/B VGND VGND VPWR VPWR _4411_/C sky130_fd_sc_hd__nor2_2
X_4341_ _4236_/A _2860_/B _3778_/D _2862_/B VGND VGND VPWR VPWR _4341_/X sky130_fd_sc_hd__o2bb2a_2
X_4272_ _3515_/X _4225_/A _4078_/C _4268_/X _4271_/Y VGND VGND VPWR VPWR _4272_/X
+ sky130_fd_sc_hd__o311a_2
X_3223_ _2937_/X _3227_/A2 _3211_/Y _5122_/Q VGND VGND VPWR VPWR _5122_/D sky130_fd_sc_hd__a22o_2
XFILLER_86_318 VGND VGND VPWR VPWR sky130_fd_sc_hd__decap_3
XFILLER_86_307 VGND VGND VPWR VPWR sky130_fd_sc_hd__fill_1
XFILLER_79_370 VGND VGND VPWR VPWR sky130_fd_sc_hd__decap_3
XFILLER_39_245 VGND VGND VPWR VPWR sky130_fd_sc_hd__decap_3
X_3154_ _2947_/X _3139_/B _3139_/Y _5061_/Q VGND VGND VPWR VPWR _5061_/D sky130_fd_sc_hd__a22o_2
XFILLER_39_278 VGND VGND VPWR VPWR sky130_fd_sc_hd__fill_2
X_3085_ _2897_/X _3100_/A2 _3084_/Y _4999_/Q VGND VGND VPWR VPWR _4999_/D sky130_fd_sc_hd__a22o_2
XFILLER_82_557 VGND VGND VPWR VPWR sky130_fd_sc_hd__fill_1
XFILLER_22_112 VGND VGND VPWR VPWR sky130_fd_sc_hd__decap_3
XFILLER_50_410 VGND VGND VPWR VPWR sky130_fd_sc_hd__decap_3
XFILLER_50_421 VGND VGND VPWR VPWR sky130_fd_sc_hd__fill_2
XFILLER_62_281 VGND VGND VPWR VPWR sky130_fd_sc_hd__decap_3
XFILLER_22_156 VGND VGND VPWR VPWR sky130_fd_sc_hd__decap_3
X_3987_ _4078_/B _3987_/B VGND VGND VPWR VPWR _3987_/Y sky130_fd_sc_hd__nor2_2
Xclkbuf_2_2__f_CLK clkbuf_0_CLK/X VGND VGND VPWR VPWR clkload1/A sky130_fd_sc_hd__clkbuf_16
X_2938_ _4882_/Q _2902_/Y _2937_/X _2951_/B2 VGND VGND VPWR VPWR _4882_/D sky130_fd_sc_hd__a22o_2
X_2869_ _2873_/A _2869_/B VGND VGND VPWR VPWR _2869_/Y sky130_fd_sc_hd__nor2_2
XFILLER_2_506 VGND VGND VPWR VPWR sky130_fd_sc_hd__decap_3
X_4608_ _4607_/X _4544_/X _4682_/S VGND VGND VPWR VPWR _4608_/X sky130_fd_sc_hd__mux2_1
XFILLER_2_539 VGND VGND VPWR VPWR sky130_fd_sc_hd__decap_3
X_4539_ _4521_/Y _4538_/X _4692_/A VGND VGND VPWR VPWR _5230_/D sky130_fd_sc_hd__a21oi_2
XFILLER_77_16 VGND VGND VPWR VPWR sky130_fd_sc_hd__decap_3
XFILLER_89_189 VGND VGND VPWR VPWR sky130_fd_sc_hd__decap_3
XFILLER_89_178 VGND VGND VPWR VPWR sky130_fd_sc_hd__decap_3
XFILLER_77_329 VGND VGND VPWR VPWR sky130_fd_sc_hd__decap_3
XFILLER_18_418 VGND VGND VPWR VPWR sky130_fd_sc_hd__fill_2
XFILLER_73_535 VGND VGND VPWR VPWR sky130_fd_sc_hd__decap_3
XTAP_TAPCELL_ROW_56_733 VGND VPWR sky130_fd_sc_hd__tapvpwrvgnd_1
XFILLER_26_53 VGND VGND VPWR VPWR sky130_fd_sc_hd__decap_3
XFILLER_60_229 VGND VGND VPWR VPWR sky130_fd_sc_hd__decap_3
XTAP_TAPCELL_ROW_28_468 VGND VPWR sky130_fd_sc_hd__tapvpwrvgnd_1
XFILLER_13_101 VGND VGND VPWR VPWR sky130_fd_sc_hd__decap_3
XFILLER_26_97 VGND VGND VPWR VPWR sky130_fd_sc_hd__decap_3
XFILLER_41_410 VGND VGND VPWR VPWR sky130_fd_sc_hd__decap_3
XFILLER_41_476 VGND VGND VPWR VPWR sky130_fd_sc_hd__decap_3
XFILLER_9_116 VGND VGND VPWR VPWR sky130_fd_sc_hd__fill_1
XTAP_TAPCELL_ROW_11_302 VGND VPWR sky130_fd_sc_hd__tapvpwrvgnd_1
XFILLER_42_85 VGND VGND VPWR VPWR sky130_fd_sc_hd__decap_3
XFILLER_5_311 VGND VGND VPWR VPWR sky130_fd_sc_hd__decap_3
XPHY_EDGE_ROW_39_Left_133 VGND VGND VPWR VPWR sky130_fd_sc_hd__decap_3
XFILLER_1_550 VGND VGND VPWR VPWR sky130_fd_sc_hd__decap_3
XFILLER_3_35 VGND VGND VPWR VPWR sky130_fd_sc_hd__fill_2
XFILLER_68_318 VGND VGND VPWR VPWR sky130_fd_sc_hd__decap_3
XFILLER_3_57 VGND VGND VPWR VPWR sky130_fd_sc_hd__decap_3
XFILLER_49_543 VGND VGND VPWR VPWR sky130_fd_sc_hd__decap_3
XFILLER_49_554 VGND VGND VPWR VPWR sky130_fd_sc_hd__decap_3
XFILLER_67_71 VGND VGND VPWR VPWR sky130_fd_sc_hd__decap_3
XPHY_EDGE_ROW_48_Left_142 VGND VGND VPWR VPWR sky130_fd_sc_hd__decap_3
XFILLER_76_362 VGND VGND VPWR VPWR sky130_fd_sc_hd__fill_2
XFILLER_36_259 VGND VGND VPWR VPWR sky130_fd_sc_hd__decap_3
XFILLER_64_557 VGND VGND VPWR VPWR sky130_fd_sc_hd__fill_1
XFILLER_17_473 VGND VGND VPWR VPWR sky130_fd_sc_hd__decap_3
XFILLER_51_218 VGND VGND VPWR VPWR sky130_fd_sc_hd__decap_3
XFILLER_83_70 VGND VGND VPWR VPWR sky130_fd_sc_hd__decap_3
XFILLER_32_410 VGND VGND VPWR VPWR sky130_fd_sc_hd__decap_3
XFILLER_32_421 VGND VGND VPWR VPWR sky130_fd_sc_hd__decap_3
X_4890_ _5099_/CLK _4890_/D VGND VGND VPWR VPWR _4890_/Q sky130_fd_sc_hd__dfxtp_2
X_3910_ _3963_/A _3878_/X _3909_/X VGND VGND VPWR VPWR _3910_/Y sky130_fd_sc_hd__a21boi_2
XFILLER_91_398 VGND VGND VPWR VPWR sky130_fd_sc_hd__decap_3
XFILLER_83_92 VGND VGND VPWR VPWR sky130_fd_sc_hd__decap_3
X_3841_ _4192_/B _4192_/C _4192_/D _4192_/A VGND VGND VPWR VPWR _3841_/X sky130_fd_sc_hd__o31a_2
XFILLER_32_498 VGND VGND VPWR VPWR sky130_fd_sc_hd__decap_3
X_3772_ _3766_/B _3749_/A _3769_/X _3771_/Y VGND VGND VPWR VPWR _3772_/X sky130_fd_sc_hd__a211o_2
XFILLER_80_3 VGND VGND VPWR VPWR sky130_fd_sc_hd__fill_1
X_2723_ _4888_/Q _4872_/Q _5096_/Q _5080_/Q _2851_/S0 _2854_/S1 VGND VGND VPWR VPWR
+ _2723_/X sky130_fd_sc_hd__mux4_2
XPHY_EDGE_ROW_57_Left_151 VGND VGND VPWR VPWR sky130_fd_sc_hd__decap_3
X_2654_ _5164_/Q _4397_/B VGND VGND VPWR VPWR _2656_/A sky130_fd_sc_hd__nand2_2
XFILLER_8_193 VGND VGND VPWR VPWR sky130_fd_sc_hd__decap_3
X_2585_ _2579_/X _2581_/X _2584_/X _2433_/Y VGND VGND VPWR VPWR _4321_/B sky130_fd_sc_hd__a22oi_2
X_4324_ _4393_/A _4393_/B VGND VGND VPWR VPWR _4325_/C sky130_fd_sc_hd__or2_2
XFILLER_47_19 VGND VGND VPWR VPWR sky130_fd_sc_hd__fill_1
X_4255_ _5224_/Q _4275_/B VGND VGND VPWR VPWR _4255_/Y sky130_fd_sc_hd__nor2_2
XFILLER_86_115 VGND VGND VPWR VPWR sky130_fd_sc_hd__decap_3
X_4186_ _4186_/A _4186_/B _4186_/C _4186_/D VGND VGND VPWR VPWR _4186_/X sky130_fd_sc_hd__or4_2
X_3206_ _2941_/X _3193_/B _3193_/Y _5107_/Q VGND VGND VPWR VPWR _5107_/D sky130_fd_sc_hd__a22o_2
XPHY_EDGE_ROW_66_Left_160 VGND VGND VPWR VPWR sky130_fd_sc_hd__decap_3
XFILLER_86_159 VGND VGND VPWR VPWR sky130_fd_sc_hd__decap_3
XFILLER_67_362 VGND VGND VPWR VPWR sky130_fd_sc_hd__decap_3
XFILLER_67_384 VGND VGND VPWR VPWR sky130_fd_sc_hd__decap_3
X_3137_ _2950_/X _3121_/B _3121_/Y _5046_/Q VGND VGND VPWR VPWR _5046_/D sky130_fd_sc_hd__a22o_2
XFILLER_27_259 VGND VGND VPWR VPWR sky130_fd_sc_hd__decap_3
XFILLER_82_343 VGND VGND VPWR VPWR sky130_fd_sc_hd__decap_3
X_3068_ _2905_/X _3066_/B _3066_/Y _4984_/Q VGND VGND VPWR VPWR _4984_/D sky130_fd_sc_hd__a22o_2
XTAP_TAPCELL_ROW_53_703 VGND VPWR sky130_fd_sc_hd__tapvpwrvgnd_1
XFILLER_82_365 VGND VGND VPWR VPWR sky130_fd_sc_hd__decap_3
XFILLER_23_421 VGND VGND VPWR VPWR sky130_fd_sc_hd__decap_3
XFILLER_35_292 VGND VGND VPWR VPWR sky130_fd_sc_hd__decap_3
XTAP_TAPCELL_ROW_25_438 VGND VPWR sky130_fd_sc_hd__tapvpwrvgnd_1
XFILLER_82_398 VGND VGND VPWR VPWR sky130_fd_sc_hd__decap_3
XFILLER_10_115 VGND VGND VPWR VPWR sky130_fd_sc_hd__fill_2
XFILLER_23_498 VGND VGND VPWR VPWR sky130_fd_sc_hd__fill_1
XTAP_TAPCELL_ROW_61_780 VGND VPWR sky130_fd_sc_hd__tapvpwrvgnd_1
XFILLER_88_15 VGND VGND VPWR VPWR sky130_fd_sc_hd__fill_1
XFILLER_77_137 VGND VGND VPWR VPWR sky130_fd_sc_hd__decap_3
XFILLER_77_159 VGND VGND VPWR VPWR sky130_fd_sc_hd__decap_3
XFILLER_46_513 VGND VGND VPWR VPWR sky130_fd_sc_hd__decap_3
XFILLER_58_384 VGND VGND VPWR VPWR sky130_fd_sc_hd__decap_3
XFILLER_18_259 VGND VGND VPWR VPWR sky130_fd_sc_hd__decap_3
XFILLER_37_63 VGND VGND VPWR VPWR sky130_fd_sc_hd__decap_3
XFILLER_73_321 VGND VGND VPWR VPWR sky130_fd_sc_hd__decap_3
XFILLER_61_505 VGND VGND VPWR VPWR sky130_fd_sc_hd__fill_1
XFILLER_73_387 VGND VGND VPWR VPWR sky130_fd_sc_hd__decap_3
XFILLER_14_410 VGND VGND VPWR VPWR sky130_fd_sc_hd__decap_3
XFILLER_14_421 VGND VGND VPWR VPWR sky130_fd_sc_hd__decap_3
XFILLER_41_284 VGND VGND VPWR VPWR sky130_fd_sc_hd__decap_3
XFILLER_45_6 VGND VGND VPWR VPWR sky130_fd_sc_hd__decap_3
XFILLER_78_70 VGND VGND VPWR VPWR sky130_fd_sc_hd__decap_3
XFILLER_1_391 VGND VGND VPWR VPWR sky130_fd_sc_hd__fill_1
XFILLER_49_340 VGND VGND VPWR VPWR sky130_fd_sc_hd__decap_3
XFILLER_68_159 VGND VGND VPWR VPWR sky130_fd_sc_hd__decap_3
X_4040_ _2422_/Y _4854_/B _4038_/X _4039_/Y _4692_/A VGND VGND VPWR VPWR _5215_/D
+ sky130_fd_sc_hd__a221oi_2
XFILLER_49_373 VGND VGND VPWR VPWR sky130_fd_sc_hd__decap_3
XTAP_TAPCELL_ROW_67_839 VGND VPWR sky130_fd_sc_hd__tapvpwrvgnd_1
XFILLER_64_321 VGND VGND VPWR VPWR sky130_fd_sc_hd__decap_3
XFILLER_64_343 VGND VGND VPWR VPWR sky130_fd_sc_hd__decap_3
XFILLER_64_365 VGND VGND VPWR VPWR sky130_fd_sc_hd__decap_3
XFILLER_17_281 VGND VGND VPWR VPWR sky130_fd_sc_hd__decap_3
X_4942_ _5118_/CLK _4942_/D VGND VGND VPWR VPWR _4942_/Q sky130_fd_sc_hd__dfxtp_2
XFILLER_32_251 VGND VGND VPWR VPWR sky130_fd_sc_hd__fill_1
X_4873_ _5083_/CLK _4873_/D VGND VGND VPWR VPWR _4873_/Q sky130_fd_sc_hd__dfxtp_2
XTAP_TAPCELL_ROW_22_408 VGND VPWR sky130_fd_sc_hd__tapvpwrvgnd_1
X_3824_ _3824_/A _3824_/B VGND VGND VPWR VPWR _3986_/B sky130_fd_sc_hd__or2_2
X_3755_ _4310_/A _4103_/B VGND VGND VPWR VPWR _3755_/Y sky130_fd_sc_hd__nor2_2
X_3686_ _2430_/Y _3685_/X _3680_/Y _3682_/Y VGND VGND VPWR VPWR _3788_/B sky130_fd_sc_hd__o2bb2a_2
X_2706_ _2894_/A _2706_/B _2707_/C _2707_/D VGND VGND VPWR VPWR _2706_/X sky130_fd_sc_hd__and4_2
XTAP_TAPCELL_ROW_30_485 VGND VPWR sky130_fd_sc_hd__tapvpwrvgnd_1
XFILLER_9_491 VGND VGND VPWR VPWR sky130_fd_sc_hd__decap_3
X_2637_ _5120_/Q _5008_/Q _4992_/Q _4976_/Q _2676_/S0 _2676_/S1 VGND VGND VPWR VPWR
+ _2637_/X sky130_fd_sc_hd__mux4_2
XPHY_EDGE_ROW_12_Right_12 VGND VGND VPWR VPWR sky130_fd_sc_hd__decap_3
X_2568_ _4890_/Q _4874_/Q _5098_/Q _5082_/Q _2676_/S0 _2676_/S1 VGND VGND VPWR VPWR
+ _2568_/X sky130_fd_sc_hd__mux4_2
XFILLER_87_402 VGND VGND VPWR VPWR sky130_fd_sc_hd__decap_3
X_4307_ _4307_/A VGND VGND VPWR VPWR _4307_/Y sky130_fd_sc_hd__inv_2
X_2499_ _2677_/S _2498_/X _5130_/Q VGND VGND VPWR VPWR _2499_/X sky130_fd_sc_hd__o21a_2
XFILLER_87_435 VGND VGND VPWR VPWR sky130_fd_sc_hd__decap_3
XFILLER_59_159 VGND VGND VPWR VPWR sky130_fd_sc_hd__decap_3
X_4238_ _4239_/A _4239_/B VGND VGND VPWR VPWR _4238_/X sky130_fd_sc_hd__and2_2
XFILLER_28_524 VGND VGND VPWR VPWR sky130_fd_sc_hd__decap_3
XFILLER_55_310 VGND VGND VPWR VPWR sky130_fd_sc_hd__decap_3
XFILLER_74_118 VGND VGND VPWR VPWR sky130_fd_sc_hd__decap_3
XFILLER_28_557 VGND VGND VPWR VPWR sky130_fd_sc_hd__fill_1
XFILLER_55_343 VGND VGND VPWR VPWR sky130_fd_sc_hd__decap_3
X_4169_ _4200_/A _4169_/B _4189_/A _4169_/D VGND VGND VPWR VPWR _4186_/A sky130_fd_sc_hd__and4_2
XFILLER_43_505 VGND VGND VPWR VPWR sky130_fd_sc_hd__decap_3
XFILLER_55_376 VGND VGND VPWR VPWR sky130_fd_sc_hd__fill_1
XTAP_TAPCELL_ROW_38_563 VGND VPWR sky130_fd_sc_hd__tapvpwrvgnd_1
XPHY_EDGE_ROW_21_Right_21 VGND VGND VPWR VPWR sky130_fd_sc_hd__decap_3
XFILLER_70_324 VGND VGND VPWR VPWR sky130_fd_sc_hd__fill_1
XFILLER_82_184 VGND VGND VPWR VPWR sky130_fd_sc_hd__decap_3
XFILLER_70_346 VGND VGND VPWR VPWR sky130_fd_sc_hd__decap_3
XFILLER_11_413 VGND VGND VPWR VPWR sky130_fd_sc_hd__fill_1
XFILLER_23_251 VGND VGND VPWR VPWR sky130_fd_sc_hd__decap_3
XFILLER_90_38 VGND VGND VPWR VPWR sky130_fd_sc_hd__fill_1
XFILLER_23_54 VGND VGND VPWR VPWR sky130_fd_sc_hd__fill_2
XFILLER_7_439 VGND VGND VPWR VPWR sky130_fd_sc_hd__decap_3
XPHY_EDGE_ROW_30_Right_30 VGND VGND VPWR VPWR sky130_fd_sc_hd__decap_3
XFILLER_2_144 VGND VGND VPWR VPWR sky130_fd_sc_hd__decap_3
XFILLER_78_424 VGND VGND VPWR VPWR sky130_fd_sc_hd__decap_3
XFILLER_78_457 VGND VGND VPWR VPWR sky130_fd_sc_hd__decap_3
XFILLER_65_129 VGND VGND VPWR VPWR sky130_fd_sc_hd__decap_3
XFILLER_93_427 VGND VGND VPWR VPWR sky130_fd_sc_hd__decap_3
XFILLER_19_535 VGND VGND VPWR VPWR sky130_fd_sc_hd__decap_3
XFILLER_46_321 VGND VGND VPWR VPWR sky130_fd_sc_hd__fill_1
XFILLER_93_449 VGND VGND VPWR VPWR sky130_fd_sc_hd__decap_3
XFILLER_86_490 VGND VGND VPWR VPWR sky130_fd_sc_hd__decap_3
XFILLER_0_69 VGND VGND VPWR VPWR sky130_fd_sc_hd__decap_3
XFILLER_73_162 VGND VGND VPWR VPWR sky130_fd_sc_hd__decap_3
XTAP_TAPCELL_ROW_64_809 VGND VPWR sky130_fd_sc_hd__tapvpwrvgnd_1
XFILLER_64_72 VGND VGND VPWR VPWR sky130_fd_sc_hd__decap_3
XFILLER_14_240 VGND VGND VPWR VPWR sky130_fd_sc_hd__decap_3
XFILLER_61_379 VGND VGND VPWR VPWR sky130_fd_sc_hd__decap_3
XTAP_TAPCELL_ROW_72_886 VGND VPWR sky130_fd_sc_hd__tapvpwrvgnd_1
XFILLER_9_67 VGND VGND VPWR VPWR sky130_fd_sc_hd__decap_3
X_3540_ _4378_/B _4378_/A _3866_/B VGND VGND VPWR VPWR _3917_/B sky130_fd_sc_hd__mux2_1
XFILLER_6_483 VGND VGND VPWR VPWR sky130_fd_sc_hd__decap_3
X_5210_ _5241_/CLK _5210_/D VGND VGND VPWR VPWR _5210_/Q sky130_fd_sc_hd__dfxtp_2
X_3471_ _3472_/A _3472_/C _3472_/B VGND VGND VPWR VPWR _3471_/X sky130_fd_sc_hd__o21a_2
X_2422_ _5215_/Q VGND VGND VPWR VPWR _2422_/Y sky130_fd_sc_hd__inv_2
XFILLER_89_80 VGND VGND VPWR VPWR sky130_fd_sc_hd__decap_3
X_5141_ _5263_/CLK _5141_/D VGND VGND VPWR VPWR _5141_/Q sky130_fd_sc_hd__dfxtp_2
X_5072_ _5103_/CLK _5072_/D VGND VGND VPWR VPWR _5072_/Q sky130_fd_sc_hd__dfxtp_2
X_4023_ _4550_/B _4022_/Y _4023_/S VGND VGND VPWR VPWR _4023_/X sky130_fd_sc_hd__mux2_1
XFILLER_84_427 VGND VGND VPWR VPWR sky130_fd_sc_hd__decap_3
XFILLER_25_505 VGND VGND VPWR VPWR sky130_fd_sc_hd__decap_3
XFILLER_37_354 VGND VGND VPWR VPWR sky130_fd_sc_hd__decap_3
XFILLER_52_302 VGND VGND VPWR VPWR sky130_fd_sc_hd__decap_3
XFILLER_92_482 VGND VGND VPWR VPWR sky130_fd_sc_hd__decap_3
XTAP_TAPCELL_ROW_35_533 VGND VPWR sky130_fd_sc_hd__tapvpwrvgnd_1
X_4925_ _5117_/CLK _4925_/D VGND VGND VPWR VPWR _4925_/Q sky130_fd_sc_hd__dfxtp_2
XFILLER_20_221 VGND VGND VPWR VPWR sky130_fd_sc_hd__fill_2
X_4856_ _5285_/Q _5284_/Q VGND VGND VPWR VPWR _4856_/X sky130_fd_sc_hd__and2b_2
X_3807_ _3715_/Y _4094_/B _3790_/Y VGND VGND VPWR VPWR _4188_/B sky130_fd_sc_hd__a21oi_2
X_4787_ _4778_/B _4780_/B _4776_/X VGND VGND VPWR VPWR _4788_/B sky130_fd_sc_hd__a21o_2
X_3738_ _3740_/A VGND VGND VPWR VPWR _4062_/B sky130_fd_sc_hd__inv_2
X_3669_ _5074_/Q _5058_/Q _5042_/Q _5026_/Q _3706_/S0 _3706_/S1 VGND VGND VPWR VPWR
+ _3669_/X sky130_fd_sc_hd__mux4_2
XFILLER_87_210 VGND VGND VPWR VPWR sky130_fd_sc_hd__decap_3
XTAP_TAPCELL_ROW_7_269 VGND VPWR sky130_fd_sc_hd__tapvpwrvgnd_1
XFILLER_75_427 VGND VGND VPWR VPWR sky130_fd_sc_hd__decap_3
XFILLER_87_276 VGND VGND VPWR VPWR sky130_fd_sc_hd__decap_3
XFILLER_75_449 VGND VGND VPWR VPWR sky130_fd_sc_hd__decap_3
XFILLER_87_298 VGND VGND VPWR VPWR sky130_fd_sc_hd__decap_3
XFILLER_16_516 VGND VGND VPWR VPWR sky130_fd_sc_hd__decap_3
XFILLER_18_76 VGND VGND VPWR VPWR sky130_fd_sc_hd__decap_3
XFILLER_28_365 VGND VGND VPWR VPWR sky130_fd_sc_hd__decap_3
XFILLER_55_140 VGND VGND VPWR VPWR sky130_fd_sc_hd__decap_3
XTAP_TAPCELL_ROW_87_1030 VGND VPWR sky130_fd_sc_hd__tapvpwrvgnd_1
XFILLER_28_398 VGND VGND VPWR VPWR sky130_fd_sc_hd__decap_3
XFILLER_43_335 VGND VGND VPWR VPWR sky130_fd_sc_hd__fill_1
XFILLER_70_110 VGND VGND VPWR VPWR sky130_fd_sc_hd__decap_3
XFILLER_83_471 VGND VGND VPWR VPWR sky130_fd_sc_hd__decap_3
XFILLER_43_346 VGND VGND VPWR VPWR sky130_fd_sc_hd__decap_3
XFILLER_55_195 VGND VGND VPWR VPWR sky130_fd_sc_hd__decap_3
XFILLER_43_379 VGND VGND VPWR VPWR sky130_fd_sc_hd__decap_3
XFILLER_11_210 VGND VGND VPWR VPWR sky130_fd_sc_hd__decap_3
XFILLER_11_265 VGND VGND VPWR VPWR sky130_fd_sc_hd__decap_3
XFILLER_11_287 VGND VGND VPWR VPWR sky130_fd_sc_hd__decap_3
XFILLER_50_41 VGND VGND VPWR VPWR sky130_fd_sc_hd__decap_3
XFILLER_7_236 VGND VGND VPWR VPWR sky130_fd_sc_hd__fill_2
Xwire167 _5180_/Q VGND VGND VPWR VPWR _3884_/D sky130_fd_sc_hd__buf_8
XFILLER_78_210 VGND VGND VPWR VPWR sky130_fd_sc_hd__decap_3
XFILLER_59_72 VGND VGND VPWR VPWR sky130_fd_sc_hd__decap_3
XFILLER_78_243 VGND VGND VPWR VPWR sky130_fd_sc_hd__decap_3
XFILLER_78_287 VGND VGND VPWR VPWR sky130_fd_sc_hd__decap_3
XFILLER_78_265 VGND VGND VPWR VPWR sky130_fd_sc_hd__fill_2
XFILLER_66_438 VGND VGND VPWR VPWR sky130_fd_sc_hd__decap_3
XTAP_TAPCELL_ROW_77_934 VGND VPWR sky130_fd_sc_hd__tapvpwrvgnd_1
XFILLER_93_235 VGND VGND VPWR VPWR sky130_fd_sc_hd__fill_1
XFILLER_19_343 VGND VGND VPWR VPWR sky130_fd_sc_hd__fill_1
XTAP_TAPCELL_ROW_49_669 VGND VPWR sky130_fd_sc_hd__tapvpwrvgnd_1
XFILLER_61_187 VGND VGND VPWR VPWR sky130_fd_sc_hd__decap_3
X_2971_ _3046_/C _5193_/Q _5192_/Q VGND VGND VPWR VPWR _3028_/B sky130_fd_sc_hd__or3b_2
XTAP_TAPCELL_ROW_32_503 VGND VPWR sky130_fd_sc_hd__tapvpwrvgnd_1
XFILLER_42_390 VGND VGND VPWR VPWR sky130_fd_sc_hd__decap_3
X_4710_ input46/X _4694_/Y _4709_/X _3366_/A VGND VGND VPWR VPWR _5249_/D sky130_fd_sc_hd__o211a_2
X_4641_ _4640_/X _4588_/X _4682_/S VGND VGND VPWR VPWR _4641_/X sky130_fd_sc_hd__mux2_1
XTAP_TAPCELL_ROW_40_580 VGND VPWR sky130_fd_sc_hd__tapvpwrvgnd_1
X_4572_ _4511_/X _4514_/X _4572_/S VGND VGND VPWR VPWR _4572_/X sky130_fd_sc_hd__mux2_1
X_3523_ _3518_/X _3519_/X _3522_/X _2430_/Y VGND VGND VPWR VPWR _4286_/A sky130_fd_sc_hd__a22o_2
X_3454_ _3454_/A _3454_/B VGND VGND VPWR VPWR _3457_/B sky130_fd_sc_hd__nand2_2
XFILLER_89_508 VGND VGND VPWR VPWR sky130_fd_sc_hd__decap_3
XFILLER_69_221 VGND VGND VPWR VPWR sky130_fd_sc_hd__decap_3
X_3385_ _5156_/Q _5153_/Q _3384_/C VGND VGND VPWR VPWR _3385_/Y sky130_fd_sc_hd__a21oi_2
XFILLER_29_107 VGND VGND VPWR VPWR sky130_fd_sc_hd__decap_3
XFILLER_57_405 VGND VGND VPWR VPWR sky130_fd_sc_hd__decap_3
XFILLER_69_254 VGND VGND VPWR VPWR sky130_fd_sc_hd__decap_3
XFILLER_69_287 VGND VGND VPWR VPWR sky130_fd_sc_hd__decap_3
X_5124_ _5177_/CLK _5124_/D VGND VGND VPWR VPWR _5124_/Q sky130_fd_sc_hd__dfxtp_2
XTAP_TAPCELL_ROW_4_239 VGND VPWR sky130_fd_sc_hd__tapvpwrvgnd_1
XFILLER_57_438 VGND VGND VPWR VPWR sky130_fd_sc_hd__decap_3
XFILLER_57_449 VGND VGND VPWR VPWR sky130_fd_sc_hd__decap_3
X_5055_ _5103_/CLK _5055_/D VGND VGND VPWR VPWR _5055_/Q sky130_fd_sc_hd__dfxtp_2
XFILLER_84_213 VGND VGND VPWR VPWR sky130_fd_sc_hd__decap_3
XFILLER_37_140 VGND VGND VPWR VPWR sky130_fd_sc_hd__decap_3
X_4006_ _2443_/X _2869_/B _3995_/X _3998_/X _4005_/Y VGND VGND VPWR VPWR _4006_/X
+ sky130_fd_sc_hd__o2111a_2
XFILLER_65_482 VGND VGND VPWR VPWR sky130_fd_sc_hd__decap_3
XFILLER_25_335 VGND VGND VPWR VPWR sky130_fd_sc_hd__fill_1
XFILLER_80_441 VGND VGND VPWR VPWR sky130_fd_sc_hd__fill_1
XFILLER_80_463 VGND VGND VPWR VPWR sky130_fd_sc_hd__decap_3
X_4908_ _5111_/CLK _4908_/D VGND VGND VPWR VPWR _4908_/Q sky130_fd_sc_hd__dfxtp_2
XFILLER_21_541 VGND VGND VPWR VPWR sky130_fd_sc_hd__fill_1
XFILLER_21_552 VGND VGND VPWR VPWR sky130_fd_sc_hd__decap_3
X_4839_ _4839_/A _4839_/B VGND VGND VPWR VPWR _4839_/Y sky130_fd_sc_hd__xnor2_2
XFILLER_4_206 VGND VGND VPWR VPWR sky130_fd_sc_hd__decap_3
XFILLER_20_44 VGND VGND VPWR VPWR sky130_fd_sc_hd__decap_3
XFILLER_20_77 VGND VGND VPWR VPWR sky130_fd_sc_hd__decap_3
XFILLER_20_88 VGND VGND VPWR VPWR sky130_fd_sc_hd__decap_3
XFILLER_88_530 VGND VGND VPWR VPWR sky130_fd_sc_hd__fill_2
XFILLER_48_438 VGND VGND VPWR VPWR sky130_fd_sc_hd__decap_3
XFILLER_48_449 VGND VGND VPWR VPWR sky130_fd_sc_hd__decap_3
XFILLER_63_408 VGND VGND VPWR VPWR sky130_fd_sc_hd__fill_1
XTAP_TAPCELL_ROW_74_904 VGND VPWR sky130_fd_sc_hd__tapvpwrvgnd_1
XPHY_EDGE_ROW_11_Left_105 VGND VGND VPWR VPWR sky130_fd_sc_hd__decap_3
XTAP_TAPCELL_ROW_46_639 VGND VPWR sky130_fd_sc_hd__tapvpwrvgnd_1
XFILLER_16_357 VGND VGND VPWR VPWR sky130_fd_sc_hd__decap_3
XFILLER_28_195 VGND VGND VPWR VPWR sky130_fd_sc_hd__fill_1
XFILLER_45_52 VGND VGND VPWR VPWR sky130_fd_sc_hd__decap_3
XFILLER_71_430 VGND VGND VPWR VPWR sky130_fd_sc_hd__decap_3
XFILLER_71_452 VGND VGND VPWR VPWR sky130_fd_sc_hd__decap_3
XFILLER_83_290 VGND VGND VPWR VPWR sky130_fd_sc_hd__decap_3
XFILLER_16_368 VGND VGND VPWR VPWR sky130_fd_sc_hd__decap_3
XTAP_TAPCELL_ROW_82_981 VGND VPWR sky130_fd_sc_hd__tapvpwrvgnd_1
XFILLER_31_349 VGND VGND VPWR VPWR sky130_fd_sc_hd__fill_1
XFILLER_12_552 VGND VGND VPWR VPWR sky130_fd_sc_hd__decap_3
XFILLER_61_51 VGND VGND VPWR VPWR sky130_fd_sc_hd__decap_3
XPHY_EDGE_ROW_20_Left_114 VGND VGND VPWR VPWR sky130_fd_sc_hd__decap_3
XFILLER_39_405 VGND VGND VPWR VPWR sky130_fd_sc_hd__decap_3
X_3170_ _2941_/X _3173_/A2 _3157_/Y _5075_/Q VGND VGND VPWR VPWR _5075_/D sky130_fd_sc_hd__a22o_2
XFILLER_39_427 VGND VGND VPWR VPWR sky130_fd_sc_hd__decap_3
XFILLER_39_449 VGND VGND VPWR VPWR sky130_fd_sc_hd__decap_3
XFILLER_66_235 VGND VGND VPWR VPWR sky130_fd_sc_hd__decap_3
XTAP_TAPCELL_ROW_1_209 VGND VPWR sky130_fd_sc_hd__tapvpwrvgnd_1
XFILLER_47_482 VGND VGND VPWR VPWR sky130_fd_sc_hd__decap_3
XFILLER_34_121 VGND VGND VPWR VPWR sky130_fd_sc_hd__fill_2
XFILLER_62_452 VGND VGND VPWR VPWR sky130_fd_sc_hd__decap_3
XTAP_TAPCELL_ROW_17_363 VGND VPWR sky130_fd_sc_hd__tapvpwrvgnd_1
XFILLER_62_496 VGND VGND VPWR VPWR sky130_fd_sc_hd__decap_3
X_2954_ _4692_/A _2954_/B VGND VGND VPWR VPWR _2954_/Y sky130_fd_sc_hd__nor2_4
X_2885_ _3838_/A _2883_/B _2683_/A VGND VGND VPWR VPWR _2886_/B sky130_fd_sc_hd__a21boi_2
X_4624_ _4622_/X _4623_/Y _4692_/A VGND VGND VPWR VPWR _5236_/D sky130_fd_sc_hd__a21oi_2
XPHY_EDGE_ROW_6_Right_6 VGND VGND VPWR VPWR sky130_fd_sc_hd__decap_3
X_4555_ _4540_/Y _4554_/X _4692_/A VGND VGND VPWR VPWR _5231_/D sky130_fd_sc_hd__a21oi_2
X_3506_ _4437_/A _3548_/B VGND VGND VPWR VPWR _4078_/A sky130_fd_sc_hd__nand2b_2
X_4486_ _4313_/X _4307_/A _4486_/S VGND VGND VPWR VPWR _4487_/B sky130_fd_sc_hd__mux2_1
XFILLER_89_327 VGND VGND VPWR VPWR sky130_fd_sc_hd__fill_2
X_3437_ _3438_/B VGND VGND VPWR VPWR _3437_/Y sky130_fd_sc_hd__inv_2
X_3368_ _5182_/Q _5016_/Q _3367_/X VGND VGND VPWR VPWR _3369_/B sky130_fd_sc_hd__a21oi_2
XFILLER_57_213 VGND VGND VPWR VPWR sky130_fd_sc_hd__fill_1
X_5107_ _5107_/CLK _5107_/D VGND VGND VPWR VPWR _5107_/Q sky130_fd_sc_hd__dfxtp_2
XFILLER_85_533 VGND VGND VPWR VPWR sky130_fd_sc_hd__decap_3
XFILLER_57_268 VGND VGND VPWR VPWR sky130_fd_sc_hd__decap_3
X_3299_ _5270_/Q _3305_/B _3298_/Y _3338_/B VGND VGND VPWR VPWR _5149_/D sky130_fd_sc_hd__o211a_2
XFILLER_38_471 VGND VGND VPWR VPWR sky130_fd_sc_hd__fill_2
XFILLER_57_279 VGND VGND VPWR VPWR sky130_fd_sc_hd__fill_1
X_5038_ _5102_/CLK _5038_/D VGND VGND VPWR VPWR _5038_/Q sky130_fd_sc_hd__dfxtp_2
XTAP_TAPCELL_ROW_84_1000 VGND VPWR sky130_fd_sc_hd__tapvpwrvgnd_1
XFILLER_53_441 VGND VGND VPWR VPWR sky130_fd_sc_hd__decap_3
XFILLER_13_316 VGND VGND VPWR VPWR sky130_fd_sc_hd__decap_3
XFILLER_53_452 VGND VGND VPWR VPWR sky130_fd_sc_hd__decap_3
XTAP_TAPCELL_ROW_43_609 VGND VPWR sky130_fd_sc_hd__tapvpwrvgnd_1
XFILLER_13_349 VGND VGND VPWR VPWR sky130_fd_sc_hd__decap_3
XFILLER_15_66 VGND VGND VPWR VPWR sky130_fd_sc_hd__decap_3
XFILLER_80_282 VGND VGND VPWR VPWR sky130_fd_sc_hd__decap_3
XFILLER_9_309 VGND VGND VPWR VPWR sky130_fd_sc_hd__decap_3
XTAP_TAPCELL_ROW_51_686 VGND VPWR sky130_fd_sc_hd__tapvpwrvgnd_1
XFILLER_21_393 VGND VGND VPWR VPWR sky130_fd_sc_hd__decap_3
XFILLER_31_32 VGND VGND VPWR VPWR sky130_fd_sc_hd__decap_3
XFILLER_31_43 VGND VGND VPWR VPWR sky130_fd_sc_hd__decap_3
XFILLER_5_515 VGND VGND VPWR VPWR sky130_fd_sc_hd__decap_3
XFILLER_5_548 VGND VGND VPWR VPWR sky130_fd_sc_hd__decap_3
Xoutput54 _5279_/Q VGND VGND VPWR VPWR EX_HALT sky130_fd_sc_hd__clkdlybuf4s25_1
Xoutput65 _5141_/Q VGND VGND VPWR VPWR INSTR_ADDR[4] sky130_fd_sc_hd__clkdlybuf4s25_1
Xoutput76 _2861_/Y VGND VGND VPWR VPWR MEM_ADDR[0] sky130_fd_sc_hd__clkdlybuf4s25_1
XFILLER_0_231 VGND VGND VPWR VPWR sky130_fd_sc_hd__decap_3
XFILLER_0_253 VGND VGND VPWR VPWR sky130_fd_sc_hd__decap_3
Xoutput87 _2871_/Y VGND VGND VPWR VPWR MEM_ADDR[5] sky130_fd_sc_hd__clkdlybuf4s25_1
Xoutput98 _2857_/X VGND VGND VPWR VPWR MEM_STR_DATA[15] sky130_fd_sc_hd__clkdlybuf4s25_1
XFILLER_88_393 VGND VGND VPWR VPWR sky130_fd_sc_hd__decap_3
XFILLER_88_371 VGND VGND VPWR VPWR sky130_fd_sc_hd__decap_3
XFILLER_76_544 VGND VGND VPWR VPWR sky130_fd_sc_hd__decap_3
XFILLER_76_533 VGND VGND VPWR VPWR sky130_fd_sc_hd__fill_1
XTAP_TAPCELL_ROW_59_764 VGND VPWR sky130_fd_sc_hd__tapvpwrvgnd_1
XFILLER_56_73 VGND VGND VPWR VPWR sky130_fd_sc_hd__decap_3
XFILLER_63_205 VGND VGND VPWR VPWR sky130_fd_sc_hd__decap_3
XFILLER_63_238 VGND VGND VPWR VPWR sky130_fd_sc_hd__decap_3
XFILLER_91_547 VGND VGND VPWR VPWR sky130_fd_sc_hd__decap_3
XFILLER_16_165 VGND VGND VPWR VPWR sky130_fd_sc_hd__fill_2
XFILLER_31_113 VGND VGND VPWR VPWR sky130_fd_sc_hd__decap_3
XTAP_TAPCELL_ROW_14_333 VGND VPWR sky130_fd_sc_hd__tapvpwrvgnd_1
XFILLER_12_360 VGND VGND VPWR VPWR sky130_fd_sc_hd__decap_3
XPHY_EDGE_ROW_59_Right_59 VGND VGND VPWR VPWR sky130_fd_sc_hd__decap_3
X_2670_ _2670_/A _4633_/S VGND VGND VPWR VPWR _4174_/B sky130_fd_sc_hd__nand2_2
XFILLER_8_386 VGND VGND VPWR VPWR sky130_fd_sc_hd__decap_3
X_4340_ _3363_/A _4213_/A _4340_/S VGND VGND VPWR VPWR _4340_/X sky130_fd_sc_hd__mux2_1
X_4271_ _4271_/A _4271_/B VGND VGND VPWR VPWR _4271_/Y sky130_fd_sc_hd__nor2_2
X_3222_ _2934_/X _3227_/A2 _3211_/Y _5121_/Q VGND VGND VPWR VPWR _5121_/D sky130_fd_sc_hd__a22o_2
XFILLER_67_511 VGND VGND VPWR VPWR sky130_fd_sc_hd__decap_3
X_3153_ _2944_/X _3139_/B _3139_/Y _5060_/Q VGND VGND VPWR VPWR _5060_/D sky130_fd_sc_hd__a22o_2
XPHY_EDGE_ROW_68_Right_68 VGND VGND VPWR VPWR sky130_fd_sc_hd__decap_3
XFILLER_79_382 VGND VGND VPWR VPWR sky130_fd_sc_hd__fill_2
XFILLER_27_408 VGND VGND VPWR VPWR sky130_fd_sc_hd__decap_3
XFILLER_54_227 VGND VGND VPWR VPWR sky130_fd_sc_hd__decap_3
X_3084_ _3494_/A _3084_/B VGND VGND VPWR VPWR _3084_/Y sky130_fd_sc_hd__nor2_4
XFILLER_35_441 VGND VGND VPWR VPWR sky130_fd_sc_hd__decap_3
XFILLER_35_452 VGND VGND VPWR VPWR sky130_fd_sc_hd__fill_1
XFILLER_62_260 VGND VGND VPWR VPWR sky130_fd_sc_hd__decap_3
XFILLER_22_124 VGND VGND VPWR VPWR sky130_fd_sc_hd__decap_3
XFILLER_50_455 VGND VGND VPWR VPWR sky130_fd_sc_hd__decap_3
XFILLER_50_466 VGND VGND VPWR VPWR sky130_fd_sc_hd__decap_3
X_3986_ _3986_/A _3986_/B VGND VGND VPWR VPWR _3986_/Y sky130_fd_sc_hd__nor2_2
XPHY_EDGE_ROW_77_Right_77 VGND VGND VPWR VPWR sky130_fd_sc_hd__decap_3
XFILLER_50_477 VGND VGND VPWR VPWR sky130_fd_sc_hd__decap_3
X_2937_ _5276_/Q _5221_/Q _2947_/B1 _5237_/Q _2936_/X VGND VGND VPWR VPWR _2937_/X
+ sky130_fd_sc_hd__a221o_2
X_4607_ _4606_/Y _4575_/Y _4681_/S VGND VGND VPWR VPWR _4607_/X sky130_fd_sc_hd__mux2_1
X_2868_ _3986_/A _2868_/B VGND VGND VPWR VPWR _2869_/B sky130_fd_sc_hd__xnor2_2
X_2799_ _5120_/Q _5008_/Q _4992_/Q _4976_/Q _5135_/Q _5136_/Q VGND VGND VPWR VPWR
+ _2799_/X sky130_fd_sc_hd__mux4_2
XFILLER_2_518 VGND VGND VPWR VPWR sky130_fd_sc_hd__decap_3
X_4538_ _3995_/X _4522_/X _4537_/X _4278_/X VGND VGND VPWR VPWR _4538_/X sky130_fd_sc_hd__a31o_2
XFILLER_89_113 VGND VGND VPWR VPWR sky130_fd_sc_hd__decap_3
XFILLER_89_102 VGND VGND VPWR VPWR sky130_fd_sc_hd__fill_1
X_4469_ _4468_/A _4468_/B _4468_/Y _3764_/X VGND VGND VPWR VPWR _4469_/Y sky130_fd_sc_hd__o211ai_2
XFILLER_77_28 VGND VGND VPWR VPWR sky130_fd_sc_hd__decap_3
XPHY_EDGE_ROW_86_Right_86 VGND VGND VPWR VPWR sky130_fd_sc_hd__decap_3
XFILLER_77_308 VGND VGND VPWR VPWR sky130_fd_sc_hd__decap_3
XFILLER_58_533 VGND VGND VPWR VPWR sky130_fd_sc_hd__decap_3
XFILLER_58_555 VGND VGND VPWR VPWR sky130_fd_sc_hd__decap_3
XFILLER_85_330 VGND VGND VPWR VPWR sky130_fd_sc_hd__decap_3
XFILLER_73_503 VGND VGND VPWR VPWR sky130_fd_sc_hd__fill_1
XFILLER_73_514 VGND VGND VPWR VPWR sky130_fd_sc_hd__decap_3
XFILLER_85_396 VGND VGND VPWR VPWR sky130_fd_sc_hd__fill_2
XFILLER_26_32 VGND VGND VPWR VPWR sky130_fd_sc_hd__fill_1
XFILLER_45_249 VGND VGND VPWR VPWR sky130_fd_sc_hd__fill_1
XFILLER_73_547 VGND VGND VPWR VPWR sky130_fd_sc_hd__decap_3
XTAP_TAPCELL_ROW_56_734 VGND VPWR sky130_fd_sc_hd__tapvpwrvgnd_1
XFILLER_26_463 VGND VGND VPWR VPWR sky130_fd_sc_hd__decap_3
XFILLER_26_65 VGND VGND VPWR VPWR sky130_fd_sc_hd__decap_3
XTAP_TAPCELL_ROW_28_469 VGND VPWR sky130_fd_sc_hd__tapvpwrvgnd_1
XFILLER_26_496 VGND VGND VPWR VPWR sky130_fd_sc_hd__decap_3
XFILLER_53_260 VGND VGND VPWR VPWR sky130_fd_sc_hd__decap_3
XFILLER_41_444 VGND VGND VPWR VPWR sky130_fd_sc_hd__decap_3
XFILLER_41_455 VGND VGND VPWR VPWR sky130_fd_sc_hd__decap_3
XTAP_TAPCELL_ROW_11_303 VGND VPWR sky130_fd_sc_hd__tapvpwrvgnd_1
XFILLER_42_64 VGND VGND VPWR VPWR sky130_fd_sc_hd__decap_3
XFILLER_49_500 VGND VGND VPWR VPWR sky130_fd_sc_hd__decap_3
XFILLER_49_511 VGND VGND VPWR VPWR sky130_fd_sc_hd__decap_3
XFILLER_76_341 VGND VGND VPWR VPWR sky130_fd_sc_hd__decap_3
XFILLER_64_525 VGND VGND VPWR VPWR sky130_fd_sc_hd__decap_3
XFILLER_91_300 VGND VGND VPWR VPWR sky130_fd_sc_hd__decap_3
XFILLER_76_374 VGND VGND VPWR VPWR sky130_fd_sc_hd__decap_3
XFILLER_17_430 VGND VGND VPWR VPWR sky130_fd_sc_hd__decap_3
XFILLER_64_536 VGND VGND VPWR VPWR sky130_fd_sc_hd__decap_3
XFILLER_51_208 VGND VGND VPWR VPWR sky130_fd_sc_hd__decap_3
XFILLER_91_388 VGND VGND VPWR VPWR sky130_fd_sc_hd__decap_3
XFILLER_91_366 VGND VGND VPWR VPWR sky130_fd_sc_hd__fill_1
XFILLER_17_485 VGND VGND VPWR VPWR sky130_fd_sc_hd__decap_3
XFILLER_32_455 VGND VGND VPWR VPWR sky130_fd_sc_hd__decap_3
XFILLER_32_466 VGND VGND VPWR VPWR sky130_fd_sc_hd__decap_3
X_3840_ _5167_/Q _3840_/B VGND VGND VPWR VPWR _4192_/D sky130_fd_sc_hd__nor2_2
XFILLER_32_477 VGND VGND VPWR VPWR sky130_fd_sc_hd__decap_3
X_3771_ _2443_/X _3894_/B _2861_/B VGND VGND VPWR VPWR _3771_/Y sky130_fd_sc_hd__a21oi_2
X_2722_ _2857_/A _4728_/B VGND VGND VPWR VPWR _2722_/X sky130_fd_sc_hd__and2_2
XFILLER_73_3 VGND VGND VPWR VPWR sky130_fd_sc_hd__fill_1
XFILLER_8_150 VGND VGND VPWR VPWR sky130_fd_sc_hd__decap_3
X_2653_ _2647_/X _2649_/X _2652_/X _2433_/Y VGND VGND VPWR VPWR _3786_/B sky130_fd_sc_hd__a22o_2
X_2584_ _2582_/X _2583_/X _5129_/Q VGND VGND VPWR VPWR _2584_/X sky130_fd_sc_hd__mux2_1
X_4323_ _4393_/C _4393_/D VGND VGND VPWR VPWR _4323_/Y sky130_fd_sc_hd__nor2_2
X_4254_ _4168_/A _4235_/Y _4236_/Y _4253_/X VGND VGND VPWR VPWR _4254_/X sky130_fd_sc_hd__a22o_2
XFILLER_86_127 VGND VGND VPWR VPWR sky130_fd_sc_hd__decap_3
X_4185_ _4185_/A _4185_/B _4185_/C _4184_/X VGND VGND VPWR VPWR _4186_/D sky130_fd_sc_hd__or4b_2
X_3205_ _2937_/X _3193_/B _3193_/Y _5106_/Q VGND VGND VPWR VPWR _5106_/D sky130_fd_sc_hd__a22o_2
XFILLER_55_514 VGND VGND VPWR VPWR sky130_fd_sc_hd__decap_3
X_3136_ _2947_/X _3121_/B _3121_/Y _5045_/Q VGND VGND VPWR VPWR _5045_/D sky130_fd_sc_hd__a22o_2
XFILLER_82_300 VGND VGND VPWR VPWR sky130_fd_sc_hd__decap_3
XFILLER_55_547 VGND VGND VPWR VPWR sky130_fd_sc_hd__decap_3
XFILLER_67_396 VGND VGND VPWR VPWR sky130_fd_sc_hd__decap_3
X_3067_ _2897_/X _3066_/B _3066_/Y _4983_/Q VGND VGND VPWR VPWR _4983_/D sky130_fd_sc_hd__a22o_2
XFILLER_70_517 VGND VGND VPWR VPWR sky130_fd_sc_hd__fill_1
XTAP_TAPCELL_ROW_53_704 VGND VPWR sky130_fd_sc_hd__tapvpwrvgnd_1
XFILLER_82_377 VGND VGND VPWR VPWR sky130_fd_sc_hd__fill_1
XFILLER_82_355 VGND VGND VPWR VPWR sky130_fd_sc_hd__fill_1
XTAP_TAPCELL_ROW_25_439 VGND VPWR sky130_fd_sc_hd__tapvpwrvgnd_1
XFILLER_23_433 VGND VGND VPWR VPWR sky130_fd_sc_hd__decap_3
XFILLER_23_455 VGND VGND VPWR VPWR sky130_fd_sc_hd__decap_3
XFILLER_50_241 VGND VGND VPWR VPWR sky130_fd_sc_hd__decap_3
XFILLER_10_105 VGND VGND VPWR VPWR sky130_fd_sc_hd__fill_2
XFILLER_23_488 VGND VGND VPWR VPWR sky130_fd_sc_hd__fill_2
XFILLER_50_263 VGND VGND VPWR VPWR sky130_fd_sc_hd__decap_3
XFILLER_50_285 VGND VGND VPWR VPWR sky130_fd_sc_hd__decap_3
XTAP_TAPCELL_ROW_61_781 VGND VPWR sky130_fd_sc_hd__tapvpwrvgnd_1
XFILLER_10_138 VGND VGND VPWR VPWR sky130_fd_sc_hd__fill_2
X_3969_ _3865_/X _3860_/X _3969_/S VGND VGND VPWR VPWR _3969_/X sky130_fd_sc_hd__mux2_1
XFILLER_12_56 VGND VGND VPWR VPWR sky130_fd_sc_hd__decap_3
XFILLER_5_6 VGND VGND VPWR VPWR sky130_fd_sc_hd__decap_3
XFILLER_88_38 VGND VGND VPWR VPWR sky130_fd_sc_hd__fill_1
XFILLER_58_341 VGND VGND VPWR VPWR sky130_fd_sc_hd__decap_3
XFILLER_46_525 VGND VGND VPWR VPWR sky130_fd_sc_hd__decap_3
XFILLER_58_363 VGND VGND VPWR VPWR sky130_fd_sc_hd__fill_1
XFILLER_58_374 VGND VGND VPWR VPWR sky130_fd_sc_hd__decap_3
XFILLER_18_249 VGND VGND VPWR VPWR sky130_fd_sc_hd__decap_3
XFILLER_37_75 VGND VGND VPWR VPWR sky130_fd_sc_hd__fill_2
XFILLER_85_193 VGND VGND VPWR VPWR sky130_fd_sc_hd__decap_3
XFILLER_37_97 VGND VGND VPWR VPWR sky130_fd_sc_hd__decap_3
XFILLER_73_355 VGND VGND VPWR VPWR sky130_fd_sc_hd__decap_3
XFILLER_61_539 VGND VGND VPWR VPWR sky130_fd_sc_hd__fill_1
XFILLER_73_399 VGND VGND VPWR VPWR sky130_fd_sc_hd__decap_3
XFILLER_53_41 VGND VGND VPWR VPWR sky130_fd_sc_hd__decap_3
XFILLER_53_63 VGND VGND VPWR VPWR sky130_fd_sc_hd__fill_2
XFILLER_53_96 VGND VGND VPWR VPWR sky130_fd_sc_hd__decap_3
XFILLER_5_131 VGND VGND VPWR VPWR sky130_fd_sc_hd__decap_3
XFILLER_5_164 VGND VGND VPWR VPWR sky130_fd_sc_hd__decap_3
XFILLER_5_186 VGND VGND VPWR VPWR sky130_fd_sc_hd__fill_2
XFILLER_38_6 VGND VGND VPWR VPWR sky130_fd_sc_hd__fill_2
XFILLER_78_82 VGND VGND VPWR VPWR sky130_fd_sc_hd__fill_2
XFILLER_49_330 VGND VGND VPWR VPWR sky130_fd_sc_hd__decap_3
XFILLER_37_503 VGND VGND VPWR VPWR sky130_fd_sc_hd__fill_1
XFILLER_49_352 VGND VGND VPWR VPWR sky130_fd_sc_hd__decap_3
XFILLER_83_119 VGND VGND VPWR VPWR sky130_fd_sc_hd__decap_3
XFILLER_37_536 VGND VGND VPWR VPWR sky130_fd_sc_hd__fill_2
XFILLER_49_385 VGND VGND VPWR VPWR sky130_fd_sc_hd__decap_3
XFILLER_49_396 VGND VGND VPWR VPWR sky130_fd_sc_hd__decap_3
XFILLER_76_193 VGND VGND VPWR VPWR sky130_fd_sc_hd__decap_3
XFILLER_17_271 VGND VGND VPWR VPWR sky130_fd_sc_hd__decap_3
X_4941_ clkload3/A _4941_/D VGND VGND VPWR VPWR _4941_/Q sky130_fd_sc_hd__dfxtp_2
XFILLER_32_230 VGND VGND VPWR VPWR sky130_fd_sc_hd__decap_3
X_4872_ _5083_/CLK _4872_/D VGND VGND VPWR VPWR _4872_/Q sky130_fd_sc_hd__dfxtp_2
X_3823_ _3820_/A _3820_/B _3821_/X _2620_/A VGND VGND VPWR VPWR _3824_/B sky130_fd_sc_hd__o211a_2
XTAP_TAPCELL_ROW_22_409 VGND VPWR sky130_fd_sc_hd__tapvpwrvgnd_1
XFILLER_32_296 VGND VGND VPWR VPWR sky130_fd_sc_hd__decap_3
XFILLER_20_469 VGND VGND VPWR VPWR sky130_fd_sc_hd__decap_3
X_3754_ _5159_/Q _4298_/A _4309_/S VGND VGND VPWR VPWR _4103_/B sky130_fd_sc_hd__mux2_1
X_3685_ _3683_/X _3684_/X _3733_/S VGND VGND VPWR VPWR _3685_/X sky130_fd_sc_hd__mux2_1
X_2705_ _2894_/A _2705_/B VGND VGND VPWR VPWR _2705_/X sky130_fd_sc_hd__and2_2
XTAP_TAPCELL_ROW_30_486 VGND VPWR sky130_fd_sc_hd__tapvpwrvgnd_1
X_2636_ _4960_/Q _4944_/Q _4928_/Q _4912_/Q _5127_/Q _5128_/Q VGND VGND VPWR VPWR
+ _2636_/X sky130_fd_sc_hd__mux4_2
X_2567_ _2567_/A _4528_/S VGND VGND VPWR VPWR _3986_/A sky130_fd_sc_hd__nor2_2
XFILLER_59_105 VGND VGND VPWR VPWR sky130_fd_sc_hd__decap_3
XFILLER_59_116 VGND VGND VPWR VPWR sky130_fd_sc_hd__decap_3
X_4306_ _4393_/D _4393_/C _4313_/S VGND VGND VPWR VPWR _4307_/A sky130_fd_sc_hd__mux2_1
X_5286_ _5286_/CLK _5286_/D VGND VGND VPWR VPWR _5286_/Q sky130_fd_sc_hd__dfxtp_2
X_2498_ _5076_/Q _5060_/Q _5044_/Q _5028_/Q _2672_/S0 _2672_/S1 VGND VGND VPWR VPWR
+ _2498_/X sky130_fd_sc_hd__mux4_2
XFILLER_87_414 VGND VGND VPWR VPWR sky130_fd_sc_hd__decap_3
X_4237_ _3666_/A _4214_/B _3811_/X VGND VGND VPWR VPWR _4239_/B sky130_fd_sc_hd__o21a_2
XFILLER_87_458 VGND VGND VPWR VPWR sky130_fd_sc_hd__decap_3
XFILLER_87_447 VGND VGND VPWR VPWR sky130_fd_sc_hd__fill_1
XFILLER_28_536 VGND VGND VPWR VPWR sky130_fd_sc_hd__decap_3
XFILLER_55_333 VGND VGND VPWR VPWR sky130_fd_sc_hd__decap_3
XFILLER_74_29 VGND VGND VPWR VPWR sky130_fd_sc_hd__decap_3
X_4168_ _4168_/A _4168_/B _4168_/C VGND VGND VPWR VPWR _4168_/X sky130_fd_sc_hd__and3_2
XFILLER_55_355 VGND VGND VPWR VPWR sky130_fd_sc_hd__decap_3
X_4099_ _4397_/B _4449_/S _4098_/Y VGND VGND VPWR VPWR _4099_/X sky130_fd_sc_hd__o21a_2
X_3119_ _2950_/X _3119_/A2 _3103_/Y _5030_/Q VGND VGND VPWR VPWR _5030_/D sky130_fd_sc_hd__a22o_2
XTAP_TAPCELL_ROW_38_564 VGND VPWR sky130_fd_sc_hd__tapvpwrvgnd_1
XFILLER_82_141 VGND VGND VPWR VPWR sky130_fd_sc_hd__decap_3
XFILLER_15_219 VGND VGND VPWR VPWR sky130_fd_sc_hd__decap_3
XFILLER_55_388 VGND VGND VPWR VPWR sky130_fd_sc_hd__decap_3
XFILLER_55_399 VGND VGND VPWR VPWR sky130_fd_sc_hd__decap_3
XFILLER_70_358 VGND VGND VPWR VPWR sky130_fd_sc_hd__decap_3
XFILLER_23_263 VGND VGND VPWR VPWR sky130_fd_sc_hd__decap_3
XFILLER_11_436 VGND VGND VPWR VPWR sky130_fd_sc_hd__decap_3
XFILLER_23_296 VGND VGND VPWR VPWR sky130_fd_sc_hd__decap_3
XFILLER_11_458 VGND VGND VPWR VPWR sky130_fd_sc_hd__decap_3
XFILLER_23_99 VGND VGND VPWR VPWR sky130_fd_sc_hd__decap_3
XFILLER_2_134 VGND VGND VPWR VPWR sky130_fd_sc_hd__decap_3
XFILLER_3_3 VGND VGND VPWR VPWR sky130_fd_sc_hd__fill_1
XFILLER_78_403 VGND VGND VPWR VPWR sky130_fd_sc_hd__decap_3
XFILLER_2_178 VGND VGND VPWR VPWR sky130_fd_sc_hd__fill_1
XFILLER_78_436 VGND VGND VPWR VPWR sky130_fd_sc_hd__decap_3
XFILLER_48_85 VGND VGND VPWR VPWR sky130_fd_sc_hd__decap_3
XFILLER_65_119 VGND VGND VPWR VPWR sky130_fd_sc_hd__decap_3
XFILLER_93_417 VGND VGND VPWR VPWR sky130_fd_sc_hd__decap_3
XFILLER_93_406 VGND VGND VPWR VPWR sky130_fd_sc_hd__decap_3
XFILLER_0_15 VGND VGND VPWR VPWR sky130_fd_sc_hd__decap_3
XFILLER_19_547 VGND VGND VPWR VPWR sky130_fd_sc_hd__decap_3
XFILLER_93_439 VGND VGND VPWR VPWR sky130_fd_sc_hd__decap_3
XFILLER_61_303 VGND VGND VPWR VPWR sky130_fd_sc_hd__decap_3
XPHY_EDGE_ROW_85_Left_179 VGND VGND VPWR VPWR sky130_fd_sc_hd__decap_3
XTAP_TAPCELL_ROW_72_887 VGND VPWR sky130_fd_sc_hd__tapvpwrvgnd_1
XFILLER_9_24 VGND VGND VPWR VPWR sky130_fd_sc_hd__decap_3
XFILLER_14_296 VGND VGND VPWR VPWR sky130_fd_sc_hd__decap_3
XFILLER_6_451 VGND VGND VPWR VPWR sky130_fd_sc_hd__decap_3
XFILLER_6_473 VGND VGND VPWR VPWR sky130_fd_sc_hd__decap_3
XFILLER_6_495 VGND VGND VPWR VPWR sky130_fd_sc_hd__decap_3
X_3470_ _3457_/A _3457_/B _3457_/C _3462_/B _3454_/A VGND VGND VPWR VPWR _3472_/C
+ sky130_fd_sc_hd__o311a_2
X_2421_ _5219_/Q VGND VGND VPWR VPWR _2421_/Y sky130_fd_sc_hd__inv_2
XFILLER_89_92 VGND VGND VPWR VPWR sky130_fd_sc_hd__decap_3
XFILLER_36_3 VGND VGND VPWR VPWR sky130_fd_sc_hd__decap_3
XFILLER_69_436 VGND VGND VPWR VPWR sky130_fd_sc_hd__decap_3
X_5140_ _5260_/CLK _5140_/D VGND VGND VPWR VPWR _5140_/Q sky130_fd_sc_hd__dfxtp_2
X_5071_ _5103_/CLK _5071_/D VGND VGND VPWR VPWR _5071_/Q sky130_fd_sc_hd__dfxtp_2
XFILLER_56_119 VGND VGND VPWR VPWR sky130_fd_sc_hd__decap_3
X_4022_ _4022_/A _4022_/B VGND VGND VPWR VPWR _4022_/Y sky130_fd_sc_hd__nand2_2
XFILLER_49_160 VGND VGND VPWR VPWR sky130_fd_sc_hd__decap_3
XFILLER_64_141 VGND VGND VPWR VPWR sky130_fd_sc_hd__decap_3
XFILLER_92_461 VGND VGND VPWR VPWR sky130_fd_sc_hd__decap_3
XFILLER_25_517 VGND VGND VPWR VPWR sky130_fd_sc_hd__decap_3
XFILLER_37_377 VGND VGND VPWR VPWR sky130_fd_sc_hd__decap_3
XFILLER_37_399 VGND VGND VPWR VPWR sky130_fd_sc_hd__decap_3
XFILLER_64_174 VGND VGND VPWR VPWR sky130_fd_sc_hd__decap_3
XFILLER_92_494 VGND VGND VPWR VPWR sky130_fd_sc_hd__decap_3
XFILLER_40_509 VGND VGND VPWR VPWR sky130_fd_sc_hd__decap_3
XFILLER_52_347 VGND VGND VPWR VPWR sky130_fd_sc_hd__decap_3
X_4924_ _5117_/CLK _4924_/D VGND VGND VPWR VPWR _4924_/Q sky130_fd_sc_hd__dfxtp_2
XTAP_TAPCELL_ROW_35_534 VGND VPWR sky130_fd_sc_hd__tapvpwrvgnd_1
XFILLER_20_200 VGND VGND VPWR VPWR sky130_fd_sc_hd__decap_3
XFILLER_60_380 VGND VGND VPWR VPWR sky130_fd_sc_hd__decap_3
X_4855_ _5278_/Q _4275_/B _4854_/X _3366_/A VGND VGND VPWR VPWR _5278_/D sky130_fd_sc_hd__o211a_2
X_4786_ _4786_/A VGND VGND VPWR VPWR _4815_/A sky130_fd_sc_hd__inv_2
X_3806_ _3803_/A _3746_/Y _3803_/B _3805_/Y VGND VGND VPWR VPWR _4094_/B sky130_fd_sc_hd__a31o_2
X_3737_ _3829_/B _3739_/B VGND VGND VPWR VPWR _3740_/A sky130_fd_sc_hd__nor2_2
XFILLER_69_18 VGND VGND VPWR VPWR sky130_fd_sc_hd__fill_2
X_3668_ _3705_/A _3668_/B VGND VGND VPWR VPWR _3668_/X sky130_fd_sc_hd__or2_2
X_3599_ _3600_/A _3792_/B VGND VGND VPWR VPWR _4559_/S sky130_fd_sc_hd__nor2_2
X_2619_ _2620_/B VGND VGND VPWR VPWR _3824_/A sky130_fd_sc_hd__inv_2
X_5269_ _5270_/CLK _5269_/D VGND VGND VPWR VPWR _5269_/Q sky130_fd_sc_hd__dfxtp_2
XFILLER_28_300 VGND VGND VPWR VPWR sky130_fd_sc_hd__decap_3
XFILLER_28_333 VGND VGND VPWR VPWR sky130_fd_sc_hd__decap_3
XFILLER_68_480 VGND VGND VPWR VPWR sky130_fd_sc_hd__decap_3
XFILLER_28_355 VGND VGND VPWR VPWR sky130_fd_sc_hd__decap_3
XFILLER_55_152 VGND VGND VPWR VPWR sky130_fd_sc_hd__decap_3
XTAP_TAPCELL_ROW_87_1031 VGND VPWR sky130_fd_sc_hd__tapvpwrvgnd_1
XFILLER_16_528 VGND VGND VPWR VPWR sky130_fd_sc_hd__decap_3
XFILLER_28_377 VGND VGND VPWR VPWR sky130_fd_sc_hd__decap_3
XFILLER_43_303 VGND VGND VPWR VPWR sky130_fd_sc_hd__decap_3
XFILLER_43_314 VGND VGND VPWR VPWR sky130_fd_sc_hd__decap_3
XFILLER_83_483 VGND VGND VPWR VPWR sky130_fd_sc_hd__decap_3
XFILLER_43_358 VGND VGND VPWR VPWR sky130_fd_sc_hd__decap_3
XFILLER_70_122 VGND VGND VPWR VPWR sky130_fd_sc_hd__decap_3
XFILLER_34_32 VGND VGND VPWR VPWR sky130_fd_sc_hd__fill_2
XFILLER_11_222 VGND VGND VPWR VPWR sky130_fd_sc_hd__fill_2
XFILLER_51_391 VGND VGND VPWR VPWR sky130_fd_sc_hd__fill_1
XFILLER_11_277 VGND VGND VPWR VPWR sky130_fd_sc_hd__decap_3
Xwire146 _3786_/B VGND VGND VPWR VPWR _4397_/B sky130_fd_sc_hd__buf_8
XFILLER_50_75 VGND VGND VPWR VPWR sky130_fd_sc_hd__decap_3
XFILLER_78_200 VGND VGND VPWR VPWR sky130_fd_sc_hd__decap_3
XFILLER_3_498 VGND VGND VPWR VPWR sky130_fd_sc_hd__decap_3
XFILLER_78_222 VGND VGND VPWR VPWR sky130_fd_sc_hd__decap_3
XFILLER_38_108 VGND VGND VPWR VPWR sky130_fd_sc_hd__decap_3
XFILLER_66_406 VGND VGND VPWR VPWR sky130_fd_sc_hd__decap_3
XFILLER_59_480 VGND VGND VPWR VPWR sky130_fd_sc_hd__decap_3
XTAP_TAPCELL_ROW_77_935 VGND VPWR sky130_fd_sc_hd__tapvpwrvgnd_1
XFILLER_93_225 VGND VGND VPWR VPWR sky130_fd_sc_hd__fill_2
XFILLER_78_299 VGND VGND VPWR VPWR sky130_fd_sc_hd__fill_1
XFILLER_19_388 VGND VGND VPWR VPWR sky130_fd_sc_hd__decap_3
XFILLER_19_399 VGND VGND VPWR VPWR sky130_fd_sc_hd__fill_2
XFILLER_74_483 VGND VGND VPWR VPWR sky130_fd_sc_hd__decap_3
XFILLER_34_336 VGND VGND VPWR VPWR sky130_fd_sc_hd__fill_1
XFILLER_34_347 VGND VGND VPWR VPWR sky130_fd_sc_hd__decap_3
XFILLER_61_111 VGND VGND VPWR VPWR sky130_fd_sc_hd__fill_1
XFILLER_61_122 VGND VGND VPWR VPWR sky130_fd_sc_hd__fill_1
XFILLER_61_144 VGND VGND VPWR VPWR sky130_fd_sc_hd__decap_3
X_2970_ _2950_/X _2970_/A2 _2954_/Y _4902_/Q VGND VGND VPWR VPWR _4902_/D sky130_fd_sc_hd__a22o_2
XTAP_TAPCELL_ROW_32_504 VGND VPWR sky130_fd_sc_hd__tapvpwrvgnd_1
XFILLER_30_520 VGND VGND VPWR VPWR sky130_fd_sc_hd__decap_3
XFILLER_42_380 VGND VGND VPWR VPWR sky130_fd_sc_hd__decap_3
X_4640_ _4639_/Y _4613_/X _4681_/S VGND VGND VPWR VPWR _4640_/X sky130_fd_sc_hd__mux2_1
X_4571_ _4571_/A _4571_/B VGND VGND VPWR VPWR _4571_/X sky130_fd_sc_hd__or2_2
XTAP_TAPCELL_ROW_40_581 VGND VPWR sky130_fd_sc_hd__tapvpwrvgnd_1
X_3522_ _3520_/X _3521_/X _3733_/S VGND VGND VPWR VPWR _3522_/X sky130_fd_sc_hd__mux2_1
X_3453_ _5166_/Q _5147_/Q VGND VGND VPWR VPWR _3454_/B sky130_fd_sc_hd__or2_2
X_5123_ clkload6/A _5123_/D VGND VGND VPWR VPWR _5123_/Q sky130_fd_sc_hd__dfxtp_2
X_3384_ _5156_/Q _5153_/Q _3384_/C VGND VGND VPWR VPWR _3384_/X sky130_fd_sc_hd__and3_2
XFILLER_57_417 VGND VGND VPWR VPWR sky130_fd_sc_hd__fill_1
XFILLER_84_203 VGND VGND VPWR VPWR sky130_fd_sc_hd__decap_3
X_5054_ _5102_/CLK _5054_/D VGND VGND VPWR VPWR _5054_/Q sky130_fd_sc_hd__dfxtp_2
X_4005_ _3963_/A _3999_/X _4004_/X VGND VGND VPWR VPWR _4005_/Y sky130_fd_sc_hd__a21boi_2
XFILLER_52_100 VGND VGND VPWR VPWR sky130_fd_sc_hd__decap_3
XFILLER_25_358 VGND VGND VPWR VPWR sky130_fd_sc_hd__decap_3
XFILLER_65_494 VGND VGND VPWR VPWR sky130_fd_sc_hd__fill_1
XFILLER_80_486 VGND VGND VPWR VPWR sky130_fd_sc_hd__decap_3
XFILLER_33_380 VGND VGND VPWR VPWR sky130_fd_sc_hd__decap_3
X_4907_ _5111_/CLK _4907_/D VGND VGND VPWR VPWR _4907_/Q sky130_fd_sc_hd__dfxtp_2
X_4838_ _4821_/A _4822_/X _4827_/A _4829_/B _4836_/Y VGND VGND VPWR VPWR _4838_/X
+ sky130_fd_sc_hd__a311o_2
Xclkbuf_leaf_38_CLK clkbuf_leaf_5_CLK/A VGND VGND VPWR VPWR _5111_/CLK sky130_fd_sc_hd__clkbuf_8
X_4769_ _5162_/Q _4769_/B VGND VGND VPWR VPWR _4770_/B sky130_fd_sc_hd__nor2_2
XFILLER_20_12 VGND VGND VPWR VPWR sky130_fd_sc_hd__decap_3
XFILLER_4_218 VGND VGND VPWR VPWR sky130_fd_sc_hd__decap_3
XFILLER_0_402 VGND VGND VPWR VPWR sky130_fd_sc_hd__decap_3
XFILLER_0_446 VGND VGND VPWR VPWR sky130_fd_sc_hd__fill_2
XTAP_TAPCELL_ROW_93_1090 VGND VPWR sky130_fd_sc_hd__tapvpwrvgnd_1
XFILLER_88_553 VGND VGND VPWR VPWR sky130_fd_sc_hd__decap_3
XFILLER_48_417 VGND VGND VPWR VPWR sky130_fd_sc_hd__decap_3
XFILLER_75_203 VGND VGND VPWR VPWR sky130_fd_sc_hd__fill_2
XFILLER_75_225 VGND VGND VPWR VPWR sky130_fd_sc_hd__decap_3
XFILLER_28_130 VGND VGND VPWR VPWR sky130_fd_sc_hd__decap_3
XFILLER_75_247 VGND VGND VPWR VPWR sky130_fd_sc_hd__decap_3
XTAP_TAPCELL_ROW_74_905 VGND VPWR sky130_fd_sc_hd__tapvpwrvgnd_1
XFILLER_16_336 VGND VGND VPWR VPWR sky130_fd_sc_hd__decap_3
XFILLER_71_442 VGND VGND VPWR VPWR sky130_fd_sc_hd__decap_3
XFILLER_31_317 VGND VGND VPWR VPWR sky130_fd_sc_hd__decap_3
XFILLER_43_166 VGND VGND VPWR VPWR sky130_fd_sc_hd__fill_2
XFILLER_45_86 VGND VGND VPWR VPWR sky130_fd_sc_hd__fill_1
XTAP_TAPCELL_ROW_82_982 VGND VPWR sky130_fd_sc_hd__tapvpwrvgnd_1
XFILLER_43_188 VGND VGND VPWR VPWR sky130_fd_sc_hd__fill_1
Xclkbuf_leaf_29_CLK clkload0/A VGND VGND VPWR VPWR _5102_/CLK sky130_fd_sc_hd__clkbuf_8
XFILLER_6_69 VGND VGND VPWR VPWR sky130_fd_sc_hd__decap_3
XFILLER_79_520 VGND VGND VPWR VPWR sky130_fd_sc_hd__decap_3
XFILLER_20_6 VGND VGND VPWR VPWR sky130_fd_sc_hd__decap_3
XFILLER_39_439 VGND VGND VPWR VPWR sky130_fd_sc_hd__decap_3
XFILLER_66_214 VGND VGND VPWR VPWR sky130_fd_sc_hd__decap_3
XFILLER_19_163 VGND VGND VPWR VPWR sky130_fd_sc_hd__decap_3
XFILLER_47_461 VGND VGND VPWR VPWR sky130_fd_sc_hd__decap_3
XFILLER_81_206 VGND VGND VPWR VPWR sky130_fd_sc_hd__fill_2
XFILLER_47_494 VGND VGND VPWR VPWR sky130_fd_sc_hd__fill_2
XFILLER_62_431 VGND VGND VPWR VPWR sky130_fd_sc_hd__decap_3
XFILLER_81_239 VGND VGND VPWR VPWR sky130_fd_sc_hd__decap_3
XFILLER_34_144 VGND VGND VPWR VPWR sky130_fd_sc_hd__decap_3
X_2953_ _3192_/A _3210_/A VGND VGND VPWR VPWR _2954_/B sky130_fd_sc_hd__nor2_4
XTAP_TAPCELL_ROW_17_364 VGND VPWR sky130_fd_sc_hd__tapvpwrvgnd_1
XFILLER_30_361 VGND VGND VPWR VPWR sky130_fd_sc_hd__decap_3
X_2884_ _2887_/A _2884_/B VGND VGND VPWR VPWR _2884_/Y sky130_fd_sc_hd__nor2_2
X_4623_ _5236_/Q _4854_/B VGND VGND VPWR VPWR _4623_/Y sky130_fd_sc_hd__nand2_2
X_4554_ _4037_/B _4550_/X _4553_/X _4541_/X VGND VGND VPWR VPWR _4554_/X sky130_fd_sc_hd__a31o_2
X_3505_ _4298_/A _5159_/Q _4422_/S VGND VGND VPWR VPWR _3548_/B sky130_fd_sc_hd__mux2_1
X_4485_ _4305_/Y _4290_/Y _4515_/B VGND VGND VPWR VPWR _4485_/X sky130_fd_sc_hd__mux2_1
X_3436_ _5164_/Q _5145_/Q VGND VGND VPWR VPWR _3438_/B sky130_fd_sc_hd__or2_2
X_3367_ _3884_/D _5015_/Q _5017_/Q _5181_/Q VGND VGND VPWR VPWR _3367_/X sky130_fd_sc_hd__a22o_2
XFILLER_57_203 VGND VGND VPWR VPWR sky130_fd_sc_hd__fill_2
XFILLER_57_225 VGND VGND VPWR VPWR sky130_fd_sc_hd__decap_3
X_5106_ clkload7/A _5106_/D VGND VGND VPWR VPWR _5106_/Q sky130_fd_sc_hd__dfxtp_2
X_5037_ _5102_/CLK _5037_/D VGND VGND VPWR VPWR _5037_/Q sky130_fd_sc_hd__dfxtp_2
X_3298_ _3296_/Y _3301_/B _3305_/B VGND VGND VPWR VPWR _3298_/Y sky130_fd_sc_hd__o21ai_2
XFILLER_85_545 VGND VGND VPWR VPWR sky130_fd_sc_hd__decap_3
XFILLER_38_483 VGND VGND VPWR VPWR sky130_fd_sc_hd__decap_3
XFILLER_53_420 VGND VGND VPWR VPWR sky130_fd_sc_hd__decap_3
XTAP_TAPCELL_ROW_84_1001 VGND VPWR sky130_fd_sc_hd__tapvpwrvgnd_1
XFILLER_82_29 VGND VGND VPWR VPWR sky130_fd_sc_hd__fill_1
XFILLER_82_18 VGND VGND VPWR VPWR sky130_fd_sc_hd__fill_2
XFILLER_53_475 VGND VGND VPWR VPWR sky130_fd_sc_hd__decap_3
XFILLER_40_114 VGND VGND VPWR VPWR sky130_fd_sc_hd__decap_3
XFILLER_80_294 VGND VGND VPWR VPWR sky130_fd_sc_hd__decap_3
XFILLER_15_78 VGND VGND VPWR VPWR sky130_fd_sc_hd__decap_3
XFILLER_21_361 VGND VGND VPWR VPWR sky130_fd_sc_hd__decap_3
XTAP_TAPCELL_ROW_51_687 VGND VPWR sky130_fd_sc_hd__tapvpwrvgnd_1
XFILLER_5_505 VGND VGND VPWR VPWR sky130_fd_sc_hd__decap_3
XFILLER_31_55 VGND VGND VPWR VPWR sky130_fd_sc_hd__fill_1
XFILLER_31_66 VGND VGND VPWR VPWR sky130_fd_sc_hd__decap_3
XFILLER_31_88 VGND VGND VPWR VPWR sky130_fd_sc_hd__decap_3
Xoutput55 _5153_/Q VGND VGND VPWR VPWR INSTR_ADDR[0] sky130_fd_sc_hd__clkdlybuf4s25_1
Xoutput66 _5142_/Q VGND VGND VPWR VPWR INSTR_ADDR[5] sky130_fd_sc_hd__clkdlybuf4s25_1
XFILLER_0_243 VGND VGND VPWR VPWR sky130_fd_sc_hd__decap_3
Xoutput77 _2884_/Y VGND VGND VPWR VPWR MEM_ADDR[10] sky130_fd_sc_hd__clkdlybuf4s25_1
Xoutput88 _2873_/Y VGND VGND VPWR VPWR MEM_ADDR[6] sky130_fd_sc_hd__clkdlybuf4s25_1
Xoutput99 _2731_/X VGND VGND VPWR VPWR MEM_STR_DATA[1] sky130_fd_sc_hd__clkdlybuf4s25_1
XFILLER_88_350 VGND VGND VPWR VPWR sky130_fd_sc_hd__decap_3
XFILLER_0_265 VGND VGND VPWR VPWR sky130_fd_sc_hd__decap_3
XFILLER_0_287 VGND VGND VPWR VPWR sky130_fd_sc_hd__decap_3
XFILLER_0_298 VGND VGND VPWR VPWR sky130_fd_sc_hd__decap_3
XTAP_TAPCELL_ROW_59_765 VGND VPWR sky130_fd_sc_hd__tapvpwrvgnd_1
XFILLER_76_556 VGND VGND VPWR VPWR sky130_fd_sc_hd__fill_2
XFILLER_29_472 VGND VGND VPWR VPWR sky130_fd_sc_hd__fill_2
XFILLER_56_52 VGND VGND VPWR VPWR sky130_fd_sc_hd__fill_1
XFILLER_16_122 VGND VGND VPWR VPWR sky130_fd_sc_hd__decap_3
XFILLER_29_483 VGND VGND VPWR VPWR sky130_fd_sc_hd__decap_3
XFILLER_56_280 VGND VGND VPWR VPWR sky130_fd_sc_hd__decap_3
XFILLER_16_144 VGND VGND VPWR VPWR sky130_fd_sc_hd__decap_3
XFILLER_44_442 VGND VGND VPWR VPWR sky130_fd_sc_hd__decap_3
XFILLER_71_250 VGND VGND VPWR VPWR sky130_fd_sc_hd__decap_3
XFILLER_31_147 VGND VGND VPWR VPWR sky130_fd_sc_hd__decap_3
XTAP_TAPCELL_ROW_14_334 VGND VPWR sky130_fd_sc_hd__tapvpwrvgnd_1
XFILLER_31_169 VGND VGND VPWR VPWR sky130_fd_sc_hd__decap_3
XFILLER_8_343 VGND VGND VPWR VPWR sky130_fd_sc_hd__decap_3
X_4270_ _3848_/A _4278_/B _3885_/Y _4261_/A _4070_/B VGND VGND VPWR VPWR _4271_/B
+ sky130_fd_sc_hd__a221o_2
X_3221_ _2931_/X _3227_/A2 _3211_/Y _5120_/Q VGND VGND VPWR VPWR _5120_/D sky130_fd_sc_hd__a22o_2
XFILLER_86_309 VGND VGND VPWR VPWR sky130_fd_sc_hd__decap_3
XFILLER_79_361 VGND VGND VPWR VPWR sky130_fd_sc_hd__decap_3
XFILLER_39_214 VGND VGND VPWR VPWR sky130_fd_sc_hd__fill_1
Xclkbuf_leaf_9_CLK clkload1/A VGND VGND VPWR VPWR _5176_/CLK sky130_fd_sc_hd__clkbuf_8
X_3152_ _2941_/X _3155_/A2 _3139_/Y _5059_/Q VGND VGND VPWR VPWR _5059_/D sky130_fd_sc_hd__a22o_2
XFILLER_67_545 VGND VGND VPWR VPWR sky130_fd_sc_hd__fill_2
XFILLER_67_556 VGND VGND VPWR VPWR sky130_fd_sc_hd__fill_2
X_3083_ _3138_/A _3210_/B VGND VGND VPWR VPWR _3084_/B sky130_fd_sc_hd__nor2_4
XFILLER_82_548 VGND VGND VPWR VPWR sky130_fd_sc_hd__decap_3
XFILLER_35_464 VGND VGND VPWR VPWR sky130_fd_sc_hd__decap_3
XFILLER_35_497 VGND VGND VPWR VPWR sky130_fd_sc_hd__decap_3
XFILLER_50_401 VGND VGND VPWR VPWR sky130_fd_sc_hd__decap_3
XFILLER_62_272 VGND VGND VPWR VPWR sky130_fd_sc_hd__decap_3
XFILLER_22_136 VGND VGND VPWR VPWR sky130_fd_sc_hd__decap_3
XFILLER_22_147 VGND VGND VPWR VPWR sky130_fd_sc_hd__decap_3
X_3985_ _3986_/A _3986_/B VGND VGND VPWR VPWR _3985_/X sky130_fd_sc_hd__and2_2
XFILLER_10_309 VGND VGND VPWR VPWR sky130_fd_sc_hd__decap_3
XFILLER_50_489 VGND VGND VPWR VPWR sky130_fd_sc_hd__fill_1
X_2936_ _5277_/Q _5253_/Q _5205_/Q _5275_/Q VGND VGND VPWR VPWR _2936_/X sky130_fd_sc_hd__a22o_2
X_2867_ _2873_/A _2867_/B VGND VGND VPWR VPWR _2867_/Y sky130_fd_sc_hd__nor2_2
X_4606_ _3701_/A _4638_/S _3861_/Y VGND VGND VPWR VPWR _4606_/Y sky130_fd_sc_hd__o21ai_2
X_2798_ _5137_/Q _2795_/X _5138_/Q VGND VGND VPWR VPWR _2798_/X sky130_fd_sc_hd__o21a_2
X_4537_ _4437_/X _4536_/X _4532_/X _4526_/X VGND VGND VPWR VPWR _4537_/X sky130_fd_sc_hd__o211a_2
X_4468_ _4468_/A _4468_/B VGND VGND VPWR VPWR _4468_/Y sky130_fd_sc_hd__nand2_2
X_3419_ _5162_/Q _5143_/Q VGND VGND VPWR VPWR _3419_/X sky130_fd_sc_hd__and2_2
XFILLER_89_169 VGND VGND VPWR VPWR sky130_fd_sc_hd__decap_3
X_4399_ _4397_/B _4397_/C _4397_/D _4397_/A VGND VGND VPWR VPWR _4399_/X sky130_fd_sc_hd__a22o_2
XTAP_TAPCELL_ROW_90_1060 VGND VPWR sky130_fd_sc_hd__tapvpwrvgnd_1
XFILLER_85_353 VGND VGND VPWR VPWR sky130_fd_sc_hd__decap_3
XFILLER_73_526 VGND VGND VPWR VPWR sky130_fd_sc_hd__decap_3
XFILLER_85_386 VGND VGND VPWR VPWR sky130_fd_sc_hd__decap_3
XTAP_TAPCELL_ROW_56_735 VGND VPWR sky130_fd_sc_hd__tapvpwrvgnd_1
XFILLER_26_475 VGND VGND VPWR VPWR sky130_fd_sc_hd__fill_1
XFILLER_26_77 VGND VGND VPWR VPWR sky130_fd_sc_hd__decap_3
XFILLER_41_467 VGND VGND VPWR VPWR sky130_fd_sc_hd__decap_3
XFILLER_13_169 VGND VGND VPWR VPWR sky130_fd_sc_hd__fill_1
XFILLER_42_32 VGND VGND VPWR VPWR sky130_fd_sc_hd__decap_3
XTAP_TAPCELL_ROW_11_304 VGND VPWR sky130_fd_sc_hd__tapvpwrvgnd_1
XFILLER_5_302 VGND VGND VPWR VPWR sky130_fd_sc_hd__decap_3
XFILLER_5_346 VGND VGND VPWR VPWR sky130_fd_sc_hd__decap_3
XFILLER_1_541 VGND VGND VPWR VPWR sky130_fd_sc_hd__decap_3
XFILLER_68_309 VGND VGND VPWR VPWR sky130_fd_sc_hd__decap_3
XFILLER_76_386 VGND VGND VPWR VPWR sky130_fd_sc_hd__decap_3
XFILLER_64_548 VGND VGND VPWR VPWR sky130_fd_sc_hd__decap_3
XFILLER_91_334 VGND VGND VPWR VPWR sky130_fd_sc_hd__fill_2
XFILLER_17_442 VGND VGND VPWR VPWR sky130_fd_sc_hd__decap_3
XFILLER_32_401 VGND VGND VPWR VPWR sky130_fd_sc_hd__decap_3
X_3770_ _3891_/A _3770_/B VGND VGND VPWR VPWR _3894_/B sky130_fd_sc_hd__or2_2
X_2721_ _5138_/Q _2716_/X _2718_/X _2720_/X VGND VGND VPWR VPWR _4728_/B sky130_fd_sc_hd__a22o_2
XFILLER_66_3 VGND VGND VPWR VPWR sky130_fd_sc_hd__decap_3
X_2652_ _2650_/X _2651_/X _5129_/Q VGND VGND VPWR VPWR _2652_/X sky130_fd_sc_hd__mux2_1
XFILLER_8_184 VGND VGND VPWR VPWR sky130_fd_sc_hd__decap_3
X_2583_ _4953_/Q _4937_/Q _4921_/Q _4905_/Q _5127_/Q _5128_/Q VGND VGND VPWR VPWR
+ _2583_/X sky130_fd_sc_hd__mux4_2
X_4322_ _4356_/A _4322_/B VGND VGND VPWR VPWR _4327_/A sky130_fd_sc_hd__nand2_2
X_4253_ _4261_/C _4238_/X _4261_/D _4252_/X VGND VGND VPWR VPWR _4253_/X sky130_fd_sc_hd__o31a_2
X_3204_ _2934_/X _3193_/B _3193_/Y _5105_/Q VGND VGND VPWR VPWR _5105_/D sky130_fd_sc_hd__a22o_2
X_4184_ _4267_/S _3976_/C _4224_/B _4182_/X _4183_/X VGND VGND VPWR VPWR _4184_/X
+ sky130_fd_sc_hd__o311a_2
XFILLER_79_180 VGND VGND VPWR VPWR sky130_fd_sc_hd__decap_3
XFILLER_27_206 VGND VGND VPWR VPWR sky130_fd_sc_hd__decap_3
XFILLER_27_217 VGND VGND VPWR VPWR sky130_fd_sc_hd__decap_3
XFILLER_55_526 VGND VGND VPWR VPWR sky130_fd_sc_hd__decap_3
XFILLER_67_353 VGND VGND VPWR VPWR sky130_fd_sc_hd__decap_3
XFILLER_67_375 VGND VGND VPWR VPWR sky130_fd_sc_hd__decap_3
X_3135_ _2944_/X _3120_/Y _3121_/Y _5044_/Q VGND VGND VPWR VPWR _5044_/D sky130_fd_sc_hd__a22o_2
X_3066_ _3494_/A _3066_/B VGND VGND VPWR VPWR _3066_/Y sky130_fd_sc_hd__nor2_4
XFILLER_82_312 VGND VGND VPWR VPWR sky130_fd_sc_hd__decap_3
XTAP_TAPCELL_ROW_53_705 VGND VPWR sky130_fd_sc_hd__tapvpwrvgnd_1
XFILLER_35_261 VGND VGND VPWR VPWR sky130_fd_sc_hd__decap_3
XFILLER_82_389 VGND VGND VPWR VPWR sky130_fd_sc_hd__decap_3
XFILLER_23_445 VGND VGND VPWR VPWR sky130_fd_sc_hd__decap_3
X_3968_ _3862_/X _3851_/A _3969_/S VGND VGND VPWR VPWR _4076_/B sky130_fd_sc_hd__mux2_1
XFILLER_50_297 VGND VGND VPWR VPWR sky130_fd_sc_hd__decap_3
X_2919_ _4876_/Q _2942_/A2 _2918_/X _2951_/B2 VGND VGND VPWR VPWR _4876_/D sky130_fd_sc_hd__a22o_2
XTAP_TAPCELL_ROW_61_782 VGND VPWR sky130_fd_sc_hd__tapvpwrvgnd_1
X_3899_ _4390_/A _4346_/B _3905_/B VGND VGND VPWR VPWR _3899_/X sky130_fd_sc_hd__mux2_1
XFILLER_77_128 VGND VGND VPWR VPWR sky130_fd_sc_hd__decap_3
XFILLER_58_320 VGND VGND VPWR VPWR sky130_fd_sc_hd__decap_3
XTAP_TAPCELL_ROW_69_860 VGND VPWR sky130_fd_sc_hd__tapvpwrvgnd_1
XFILLER_92_109 VGND VGND VPWR VPWR sky130_fd_sc_hd__decap_3
XFILLER_53_53 VGND VGND VPWR VPWR sky130_fd_sc_hd__decap_3
XFILLER_78_50 VGND VGND VPWR VPWR sky130_fd_sc_hd__decap_3
XFILLER_68_117 VGND VGND VPWR VPWR sky130_fd_sc_hd__decap_3
XFILLER_78_94 VGND VGND VPWR VPWR sky130_fd_sc_hd__fill_1
XFILLER_49_364 VGND VGND VPWR VPWR sky130_fd_sc_hd__decap_3
XFILLER_64_312 VGND VGND VPWR VPWR sky130_fd_sc_hd__decap_3
X_4940_ _5111_/CLK _4940_/D VGND VGND VPWR VPWR _4940_/Q sky130_fd_sc_hd__dfxtp_2
XFILLER_91_175 VGND VGND VPWR VPWR sky130_fd_sc_hd__fill_1
X_4871_ _5083_/CLK _4871_/D VGND VGND VPWR VPWR _4871_/Q sky130_fd_sc_hd__dfxtp_2
XFILLER_32_253 VGND VGND VPWR VPWR sky130_fd_sc_hd__fill_1
X_3822_ _3820_/A _3820_/B _3821_/X VGND VGND VPWR VPWR _3958_/B sky130_fd_sc_hd__o21a_2
XFILLER_32_286 VGND VGND VPWR VPWR sky130_fd_sc_hd__decap_3
XFILLER_20_459 VGND VGND VPWR VPWR sky130_fd_sc_hd__fill_2
X_3753_ _3773_/A _4310_/A VGND VGND VPWR VPWR _4309_/S sky130_fd_sc_hd__or2_2
X_3684_ _5121_/Q _5009_/Q _4993_/Q _4977_/Q _3732_/S0 _3732_/S1 VGND VGND VPWR VPWR
+ _3684_/X sky130_fd_sc_hd__mux4_2
X_2704_ _4236_/A _2707_/C _2707_/D VGND VGND VPWR VPWR _2705_/B sky130_fd_sc_hd__and3_2
XTAP_TAPCELL_ROW_30_487 VGND VPWR sky130_fd_sc_hd__tapvpwrvgnd_1
X_2635_ _2660_/A _2634_/X _5130_/Q VGND VGND VPWR VPWR _2635_/X sky130_fd_sc_hd__o21a_2
X_4305_ _3600_/A _4449_/S _4098_/Y VGND VGND VPWR VPWR _4305_/Y sky130_fd_sc_hd__o21ai_2
X_2566_ _5160_/Q _4393_/D VGND VGND VPWR VPWR _4528_/S sky130_fd_sc_hd__nor2_2
X_5285_ _5285_/CLK _5285_/D VGND VGND VPWR VPWR _5285_/Q sky130_fd_sc_hd__dfxtp_2
X_2497_ _2660_/A _2497_/B VGND VGND VPWR VPWR _2497_/X sky130_fd_sc_hd__or2_2
XFILLER_87_426 VGND VGND VPWR VPWR sky130_fd_sc_hd__decap_3
XFILLER_4_91 VGND VGND VPWR VPWR sky130_fd_sc_hd__decap_3
X_4236_ _4236_/A _4236_/B _4236_/C VGND VGND VPWR VPWR _4236_/Y sky130_fd_sc_hd__nand3_2
XFILLER_28_515 VGND VGND VPWR VPWR sky130_fd_sc_hd__decap_3
XFILLER_55_301 VGND VGND VPWR VPWR sky130_fd_sc_hd__decap_3
X_4167_ _3689_/X _4157_/X _4200_/A VGND VGND VPWR VPWR _4168_/C sky130_fd_sc_hd__a21o_2
XFILLER_28_548 VGND VGND VPWR VPWR sky130_fd_sc_hd__decap_3
XFILLER_67_161 VGND VGND VPWR VPWR sky130_fd_sc_hd__decap_3
X_3118_ _2947_/X _3103_/B _3103_/Y _5029_/Q VGND VGND VPWR VPWR _5029_/D sky130_fd_sc_hd__a22o_2
XTAP_TAPCELL_ROW_66_830 VGND VPWR sky130_fd_sc_hd__tapvpwrvgnd_1
XFILLER_55_367 VGND VGND VPWR VPWR sky130_fd_sc_hd__decap_3
X_4098_ _3825_/B _4449_/S VGND VGND VPWR VPWR _4098_/Y sky130_fd_sc_hd__nand2b_2
XFILLER_82_153 VGND VGND VPWR VPWR sky130_fd_sc_hd__decap_3
XFILLER_43_518 VGND VGND VPWR VPWR sky130_fd_sc_hd__decap_3
XFILLER_70_315 VGND VGND VPWR VPWR sky130_fd_sc_hd__decap_3
X_3049_ _2897_/X _3048_/B _3048_/Y _4967_/Q VGND VGND VPWR VPWR _4967_/D sky130_fd_sc_hd__a22o_2
XTAP_TAPCELL_ROW_38_565 VGND VPWR sky130_fd_sc_hd__tapvpwrvgnd_1
XFILLER_82_197 VGND VGND VPWR VPWR sky130_fd_sc_hd__decap_3
XFILLER_2_102 VGND VGND VPWR VPWR sky130_fd_sc_hd__fill_1
XFILLER_78_415 VGND VGND VPWR VPWR sky130_fd_sc_hd__decap_3
XFILLER_78_448 VGND VGND VPWR VPWR sky130_fd_sc_hd__decap_3
XFILLER_48_75 VGND VGND VPWR VPWR sky130_fd_sc_hd__decap_3
XFILLER_19_526 VGND VGND VPWR VPWR sky130_fd_sc_hd__fill_2
XFILLER_46_312 VGND VGND VPWR VPWR sky130_fd_sc_hd__decap_3
XFILLER_0_27 VGND VGND VPWR VPWR sky130_fd_sc_hd__fill_1
XFILLER_0_38 VGND VGND VPWR VPWR sky130_fd_sc_hd__fill_1
XFILLER_73_153 VGND VGND VPWR VPWR sky130_fd_sc_hd__decap_3
XFILLER_34_518 VGND VGND VPWR VPWR sky130_fd_sc_hd__decap_3
XFILLER_46_389 VGND VGND VPWR VPWR sky130_fd_sc_hd__decap_3
XFILLER_61_315 VGND VGND VPWR VPWR sky130_fd_sc_hd__decap_3
XFILLER_64_63 VGND VGND VPWR VPWR sky130_fd_sc_hd__decap_3
XFILLER_14_220 VGND VGND VPWR VPWR sky130_fd_sc_hd__decap_3
XFILLER_61_337 VGND VGND VPWR VPWR sky130_fd_sc_hd__decap_3
XFILLER_61_359 VGND VGND VPWR VPWR sky130_fd_sc_hd__decap_3
XFILLER_64_85 VGND VGND VPWR VPWR sky130_fd_sc_hd__decap_3
XFILLER_42_551 VGND VGND VPWR VPWR sky130_fd_sc_hd__decap_3
XTAP_TAPCELL_ROW_72_888 VGND VPWR sky130_fd_sc_hd__tapvpwrvgnd_1
XFILLER_10_470 VGND VGND VPWR VPWR sky130_fd_sc_hd__decap_3
XFILLER_10_492 VGND VGND VPWR VPWR sky130_fd_sc_hd__decap_3
XFILLER_6_430 VGND VGND VPWR VPWR sky130_fd_sc_hd__decap_3
XFILLER_6_463 VGND VGND VPWR VPWR sky130_fd_sc_hd__fill_2
XFILLER_89_60 VGND VGND VPWR VPWR sky130_fd_sc_hd__decap_3
X_5070_ _5102_/CLK _5070_/D VGND VGND VPWR VPWR _5070_/Q sky130_fd_sc_hd__dfxtp_2
XTAP_TAPCELL_ROW_9_290 VGND VPWR sky130_fd_sc_hd__tapvpwrvgnd_1
XFILLER_29_3 VGND VGND VPWR VPWR sky130_fd_sc_hd__decap_3
X_4021_ _4022_/A _4021_/B VGND VGND VPWR VPWR _4550_/B sky130_fd_sc_hd__or2_2
XFILLER_37_323 VGND VGND VPWR VPWR sky130_fd_sc_hd__decap_3
XFILLER_49_172 VGND VGND VPWR VPWR sky130_fd_sc_hd__decap_3
XFILLER_37_345 VGND VGND VPWR VPWR sky130_fd_sc_hd__decap_3
XFILLER_92_440 VGND VGND VPWR VPWR sky130_fd_sc_hd__decap_3
XFILLER_52_315 VGND VGND VPWR VPWR sky130_fd_sc_hd__decap_3
XFILLER_64_153 VGND VGND VPWR VPWR sky130_fd_sc_hd__decap_3
XTAP_TAPCELL_ROW_63_800 VGND VPWR sky130_fd_sc_hd__tapvpwrvgnd_1
XFILLER_52_337 VGND VGND VPWR VPWR sky130_fd_sc_hd__fill_2
X_4923_ clkload9/A _4923_/D VGND VGND VPWR VPWR _4923_/Q sky130_fd_sc_hd__dfxtp_2
XTAP_TAPCELL_ROW_35_535 VGND VPWR sky130_fd_sc_hd__tapvpwrvgnd_1
XFILLER_20_212 VGND VGND VPWR VPWR sky130_fd_sc_hd__decap_3
X_4854_ _4854_/A _4854_/B VGND VGND VPWR VPWR _4854_/X sky130_fd_sc_hd__or2_2
XFILLER_20_256 VGND VGND VPWR VPWR sky130_fd_sc_hd__decap_3
X_4785_ _4785_/A _4785_/B VGND VGND VPWR VPWR _4786_/A sky130_fd_sc_hd__nor2_2
X_3805_ _4079_/A _3792_/B _4090_/A _3791_/Y VGND VGND VPWR VPWR _3805_/Y sky130_fd_sc_hd__o31ai_2
X_3736_ _3829_/B _3739_/B VGND VGND VPWR VPWR _3803_/A sky130_fd_sc_hd__nand2b_2
X_3667_ _4898_/Q _4882_/Q _5106_/Q _5090_/Q _3706_/S0 _3706_/S1 VGND VGND VPWR VPWR
+ _3668_/B sky130_fd_sc_hd__mux4_2
X_3598_ _3592_/X _3594_/X _3597_/X _2430_/Y VGND VGND VPWR VPWR _3792_/B sky130_fd_sc_hd__a22o_2
X_2618_ _5159_/Q _3741_/A VGND VGND VPWR VPWR _2620_/B sky130_fd_sc_hd__nand2_2
X_2549_ _4956_/Q _4940_/Q _4924_/Q _4908_/Q _5127_/Q _5128_/Q VGND VGND VPWR VPWR
+ _2549_/X sky130_fd_sc_hd__mux4_2
XFILLER_87_201 VGND VGND VPWR VPWR sky130_fd_sc_hd__decap_3
X_5268_ _5270_/CLK _5268_/D VGND VGND VPWR VPWR _5268_/Q sky130_fd_sc_hd__dfxtp_2
XFILLER_75_407 VGND VGND VPWR VPWR sky130_fd_sc_hd__decap_3
XFILLER_75_418 VGND VGND VPWR VPWR sky130_fd_sc_hd__decap_3
X_4219_ _4219_/A _4219_/B _4217_/X VGND VGND VPWR VPWR _4227_/A sky130_fd_sc_hd__or3b_2
XFILLER_87_267 VGND VGND VPWR VPWR sky130_fd_sc_hd__decap_3
XFILLER_85_18 VGND VGND VPWR VPWR sky130_fd_sc_hd__fill_2
XFILLER_68_470 VGND VGND VPWR VPWR sky130_fd_sc_hd__decap_3
X_5199_ _5260_/CLK _5199_/D VGND VGND VPWR VPWR _5199_/Q sky130_fd_sc_hd__dfxtp_2
XFILLER_55_131 VGND VGND VPWR VPWR sky130_fd_sc_hd__decap_3
XTAP_TAPCELL_ROW_87_1032 VGND VPWR sky130_fd_sc_hd__tapvpwrvgnd_1
XFILLER_28_389 VGND VGND VPWR VPWR sky130_fd_sc_hd__decap_3
XFILLER_43_326 VGND VGND VPWR VPWR sky130_fd_sc_hd__decap_3
XFILLER_55_164 VGND VGND VPWR VPWR sky130_fd_sc_hd__decap_3
XFILLER_83_462 VGND VGND VPWR VPWR sky130_fd_sc_hd__decap_3
XFILLER_43_337 VGND VGND VPWR VPWR sky130_fd_sc_hd__decap_3
XFILLER_55_186 VGND VGND VPWR VPWR sky130_fd_sc_hd__decap_3
XFILLER_24_551 VGND VGND VPWR VPWR sky130_fd_sc_hd__decap_3
XFILLER_70_156 VGND VGND VPWR VPWR sky130_fd_sc_hd__fill_2
XFILLER_51_370 VGND VGND VPWR VPWR sky130_fd_sc_hd__decap_3
XFILLER_11_256 VGND VGND VPWR VPWR sky130_fd_sc_hd__decap_3
XFILLER_50_32 VGND VGND VPWR VPWR sky130_fd_sc_hd__decap_3
Xwire136 _2713_/Y VGND VGND VPWR VPWR _2857_/A sky130_fd_sc_hd__clkbuf_4
XFILLER_7_216 VGND VGND VPWR VPWR sky130_fd_sc_hd__decap_3
XFILLER_59_52 VGND VGND VPWR VPWR sky130_fd_sc_hd__decap_3
XFILLER_78_234 VGND VGND VPWR VPWR sky130_fd_sc_hd__decap_3
XFILLER_59_96 VGND VGND VPWR VPWR sky130_fd_sc_hd__decap_3
XFILLER_66_418 VGND VGND VPWR VPWR sky130_fd_sc_hd__fill_2
XTAP_TAPCELL_ROW_6_260 VGND VPWR sky130_fd_sc_hd__tapvpwrvgnd_1
XFILLER_78_256 VGND VGND VPWR VPWR sky130_fd_sc_hd__decap_3
XFILLER_15_9 VGND VGND VPWR VPWR sky130_fd_sc_hd__fill_1
XFILLER_59_492 VGND VGND VPWR VPWR sky130_fd_sc_hd__decap_3
XFILLER_66_429 VGND VGND VPWR VPWR sky130_fd_sc_hd__decap_3
XTAP_TAPCELL_ROW_77_936 VGND VPWR sky130_fd_sc_hd__tapvpwrvgnd_1
XFILLER_19_334 VGND VGND VPWR VPWR sky130_fd_sc_hd__fill_2
XFILLER_74_451 VGND VGND VPWR VPWR sky130_fd_sc_hd__decap_3
XFILLER_34_315 VGND VGND VPWR VPWR sky130_fd_sc_hd__fill_1
XFILLER_74_473 VGND VGND VPWR VPWR sky130_fd_sc_hd__decap_3
XFILLER_75_95 VGND VGND VPWR VPWR sky130_fd_sc_hd__fill_2
XFILLER_46_197 VGND VGND VPWR VPWR sky130_fd_sc_hd__fill_2
XFILLER_74_495 VGND VGND VPWR VPWR sky130_fd_sc_hd__fill_2
XFILLER_15_551 VGND VGND VPWR VPWR sky130_fd_sc_hd__decap_3
XFILLER_61_156 VGND VGND VPWR VPWR sky130_fd_sc_hd__decap_3
XFILLER_61_178 VGND VGND VPWR VPWR sky130_fd_sc_hd__decap_3
XTAP_TAPCELL_ROW_32_505 VGND VPWR sky130_fd_sc_hd__tapvpwrvgnd_1
X_4570_ _4568_/X _4569_/Y _4692_/A VGND VGND VPWR VPWR _5232_/D sky130_fd_sc_hd__a21oi_2
X_3521_ _5112_/Q _5000_/Q _4984_/Q _4968_/Q _3732_/S0 _3732_/S1 VGND VGND VPWR VPWR
+ _3521_/X sky130_fd_sc_hd__mux4_2
XTAP_TAPCELL_ROW_40_582 VGND VPWR sky130_fd_sc_hd__tapvpwrvgnd_1
XFILLER_6_293 VGND VGND VPWR VPWR sky130_fd_sc_hd__fill_2
X_3452_ _5166_/Q _5147_/Q VGND VGND VPWR VPWR _3454_/A sky130_fd_sc_hd__nand2_2
X_3383_ _4732_/A _5154_/Q VGND VGND VPWR VPWR _3384_/C sky130_fd_sc_hd__xor2_2
X_5122_ clkload3/A _5122_/D VGND VGND VPWR VPWR _5122_/Q sky130_fd_sc_hd__dfxtp_2
XFILLER_69_278 VGND VGND VPWR VPWR sky130_fd_sc_hd__fill_2
XFILLER_57_429 VGND VGND VPWR VPWR sky130_fd_sc_hd__decap_3
X_5053_ _5069_/CLK _5053_/D VGND VGND VPWR VPWR _5053_/Q sky130_fd_sc_hd__dfxtp_2
XFILLER_37_131 VGND VGND VPWR VPWR sky130_fd_sc_hd__decap_3
X_4004_ _3616_/A _4379_/A _4001_/X _4003_/X VGND VGND VPWR VPWR _4004_/X sky130_fd_sc_hd__o211a_2
XTAP_TAPCELL_ROW_48_660 VGND VPWR sky130_fd_sc_hd__tapvpwrvgnd_1
XFILLER_25_326 VGND VGND VPWR VPWR sky130_fd_sc_hd__decap_3
XFILLER_52_112 VGND VGND VPWR VPWR sky130_fd_sc_hd__fill_2
XFILLER_92_292 VGND VGND VPWR VPWR sky130_fd_sc_hd__decap_3
XFILLER_80_432 VGND VGND VPWR VPWR sky130_fd_sc_hd__decap_3
XFILLER_21_510 VGND VGND VPWR VPWR sky130_fd_sc_hd__decap_3
X_4906_ _5111_/CLK _4906_/D VGND VGND VPWR VPWR _4906_/Q sky130_fd_sc_hd__dfxtp_2
XFILLER_80_498 VGND VGND VPWR VPWR sky130_fd_sc_hd__decap_3
X_4837_ _4821_/A _4822_/X _4827_/A _4829_/B VGND VGND VPWR VPWR _4839_/B sky130_fd_sc_hd__a31o_2
X_4768_ _5162_/Q _4769_/B VGND VGND VPWR VPWR _4770_/A sky130_fd_sc_hd__and2_2
XFILLER_20_24 VGND VGND VPWR VPWR sky130_fd_sc_hd__decap_3
X_4699_ _5244_/Q _4725_/B VGND VGND VPWR VPWR _4699_/X sky130_fd_sc_hd__or2_2
X_3719_ _5133_/Q _3716_/X _5134_/Q VGND VGND VPWR VPWR _3719_/X sky130_fd_sc_hd__o21a_2
XFILLER_20_35 VGND VGND VPWR VPWR sky130_fd_sc_hd__decap_3
XFILLER_0_414 VGND VGND VPWR VPWR sky130_fd_sc_hd__decap_3
XTAP_TAPCELL_ROW_93_1091 VGND VPWR sky130_fd_sc_hd__tapvpwrvgnd_1
XFILLER_56_440 VGND VGND VPWR VPWR sky130_fd_sc_hd__decap_3
XFILLER_75_259 VGND VGND VPWR VPWR sky130_fd_sc_hd__decap_3
XTAP_TAPCELL_ROW_74_906 VGND VPWR sky130_fd_sc_hd__tapvpwrvgnd_1
XTAP_TAPCELL_ROW_3_230 VGND VPWR sky130_fd_sc_hd__tapvpwrvgnd_1
XFILLER_16_348 VGND VGND VPWR VPWR sky130_fd_sc_hd__decap_3
XFILLER_28_197 VGND VGND VPWR VPWR sky130_fd_sc_hd__decap_3
XFILLER_71_421 VGND VGND VPWR VPWR sky130_fd_sc_hd__decap_3
XFILLER_83_281 VGND VGND VPWR VPWR sky130_fd_sc_hd__decap_3
XFILLER_31_307 VGND VGND VPWR VPWR sky130_fd_sc_hd__fill_2
XTAP_TAPCELL_ROW_82_983 VGND VPWR sky130_fd_sc_hd__tapvpwrvgnd_1
XFILLER_61_42 VGND VGND VPWR VPWR sky130_fd_sc_hd__decap_3
XFILLER_8_536 VGND VGND VPWR VPWR sky130_fd_sc_hd__decap_3
XFILLER_6_26 VGND VGND VPWR VPWR sky130_fd_sc_hd__fill_2
XFILLER_3_274 VGND VGND VPWR VPWR sky130_fd_sc_hd__decap_3
XFILLER_66_226 VGND VGND VPWR VPWR sky130_fd_sc_hd__decap_3
XFILLER_86_83 VGND VGND VPWR VPWR sky130_fd_sc_hd__fill_1
XFILLER_13_6 VGND VGND VPWR VPWR sky130_fd_sc_hd__fill_1
XFILLER_47_440 VGND VGND VPWR VPWR sky130_fd_sc_hd__decap_3
XFILLER_47_473 VGND VGND VPWR VPWR sky130_fd_sc_hd__decap_3
XFILLER_62_421 VGND VGND VPWR VPWR sky130_fd_sc_hd__fill_1
XTAP_TAPCELL_ROW_45_630 VGND VPWR sky130_fd_sc_hd__tapvpwrvgnd_1
XFILLER_62_443 VGND VGND VPWR VPWR sky130_fd_sc_hd__decap_3
XFILLER_22_318 VGND VGND VPWR VPWR sky130_fd_sc_hd__decap_3
XFILLER_62_487 VGND VGND VPWR VPWR sky130_fd_sc_hd__decap_3
X_2952_ _5191_/Q _5190_/Q VGND VGND VPWR VPWR _3210_/A sky130_fd_sc_hd__or2_2
XTAP_TAPCELL_ROW_17_365 VGND VPWR sky130_fd_sc_hd__tapvpwrvgnd_1
XFILLER_30_373 VGND VGND VPWR VPWR sky130_fd_sc_hd__fill_1
X_2883_ _3838_/A _2883_/B VGND VGND VPWR VPWR _2884_/B sky130_fd_sc_hd__xnor2_2
XFILLER_30_395 VGND VGND VPWR VPWR sky130_fd_sc_hd__decap_3
X_4622_ _4152_/Y _4616_/X _4621_/X _4541_/X VGND VGND VPWR VPWR _4622_/X sky130_fd_sc_hd__a31o_2
X_4553_ _4312_/Y _4551_/X _4552_/X _4312_/A VGND VGND VPWR VPWR _4553_/X sky130_fd_sc_hd__a22o_2
X_4484_ _4482_/X _4564_/A _4572_/S VGND VGND VPWR VPWR _4484_/X sky130_fd_sc_hd__mux2_1
X_3504_ _3498_/X _3500_/X _3503_/X _2430_/Y VGND VGND VPWR VPWR _4298_/A sky130_fd_sc_hd__a22o_2
X_3435_ _5164_/Q _5145_/Q VGND VGND VPWR VPWR _3438_/A sky130_fd_sc_hd__nand2_2
XFILLER_89_318 VGND VGND VPWR VPWR sky130_fd_sc_hd__decap_3
X_3366_ _3366_/A _3366_/B _3366_/C VGND VGND VPWR VPWR _5188_/D sky130_fd_sc_hd__and3_2
X_5105_ _5105_/CLK _5105_/D VGND VGND VPWR VPWR _5105_/Q sky130_fd_sc_hd__dfxtp_2
X_3297_ _5149_/Q _3297_/B _3307_/D VGND VGND VPWR VPWR _3301_/B sky130_fd_sc_hd__and3_2
XFILLER_85_524 VGND VGND VPWR VPWR sky130_fd_sc_hd__decap_3
X_5036_ _5114_/CLK _5036_/D VGND VGND VPWR VPWR _5036_/Q sky130_fd_sc_hd__dfxtp_2
XFILLER_85_557 VGND VGND VPWR VPWR sky130_fd_sc_hd__fill_1
XFILLER_38_462 VGND VGND VPWR VPWR sky130_fd_sc_hd__decap_3
XFILLER_72_207 VGND VGND VPWR VPWR sky130_fd_sc_hd__fill_1
XFILLER_72_218 VGND VGND VPWR VPWR sky130_fd_sc_hd__decap_3
XTAP_TAPCELL_ROW_0_200 VGND VPWR sky130_fd_sc_hd__tapvpwrvgnd_1
XFILLER_65_281 VGND VGND VPWR VPWR sky130_fd_sc_hd__decap_3
XTAP_TAPCELL_ROW_84_1002 VGND VPWR sky130_fd_sc_hd__tapvpwrvgnd_1
XFILLER_13_307 VGND VGND VPWR VPWR sky130_fd_sc_hd__decap_3
XFILLER_15_24 VGND VGND VPWR VPWR sky130_fd_sc_hd__decap_3
XFILLER_15_57 VGND VGND VPWR VPWR sky130_fd_sc_hd__decap_3
XFILLER_25_178 VGND VGND VPWR VPWR sky130_fd_sc_hd__decap_3
XFILLER_80_273 VGND VGND VPWR VPWR sky130_fd_sc_hd__decap_3
XTAP_TAPCELL_ROW_51_688 VGND VPWR sky130_fd_sc_hd__tapvpwrvgnd_1
XFILLER_31_12 VGND VGND VPWR VPWR sky130_fd_sc_hd__decap_3
XFILLER_5_539 VGND VGND VPWR VPWR sky130_fd_sc_hd__decap_3
XFILLER_0_200 VGND VGND VPWR VPWR sky130_fd_sc_hd__decap_3
Xoutput56 _5147_/Q VGND VGND VPWR VPWR INSTR_ADDR[10] sky130_fd_sc_hd__clkdlybuf4s25_1
Xoutput67 _5143_/Q VGND VGND VPWR VPWR INSTR_ADDR[6] sky130_fd_sc_hd__clkdlybuf4s25_1
Xoutput78 _2887_/Y VGND VGND VPWR VPWR MEM_ADDR[11] sky130_fd_sc_hd__clkdlybuf4s25_1
Xoutput89 _2876_/Y VGND VGND VPWR VPWR MEM_ADDR[7] sky130_fd_sc_hd__clkdlybuf4s25_1
XFILLER_0_277 VGND VGND VPWR VPWR sky130_fd_sc_hd__decap_3
XFILLER_88_384 VGND VGND VPWR VPWR sky130_fd_sc_hd__decap_3
XTAP_TAPCELL_ROW_59_766 VGND VPWR sky130_fd_sc_hd__tapvpwrvgnd_1
XFILLER_91_505 VGND VGND VPWR VPWR sky130_fd_sc_hd__decap_3
XFILLER_56_292 VGND VGND VPWR VPWR sky130_fd_sc_hd__decap_3
XFILLER_44_454 VGND VGND VPWR VPWR sky130_fd_sc_hd__decap_3
XFILLER_16_178 VGND VGND VPWR VPWR sky130_fd_sc_hd__fill_1
XFILLER_31_104 VGND VGND VPWR VPWR sky130_fd_sc_hd__decap_3
XFILLER_44_498 VGND VGND VPWR VPWR sky130_fd_sc_hd__decap_3
XFILLER_71_273 VGND VGND VPWR VPWR sky130_fd_sc_hd__decap_3
XFILLER_71_284 VGND VGND VPWR VPWR sky130_fd_sc_hd__decap_3
XTAP_TAPCELL_ROW_42_600 VGND VPWR sky130_fd_sc_hd__tapvpwrvgnd_1
XFILLER_31_159 VGND VGND VPWR VPWR sky130_fd_sc_hd__decap_3
XTAP_TAPCELL_ROW_14_335 VGND VPWR sky130_fd_sc_hd__tapvpwrvgnd_1
XFILLER_12_351 VGND VGND VPWR VPWR sky130_fd_sc_hd__decap_3
XFILLER_82_9 VGND VGND VPWR VPWR sky130_fd_sc_hd__decap_3
XFILLER_12_373 VGND VGND VPWR VPWR sky130_fd_sc_hd__decap_3
X_3220_ _2927_/X _3211_/B _3211_/Y _5119_/Q VGND VGND VPWR VPWR _5119_/D sky130_fd_sc_hd__a22o_2
XFILLER_79_340 VGND VGND VPWR VPWR sky130_fd_sc_hd__decap_3
XFILLER_67_502 VGND VGND VPWR VPWR sky130_fd_sc_hd__fill_2
XFILLER_67_524 VGND VGND VPWR VPWR sky130_fd_sc_hd__decap_3
X_3151_ _2937_/X _3155_/A2 _3139_/Y _5058_/Q VGND VGND VPWR VPWR _5058_/D sky130_fd_sc_hd__a22o_2
XFILLER_79_373 VGND VGND VPWR VPWR sky130_fd_sc_hd__decap_3
XFILLER_11_3 VGND VGND VPWR VPWR sky130_fd_sc_hd__decap_3
XFILLER_54_218 VGND VGND VPWR VPWR sky130_fd_sc_hd__decap_3
X_3082_ _2950_/X _3066_/B _3066_/Y _4998_/Q VGND VGND VPWR VPWR _4998_/D sky130_fd_sc_hd__a22o_2
XFILLER_35_432 VGND VGND VPWR VPWR sky130_fd_sc_hd__decap_3
XFILLER_47_292 VGND VGND VPWR VPWR sky130_fd_sc_hd__decap_3
XFILLER_82_538 VGND VGND VPWR VPWR sky130_fd_sc_hd__fill_1
XFILLER_22_115 VGND VGND VPWR VPWR sky130_fd_sc_hd__decap_3
XFILLER_50_413 VGND VGND VPWR VPWR sky130_fd_sc_hd__decap_3
XFILLER_62_284 VGND VGND VPWR VPWR sky130_fd_sc_hd__decap_3
X_3984_ _5213_/Q _4275_/B _3983_/Y _3366_/A VGND VGND VPWR VPWR _5213_/D sky130_fd_sc_hd__o211a_2
X_2935_ _4881_/Q _2942_/A2 _2934_/X _2951_/B2 VGND VGND VPWR VPWR _4881_/D sky130_fd_sc_hd__a22o_2
X_2866_ _2866_/A _3958_/A VGND VGND VPWR VPWR _2867_/B sky130_fd_sc_hd__xnor2_2
X_4605_ _4225_/A _3859_/X _4312_/Y _4453_/X _4604_/X VGND VGND VPWR VPWR _4605_/X
+ sky130_fd_sc_hd__o221a_2
X_2797_ _2832_/A _2797_/B VGND VGND VPWR VPWR _2797_/X sky130_fd_sc_hd__or2_2
XFILLER_2_509 VGND VGND VPWR VPWR sky130_fd_sc_hd__decap_3
X_4536_ _4534_/X _4595_/C _4682_/S VGND VGND VPWR VPWR _4536_/X sky130_fd_sc_hd__mux2_1
X_4467_ _4467_/A _4467_/B VGND VGND VPWR VPWR _4468_/B sky130_fd_sc_hd__xnor2_2
X_4398_ _4397_/B _4397_/C _4397_/D _4397_/A VGND VGND VPWR VPWR _4398_/X sky130_fd_sc_hd__o22a_2
X_3418_ _3494_/A _3418_/B VGND VGND VPWR VPWR _5199_/D sky130_fd_sc_hd__nor2_2
XFILLER_77_19 VGND VGND VPWR VPWR sky130_fd_sc_hd__decap_3
X_3349_ _5184_/Q _3230_/B _3230_/Y _3348_/X VGND VGND VPWR VPWR _5184_/D sky130_fd_sc_hd__o22a_2
XTAP_TAPCELL_ROW_90_1061 VGND VPWR sky130_fd_sc_hd__tapvpwrvgnd_1
XFILLER_58_546 VGND VGND VPWR VPWR sky130_fd_sc_hd__decap_3
XFILLER_73_505 VGND VGND VPWR VPWR sky130_fd_sc_hd__decap_3
XFILLER_26_12 VGND VGND VPWR VPWR sky130_fd_sc_hd__decap_3
XFILLER_73_538 VGND VGND VPWR VPWR sky130_fd_sc_hd__fill_2
X_5019_ _5101_/CLK _5019_/D VGND VGND VPWR VPWR _5019_/Q sky130_fd_sc_hd__dfxtp_2
XTAP_TAPCELL_ROW_56_736 VGND VPWR sky130_fd_sc_hd__tapvpwrvgnd_1
XFILLER_26_56 VGND VGND VPWR VPWR sky130_fd_sc_hd__decap_3
XFILLER_13_104 VGND VGND VPWR VPWR sky130_fd_sc_hd__decap_3
XFILLER_41_413 VGND VGND VPWR VPWR sky130_fd_sc_hd__fill_2
XFILLER_41_435 VGND VGND VPWR VPWR sky130_fd_sc_hd__fill_2
XFILLER_41_479 VGND VGND VPWR VPWR sky130_fd_sc_hd__decap_3
XFILLER_42_77 VGND VGND VPWR VPWR sky130_fd_sc_hd__decap_3
XTAP_TAPCELL_ROW_11_305 VGND VPWR sky130_fd_sc_hd__tapvpwrvgnd_1
XFILLER_21_192 VGND VGND VPWR VPWR sky130_fd_sc_hd__decap_3
XFILLER_5_314 VGND VGND VPWR VPWR sky130_fd_sc_hd__decap_3
XFILLER_1_520 VGND VGND VPWR VPWR sky130_fd_sc_hd__decap_3
XFILLER_1_553 VGND VGND VPWR VPWR sky130_fd_sc_hd__decap_3
XFILLER_49_557 VGND VGND VPWR VPWR sky130_fd_sc_hd__fill_1
XFILLER_67_74 VGND VGND VPWR VPWR sky130_fd_sc_hd__decap_3
XFILLER_88_170 VGND VGND VPWR VPWR sky130_fd_sc_hd__decap_3
XFILLER_76_321 VGND VGND VPWR VPWR sky130_fd_sc_hd__decap_3
XFILLER_67_96 VGND VGND VPWR VPWR sky130_fd_sc_hd__decap_3
XFILLER_76_365 VGND VGND VPWR VPWR sky130_fd_sc_hd__decap_3
XFILLER_29_292 VGND VGND VPWR VPWR sky130_fd_sc_hd__decap_3
XFILLER_83_40 VGND VGND VPWR VPWR sky130_fd_sc_hd__decap_3
XFILLER_17_476 VGND VGND VPWR VPWR sky130_fd_sc_hd__decap_3
XFILLER_32_413 VGND VGND VPWR VPWR sky130_fd_sc_hd__decap_3
XFILLER_32_424 VGND VGND VPWR VPWR sky130_fd_sc_hd__decap_3
XFILLER_44_251 VGND VGND VPWR VPWR sky130_fd_sc_hd__fill_1
XFILLER_44_262 VGND VGND VPWR VPWR sky130_fd_sc_hd__fill_2
XFILLER_44_273 VGND VGND VPWR VPWR sky130_fd_sc_hd__decap_3
XTAP_TAPCELL_ROW_27_460 VGND VPWR sky130_fd_sc_hd__tapvpwrvgnd_1
XFILLER_83_95 VGND VGND VPWR VPWR sky130_fd_sc_hd__fill_2
XFILLER_83_73 VGND VGND VPWR VPWR sky130_fd_sc_hd__decap_3
XFILLER_32_446 VGND VGND VPWR VPWR sky130_fd_sc_hd__decap_3
XFILLER_44_284 VGND VGND VPWR VPWR sky130_fd_sc_hd__decap_3
XPHY_EDGE_ROW_17_Left_111 VGND VGND VPWR VPWR sky130_fd_sc_hd__decap_3
X_2720_ _2832_/A _2719_/X _2435_/Y VGND VGND VPWR VPWR _2720_/X sky130_fd_sc_hd__o21a_2
X_2651_ _4959_/Q _4943_/Q _4927_/Q _4911_/Q _5127_/Q _5128_/Q VGND VGND VPWR VPWR
+ _2651_/X sky130_fd_sc_hd__mux4_2
X_2582_ _5113_/Q _5001_/Q _4985_/Q _4969_/Q _5127_/Q _5128_/Q VGND VGND VPWR VPWR
+ _2582_/X sky130_fd_sc_hd__mux4_2
X_4321_ _4390_/A _4321_/B VGND VGND VPWR VPWR _4321_/Y sky130_fd_sc_hd__nand2_2
XPHY_EDGE_ROW_26_Left_120 VGND VGND VPWR VPWR sky130_fd_sc_hd__decap_3
X_4252_ _3845_/X _4251_/X _4250_/X _4246_/X VGND VGND VPWR VPWR _4252_/X sky130_fd_sc_hd__o211a_2
X_3203_ _2931_/X _3193_/B _3193_/Y _5104_/Q VGND VGND VPWR VPWR _5104_/D sky130_fd_sc_hd__a22o_2
XFILLER_86_118 VGND VGND VPWR VPWR sky130_fd_sc_hd__decap_3
XFILLER_67_321 VGND VGND VPWR VPWR sky130_fd_sc_hd__decap_3
XFILLER_67_343 VGND VGND VPWR VPWR sky130_fd_sc_hd__decap_3
X_4183_ _4225_/A _4183_/B VGND VGND VPWR VPWR _4183_/X sky130_fd_sc_hd__or2_2
XFILLER_55_505 VGND VGND VPWR VPWR sky130_fd_sc_hd__decap_3
XFILLER_67_365 VGND VGND VPWR VPWR sky130_fd_sc_hd__fill_2
X_3134_ _2941_/X _3121_/B _3121_/Y _5043_/Q VGND VGND VPWR VPWR _5043_/D sky130_fd_sc_hd__a22o_2
XFILLER_67_387 VGND VGND VPWR VPWR sky130_fd_sc_hd__decap_3
X_3065_ _3192_/B _3210_/B VGND VGND VPWR VPWR _3065_/Y sky130_fd_sc_hd__nor2_4
XTAP_TAPCELL_ROW_53_706 VGND VPWR sky130_fd_sc_hd__tapvpwrvgnd_1
XFILLER_82_368 VGND VGND VPWR VPWR sky130_fd_sc_hd__decap_3
XFILLER_82_346 VGND VGND VPWR VPWR sky130_fd_sc_hd__decap_3
XFILLER_23_424 VGND VGND VPWR VPWR sky130_fd_sc_hd__decap_3
XFILLER_35_295 VGND VGND VPWR VPWR sky130_fd_sc_hd__fill_1
X_3967_ _3965_/X _4078_/C _4078_/B VGND VGND VPWR VPWR _4183_/B sky130_fd_sc_hd__mux2_1
X_2918_ _2918_/A _2918_/B VGND VGND VPWR VPWR _2918_/X sky130_fd_sc_hd__or2_2
XTAP_TAPCELL_ROW_61_783 VGND VPWR sky130_fd_sc_hd__tapvpwrvgnd_1
X_3898_ _3887_/X _3898_/B _3898_/C _3898_/D VGND VGND VPWR VPWR _3898_/X sky130_fd_sc_hd__and4b_2
X_2849_ _4902_/Q _4886_/Q _5110_/Q _5094_/Q _2851_/S0 _2854_/S1 VGND VGND VPWR VPWR
+ _2850_/B sky130_fd_sc_hd__mux4_2
XFILLER_2_306 VGND VGND VPWR VPWR sky130_fd_sc_hd__fill_2
X_4519_ _3972_/X _4497_/X _4518_/X _4278_/X VGND VGND VPWR VPWR _4519_/X sky130_fd_sc_hd__a31o_2
XFILLER_88_29 VGND VGND VPWR VPWR sky130_fd_sc_hd__decap_3
XFILLER_58_332 VGND VGND VPWR VPWR sky130_fd_sc_hd__decap_3
XFILLER_46_516 VGND VGND VPWR VPWR sky130_fd_sc_hd__decap_3
XFILLER_58_365 VGND VGND VPWR VPWR sky130_fd_sc_hd__decap_3
XTAP_TAPCELL_ROW_69_861 VGND VPWR sky130_fd_sc_hd__tapvpwrvgnd_1
XFILLER_37_55 VGND VGND VPWR VPWR sky130_fd_sc_hd__fill_1
XFILLER_37_66 VGND VGND VPWR VPWR sky130_fd_sc_hd__decap_3
XFILLER_46_549 VGND VGND VPWR VPWR sky130_fd_sc_hd__decap_3
XFILLER_58_387 VGND VGND VPWR VPWR sky130_fd_sc_hd__fill_2
XFILLER_73_324 VGND VGND VPWR VPWR sky130_fd_sc_hd__decap_3
XFILLER_73_346 VGND VGND VPWR VPWR sky130_fd_sc_hd__decap_3
XFILLER_14_413 VGND VGND VPWR VPWR sky130_fd_sc_hd__decap_3
XFILLER_26_262 VGND VGND VPWR VPWR sky130_fd_sc_hd__decap_3
XFILLER_14_424 VGND VGND VPWR VPWR sky130_fd_sc_hd__fill_2
XTAP_TAPCELL_ROW_24_430 VGND VPWR sky130_fd_sc_hd__tapvpwrvgnd_1
XFILLER_41_287 VGND VGND VPWR VPWR sky130_fd_sc_hd__decap_3
XFILLER_45_9 VGND VGND VPWR VPWR sky130_fd_sc_hd__fill_1
XFILLER_78_73 VGND VGND VPWR VPWR sky130_fd_sc_hd__decap_3
XFILLER_49_321 VGND VGND VPWR VPWR sky130_fd_sc_hd__decap_3
XFILLER_37_505 VGND VGND VPWR VPWR sky130_fd_sc_hd__decap_3
XFILLER_37_516 VGND VGND VPWR VPWR sky130_fd_sc_hd__decap_3
XFILLER_49_343 VGND VGND VPWR VPWR sky130_fd_sc_hd__decap_3
XFILLER_49_376 VGND VGND VPWR VPWR sky130_fd_sc_hd__decap_3
XFILLER_64_324 VGND VGND VPWR VPWR sky130_fd_sc_hd__decap_3
XFILLER_76_162 VGND VGND VPWR VPWR sky130_fd_sc_hd__decap_3
XFILLER_64_346 VGND VGND VPWR VPWR sky130_fd_sc_hd__decap_3
XFILLER_64_368 VGND VGND VPWR VPWR sky130_fd_sc_hd__fill_1
XFILLER_17_262 VGND VGND VPWR VPWR sky130_fd_sc_hd__decap_3
XFILLER_91_165 VGND VGND VPWR VPWR sky130_fd_sc_hd__decap_3
XFILLER_17_284 VGND VGND VPWR VPWR sky130_fd_sc_hd__fill_2
XFILLER_32_221 VGND VGND VPWR VPWR sky130_fd_sc_hd__decap_3
X_4870_ _5179_/Q _3229_/Y _4870_/B1 _3253_/X VGND VGND VPWR VPWR _5179_/D sky130_fd_sc_hd__o22a_2
XFILLER_60_552 VGND VGND VPWR VPWR sky130_fd_sc_hd__decap_3
X_3821_ _5158_/Q _4321_/B VGND VGND VPWR VPWR _3821_/X sky130_fd_sc_hd__or2_2
X_3752_ _5181_/Q _3884_/D _5182_/Q VGND VGND VPWR VPWR _4310_/A sky130_fd_sc_hd__or3b_2
X_3683_ _4961_/Q _4945_/Q _4929_/Q _4913_/Q _3732_/S0 _3732_/S1 VGND VGND VPWR VPWR
+ _3683_/X sky130_fd_sc_hd__mux4_2
X_2703_ _2703_/A _2894_/A _2707_/C _2707_/D VGND VGND VPWR VPWR _2703_/X sky130_fd_sc_hd__and4_2
XTAP_TAPCELL_ROW_30_488 VGND VPWR sky130_fd_sc_hd__tapvpwrvgnd_1
XFILLER_9_494 VGND VGND VPWR VPWR sky130_fd_sc_hd__decap_3
X_2634_ _4896_/Q _4880_/Q _5104_/Q _5088_/Q _2672_/S0 _2672_/S1 VGND VGND VPWR VPWR
+ _2634_/X sky130_fd_sc_hd__mux4_2
X_2565_ _5160_/Q _4393_/D VGND VGND VPWR VPWR _2565_/Y sky130_fd_sc_hd__nand2_2
X_4304_ _4310_/A _4312_/A VGND VGND VPWR VPWR _4304_/X sky130_fd_sc_hd__or2_2
X_5284_ _5285_/CLK _5284_/D VGND VGND VPWR VPWR _5284_/Q sky130_fd_sc_hd__dfxtp_2
X_2496_ _4900_/Q _4884_/Q _5108_/Q _5092_/Q _2672_/S0 _2672_/S1 VGND VGND VPWR VPWR
+ _2497_/B sky130_fd_sc_hd__mux4_2
XFILLER_87_405 VGND VGND VPWR VPWR sky130_fd_sc_hd__decap_3
X_4235_ _4239_/A _4235_/B VGND VGND VPWR VPWR _4235_/Y sky130_fd_sc_hd__xnor2_2
XFILLER_87_449 VGND VGND VPWR VPWR sky130_fd_sc_hd__decap_3
XFILLER_87_438 VGND VGND VPWR VPWR sky130_fd_sc_hd__decap_3
X_4166_ _4166_/A _4166_/B _4157_/X VGND VGND VPWR VPWR _4168_/B sky130_fd_sc_hd__or3b_2
XFILLER_28_527 VGND VGND VPWR VPWR sky130_fd_sc_hd__decap_3
XFILLER_55_313 VGND VGND VPWR VPWR sky130_fd_sc_hd__decap_3
X_3117_ _2944_/X _3103_/B _3103_/Y _5028_/Q VGND VGND VPWR VPWR _5028_/D sky130_fd_sc_hd__a22o_2
XTAP_TAPCELL_ROW_66_831 VGND VPWR sky130_fd_sc_hd__tapvpwrvgnd_1
XFILLER_82_110 VGND VGND VPWR VPWR sky130_fd_sc_hd__fill_2
XFILLER_55_346 VGND VGND VPWR VPWR sky130_fd_sc_hd__decap_3
X_4097_ _2656_/A _3764_/X _4278_/B _3776_/B _4168_/A VGND VGND VPWR VPWR _4107_/B
+ sky130_fd_sc_hd__a221o_2
XFILLER_70_305 VGND VGND VPWR VPWR sky130_fd_sc_hd__decap_3
X_3048_ _3494_/A _3048_/B VGND VGND VPWR VPWR _3048_/Y sky130_fd_sc_hd__nor2_4
XTAP_TAPCELL_ROW_38_566 VGND VPWR sky130_fd_sc_hd__tapvpwrvgnd_1
XFILLER_82_187 VGND VGND VPWR VPWR sky130_fd_sc_hd__fill_2
XFILLER_70_349 VGND VGND VPWR VPWR sky130_fd_sc_hd__decap_3
XFILLER_23_254 VGND VGND VPWR VPWR sky130_fd_sc_hd__decap_3
X_4999_ clkload3/A _4999_/D VGND VGND VPWR VPWR _4999_/Q sky130_fd_sc_hd__dfxtp_2
XTAP_TAPCELL_ROW_21_400 VGND VPWR sky130_fd_sc_hd__tapvpwrvgnd_1
XFILLER_11_449 VGND VGND VPWR VPWR sky130_fd_sc_hd__decap_3
XFILLER_23_57 VGND VGND VPWR VPWR sky130_fd_sc_hd__fill_1
XFILLER_78_427 VGND VGND VPWR VPWR sky130_fd_sc_hd__decap_3
XFILLER_48_32 VGND VGND VPWR VPWR sky130_fd_sc_hd__decap_3
XFILLER_19_538 VGND VGND VPWR VPWR sky130_fd_sc_hd__fill_2
XFILLER_46_302 VGND VGND VPWR VPWR sky130_fd_sc_hd__decap_3
XFILLER_86_493 VGND VGND VPWR VPWR sky130_fd_sc_hd__decap_3
XFILLER_46_379 VGND VGND VPWR VPWR sky130_fd_sc_hd__fill_1
XFILLER_73_165 VGND VGND VPWR VPWR sky130_fd_sc_hd__decap_3
XFILLER_42_530 VGND VGND VPWR VPWR sky130_fd_sc_hd__fill_2
XFILLER_64_75 VGND VGND VPWR VPWR sky130_fd_sc_hd__decap_3
XFILLER_14_243 VGND VGND VPWR VPWR sky130_fd_sc_hd__decap_3
XTAP_TAPCELL_ROW_72_889 VGND VPWR sky130_fd_sc_hd__tapvpwrvgnd_1
XFILLER_14_287 VGND VGND VPWR VPWR sky130_fd_sc_hd__decap_3
XFILLER_80_52 VGND VGND VPWR VPWR sky130_fd_sc_hd__decap_3
XFILLER_80_85 VGND VGND VPWR VPWR sky130_fd_sc_hd__decap_3
XFILLER_6_442 VGND VGND VPWR VPWR sky130_fd_sc_hd__decap_3
XFILLER_6_486 VGND VGND VPWR VPWR sky130_fd_sc_hd__decap_3
XFILLER_89_83 VGND VGND VPWR VPWR sky130_fd_sc_hd__fill_1
XFILLER_69_405 VGND VGND VPWR VPWR sky130_fd_sc_hd__decap_3
XFILLER_69_449 VGND VGND VPWR VPWR sky130_fd_sc_hd__decap_3
XTAP_TAPCELL_ROW_9_291 VGND VPWR sky130_fd_sc_hd__tapvpwrvgnd_1
X_4020_ _2624_/A _3764_/X _4278_/B _3775_/B VGND VGND VPWR VPWR _4020_/X sky130_fd_sc_hd__a22o_2
XFILLER_49_151 VGND VGND VPWR VPWR sky130_fd_sc_hd__decap_3
XFILLER_37_357 VGND VGND VPWR VPWR sky130_fd_sc_hd__fill_1
XFILLER_92_452 VGND VGND VPWR VPWR sky130_fd_sc_hd__decap_3
XFILLER_92_430 VGND VGND VPWR VPWR sky130_fd_sc_hd__fill_2
XFILLER_25_508 VGND VGND VPWR VPWR sky130_fd_sc_hd__decap_3
XFILLER_52_305 VGND VGND VPWR VPWR sky130_fd_sc_hd__decap_3
XTAP_TAPCELL_ROW_63_801 VGND VPWR sky130_fd_sc_hd__tapvpwrvgnd_1
XFILLER_92_485 VGND VGND VPWR VPWR sky130_fd_sc_hd__decap_3
XFILLER_52_327 VGND VGND VPWR VPWR sky130_fd_sc_hd__decap_3
X_4922_ _5111_/CLK _4922_/D VGND VGND VPWR VPWR _4922_/Q sky130_fd_sc_hd__dfxtp_2
XTAP_TAPCELL_ROW_35_536 VGND VPWR sky130_fd_sc_hd__tapvpwrvgnd_1
XFILLER_60_371 VGND VGND VPWR VPWR sky130_fd_sc_hd__decap_3
X_4853_ _4851_/X _4852_/Y _4692_/A VGND VGND VPWR VPWR _5277_/D sky130_fd_sc_hd__a21oi_2
X_4784_ _5164_/Q _4784_/B VGND VGND VPWR VPWR _4785_/B sky130_fd_sc_hd__nor2_2
X_3804_ _4062_/A _3804_/B VGND VGND VPWR VPWR _4084_/C sky130_fd_sc_hd__nor2_2
X_3735_ _3739_/B _4393_/C VGND VGND VPWR VPWR _3735_/X sky130_fd_sc_hd__and2b_2
X_3666_ _3666_/A _4207_/A _4261_/A _4239_/A VGND VGND VPWR VPWR _3748_/B sky130_fd_sc_hd__or4_2
X_3597_ _3595_/X _3596_/X _5133_/Q VGND VGND VPWR VPWR _3597_/X sky130_fd_sc_hd__mux2_1
X_2617_ _5159_/Q _3741_/A VGND VGND VPWR VPWR _2620_/A sky130_fd_sc_hd__or2_2
X_2548_ _5116_/Q _5004_/Q _4988_/Q _4972_/Q _5127_/Q _5128_/Q VGND VGND VPWR VPWR
+ _2548_/X sky130_fd_sc_hd__mux4_2
X_5267_ _5270_/CLK _5267_/D VGND VGND VPWR VPWR _5267_/Q sky130_fd_sc_hd__dfxtp_2
XFILLER_87_213 VGND VGND VPWR VPWR sky130_fd_sc_hd__decap_3
X_4218_ _2693_/B _3764_/X _4278_/B _3779_/A _4854_/B VGND VGND VPWR VPWR _4219_/B
+ sky130_fd_sc_hd__a221o_2
X_2479_ _5130_/Q _2475_/Y _2477_/Y _2473_/Y VGND VGND VPWR VPWR _3653_/A sky130_fd_sc_hd__o31ai_4
XFILLER_87_279 VGND VGND VPWR VPWR sky130_fd_sc_hd__fill_1
X_5198_ _5283_/CLK _5198_/D VGND VGND VPWR VPWR _5198_/Q sky130_fd_sc_hd__dfxtp_2
XFILLER_55_143 VGND VGND VPWR VPWR sky130_fd_sc_hd__decap_3
X_4149_ _4148_/X _4099_/X _4266_/S VGND VGND VPWR VPWR _4149_/X sky130_fd_sc_hd__mux2_1
XFILLER_16_519 VGND VGND VPWR VPWR sky130_fd_sc_hd__decap_3
XFILLER_18_79 VGND VGND VPWR VPWR sky130_fd_sc_hd__decap_3
XFILLER_28_368 VGND VGND VPWR VPWR sky130_fd_sc_hd__decap_3
XFILLER_83_474 VGND VGND VPWR VPWR sky130_fd_sc_hd__decap_3
XFILLER_24_530 VGND VGND VPWR VPWR sky130_fd_sc_hd__fill_2
XFILLER_43_349 VGND VGND VPWR VPWR sky130_fd_sc_hd__decap_3
XFILLER_55_198 VGND VGND VPWR VPWR sky130_fd_sc_hd__decap_3
XFILLER_70_113 VGND VGND VPWR VPWR sky130_fd_sc_hd__decap_3
XFILLER_11_213 VGND VGND VPWR VPWR sky130_fd_sc_hd__decap_3
XFILLER_34_78 VGND VGND VPWR VPWR sky130_fd_sc_hd__decap_3
XFILLER_51_382 VGND VGND VPWR VPWR sky130_fd_sc_hd__decap_3
Xwire137 _3653_/A VGND VGND VPWR VPWR _4362_/A sky130_fd_sc_hd__buf_4
Xclkload0 clkload0/A VGND VGND VPWR VPWR clkload0/X sky130_fd_sc_hd__clkbuf_8
XFILLER_50_44 VGND VGND VPWR VPWR sky130_fd_sc_hd__decap_3
XFILLER_3_412 VGND VGND VPWR VPWR sky130_fd_sc_hd__fill_1
XFILLER_59_31 VGND VGND VPWR VPWR sky130_fd_sc_hd__fill_1
XFILLER_59_75 VGND VGND VPWR VPWR sky130_fd_sc_hd__fill_1
XFILLER_78_213 VGND VGND VPWR VPWR sky130_fd_sc_hd__decap_3
XTAP_TAPCELL_ROW_6_261 VGND VPWR sky130_fd_sc_hd__tapvpwrvgnd_1
XFILLER_78_246 VGND VGND VPWR VPWR sky130_fd_sc_hd__decap_3
XFILLER_19_302 VGND VGND VPWR VPWR sky130_fd_sc_hd__decap_3
XFILLER_59_471 VGND VGND VPWR VPWR sky130_fd_sc_hd__decap_3
XTAP_TAPCELL_ROW_77_937 VGND VPWR sky130_fd_sc_hd__tapvpwrvgnd_1
XFILLER_46_121 VGND VGND VPWR VPWR sky130_fd_sc_hd__fill_2
XFILLER_74_430 VGND VGND VPWR VPWR sky130_fd_sc_hd__decap_3
XFILLER_75_41 VGND VGND VPWR VPWR sky130_fd_sc_hd__decap_3
XFILLER_19_379 VGND VGND VPWR VPWR sky130_fd_sc_hd__decap_3
XFILLER_61_113 VGND VGND VPWR VPWR sky130_fd_sc_hd__decap_3
XFILLER_30_511 VGND VGND VPWR VPWR sky130_fd_sc_hd__decap_3
XTAP_TAPCELL_ROW_32_506 VGND VPWR sky130_fd_sc_hd__tapvpwrvgnd_1
XFILLER_42_393 VGND VGND VPWR VPWR sky130_fd_sc_hd__decap_3
X_3520_ _4952_/Q _4936_/Q _4920_/Q _4904_/Q _3732_/S0 _3732_/S1 VGND VGND VPWR VPWR
+ _3520_/X sky130_fd_sc_hd__mux4_2
XTAP_TAPCELL_ROW_40_583 VGND VPWR sky130_fd_sc_hd__tapvpwrvgnd_1
XFILLER_6_272 VGND VGND VPWR VPWR sky130_fd_sc_hd__fill_1
X_3451_ _5204_/Q _4854_/B VGND VGND VPWR VPWR _3451_/Y sky130_fd_sc_hd__nand2_2
XFILLER_41_3 VGND VGND VPWR VPWR sky130_fd_sc_hd__decap_3
X_3382_ _4732_/A _5154_/Q VGND VGND VPWR VPWR _3382_/X sky130_fd_sc_hd__and2_2
X_5121_ clkload5/A _5121_/D VGND VGND VPWR VPWR _5121_/Q sky130_fd_sc_hd__dfxtp_2
XFILLER_57_408 VGND VGND VPWR VPWR sky130_fd_sc_hd__decap_3
X_5052_ _5114_/CLK _5052_/D VGND VGND VPWR VPWR _5052_/Q sky130_fd_sc_hd__dfxtp_2
XFILLER_84_216 VGND VGND VPWR VPWR sky130_fd_sc_hd__decap_3
X_4003_ _4016_/A _3574_/X _4002_/Y _3569_/X VGND VGND VPWR VPWR _4003_/X sky130_fd_sc_hd__a211o_2
XFILLER_84_238 VGND VGND VPWR VPWR sky130_fd_sc_hd__decap_3
XFILLER_37_143 VGND VGND VPWR VPWR sky130_fd_sc_hd__decap_3
XTAP_TAPCELL_ROW_48_661 VGND VPWR sky130_fd_sc_hd__tapvpwrvgnd_1
XPHY_EDGE_ROW_9_Left_103 VGND VGND VPWR VPWR sky130_fd_sc_hd__decap_3
XFILLER_65_485 VGND VGND VPWR VPWR sky130_fd_sc_hd__fill_1
XFILLER_80_466 VGND VGND VPWR VPWR sky130_fd_sc_hd__decap_3
XFILLER_33_371 VGND VGND VPWR VPWR sky130_fd_sc_hd__decap_3
XFILLER_40_319 VGND VGND VPWR VPWR sky130_fd_sc_hd__decap_3
X_4905_ _4994_/CLK _4905_/D VGND VGND VPWR VPWR _4905_/Q sky130_fd_sc_hd__dfxtp_2
XFILLER_21_555 VGND VGND VPWR VPWR sky130_fd_sc_hd__decap_3
X_4836_ _4839_/A VGND VGND VPWR VPWR _4836_/Y sky130_fd_sc_hd__inv_2
X_4767_ _5263_/Q _4847_/B _4766_/Y _3338_/B VGND VGND VPWR VPWR _5263_/D sky130_fd_sc_hd__o211a_2
XFILLER_4_209 VGND VGND VPWR VPWR sky130_fd_sc_hd__decap_3
X_4698_ input40/X _4694_/Y _4697_/X _3366_/A VGND VGND VPWR VPWR _5243_/D sky130_fd_sc_hd__o211a_2
X_3718_ _3733_/S _3718_/B VGND VGND VPWR VPWR _3718_/X sky130_fd_sc_hd__or2_2
XFILLER_20_47 VGND VGND VPWR VPWR sky130_fd_sc_hd__decap_3
X_3649_ _5126_/Q _5014_/Q _4998_/Q _4982_/Q _5131_/Q _5132_/Q VGND VGND VPWR VPWR
+ _3649_/X sky130_fd_sc_hd__mux4_2
XTAP_TAPCELL_ROW_93_1092 VGND VPWR sky130_fd_sc_hd__tapvpwrvgnd_1
XTAP_TAPCELL_ROW_93_1081 VGND VPWR sky130_fd_sc_hd__tapvpwrvgnd_1
XFILLER_88_544 VGND VGND VPWR VPWR sky130_fd_sc_hd__decap_3
XFILLER_88_533 VGND VGND VPWR VPWR sky130_fd_sc_hd__fill_2
XFILLER_48_408 VGND VGND VPWR VPWR sky130_fd_sc_hd__decap_3
XFILLER_29_45 VGND VGND VPWR VPWR sky130_fd_sc_hd__decap_3
XFILLER_28_121 VGND VGND VPWR VPWR sky130_fd_sc_hd__decap_3
XTAP_TAPCELL_ROW_74_907 VGND VPWR sky130_fd_sc_hd__tapvpwrvgnd_1
XTAP_TAPCELL_ROW_3_231 VGND VPWR sky130_fd_sc_hd__tapvpwrvgnd_1
XFILLER_56_452 VGND VGND VPWR VPWR sky130_fd_sc_hd__decap_3
XFILLER_43_102 VGND VGND VPWR VPWR sky130_fd_sc_hd__fill_1
XFILLER_43_113 VGND VGND VPWR VPWR sky130_fd_sc_hd__decap_3
XFILLER_45_55 VGND VGND VPWR VPWR sky130_fd_sc_hd__fill_1
XFILLER_71_411 VGND VGND VPWR VPWR sky130_fd_sc_hd__decap_3
XFILLER_71_433 VGND VGND VPWR VPWR sky130_fd_sc_hd__decap_3
XFILLER_83_293 VGND VGND VPWR VPWR sky130_fd_sc_hd__decap_3
XFILLER_71_455 VGND VGND VPWR VPWR sky130_fd_sc_hd__decap_3
XFILLER_24_371 VGND VGND VPWR VPWR sky130_fd_sc_hd__decap_3
XTAP_TAPCELL_ROW_82_984 VGND VPWR sky130_fd_sc_hd__tapvpwrvgnd_1
XFILLER_12_555 VGND VGND VPWR VPWR sky130_fd_sc_hd__decap_3
XFILLER_51_190 VGND VGND VPWR VPWR sky130_fd_sc_hd__decap_3
XFILLER_61_54 VGND VGND VPWR VPWR sky130_fd_sc_hd__fill_2
XFILLER_79_511 VGND VGND VPWR VPWR sky130_fd_sc_hd__decap_3
XFILLER_39_408 VGND VGND VPWR VPWR sky130_fd_sc_hd__fill_2
XFILLER_66_205 VGND VGND VPWR VPWR sky130_fd_sc_hd__decap_3
XFILLER_66_238 VGND VGND VPWR VPWR sky130_fd_sc_hd__decap_3
XFILLER_47_452 VGND VGND VPWR VPWR sky130_fd_sc_hd__decap_3
XFILLER_47_485 VGND VGND VPWR VPWR sky130_fd_sc_hd__decap_3
XFILLER_62_411 VGND VGND VPWR VPWR sky130_fd_sc_hd__decap_3
XFILLER_74_293 VGND VGND VPWR VPWR sky130_fd_sc_hd__decap_3
XTAP_TAPCELL_ROW_45_631 VGND VPWR sky130_fd_sc_hd__tapvpwrvgnd_1
XFILLER_62_499 VGND VGND VPWR VPWR sky130_fd_sc_hd__decap_3
X_2951_ _4886_/Q _2902_/Y _2950_/X _2951_/B2 VGND VGND VPWR VPWR _4886_/D sky130_fd_sc_hd__a22o_2
XTAP_TAPCELL_ROW_17_366 VGND VPWR sky130_fd_sc_hd__tapvpwrvgnd_1
XFILLER_15_393 VGND VGND VPWR VPWR sky130_fd_sc_hd__decap_3
X_4621_ _4312_/Y _4484_/X _4618_/X _4620_/Y VGND VGND VPWR VPWR _4621_/X sky130_fd_sc_hd__o211a_2
X_2882_ _2877_/A _3776_/A _3776_/B _2686_/Y VGND VGND VPWR VPWR _2883_/B sky130_fd_sc_hd__a31o_2
XFILLER_89_3 VGND VGND VPWR VPWR sky130_fd_sc_hd__fill_1
X_4552_ _4441_/X _4450_/X _4572_/S VGND VGND VPWR VPWR _4552_/X sky130_fd_sc_hd__mux2_1
X_4483_ _4515_/B _4483_/B VGND VGND VPWR VPWR _4564_/A sky130_fd_sc_hd__or2_2
X_3503_ _3501_/X _3502_/X _5133_/Q VGND VGND VPWR VPWR _3503_/X sky130_fd_sc_hd__mux2_1
X_3434_ _3427_/Y _3433_/X _3494_/A VGND VGND VPWR VPWR _5201_/D sky130_fd_sc_hd__a21oi_2
X_3365_ _5188_/Q _4275_/B _3358_/X _3359_/X VGND VGND VPWR VPWR _3366_/C sky130_fd_sc_hd__o22a_2
X_5104_ _5109_/CLK _5104_/D VGND VGND VPWR VPWR _5104_/Q sky130_fd_sc_hd__dfxtp_2
X_3296_ _3297_/B _3307_/D _5149_/Q VGND VGND VPWR VPWR _3296_/Y sky130_fd_sc_hd__a21oi_2
XFILLER_38_430 VGND VGND VPWR VPWR sky130_fd_sc_hd__decap_3
X_5035_ _5101_/CLK _5035_/D VGND VGND VPWR VPWR _5035_/Q sky130_fd_sc_hd__dfxtp_2
XTAP_TAPCELL_ROW_0_201 VGND VPWR sky130_fd_sc_hd__tapvpwrvgnd_1
XFILLER_25_113 VGND VGND VPWR VPWR sky130_fd_sc_hd__decap_3
XTAP_TAPCELL_ROW_84_1003 VGND VPWR sky130_fd_sc_hd__tapvpwrvgnd_1
XFILLER_25_157 VGND VGND VPWR VPWR sky130_fd_sc_hd__decap_3
XFILLER_53_444 VGND VGND VPWR VPWR sky130_fd_sc_hd__decap_3
XFILLER_53_455 VGND VGND VPWR VPWR sky130_fd_sc_hd__fill_2
XFILLER_53_466 VGND VGND VPWR VPWR sky130_fd_sc_hd__decap_3
XFILLER_80_241 VGND VGND VPWR VPWR sky130_fd_sc_hd__fill_2
XFILLER_13_319 VGND VGND VPWR VPWR sky130_fd_sc_hd__fill_1
XFILLER_80_285 VGND VGND VPWR VPWR sky130_fd_sc_hd__decap_3
XFILLER_15_69 VGND VGND VPWR VPWR sky130_fd_sc_hd__fill_1
XFILLER_21_352 VGND VGND VPWR VPWR sky130_fd_sc_hd__decap_3
XTAP_TAPCELL_ROW_51_689 VGND VPWR sky130_fd_sc_hd__tapvpwrvgnd_1
XFILLER_21_396 VGND VGND VPWR VPWR sky130_fd_sc_hd__decap_3
X_4819_ _5168_/Q _4820_/B VGND VGND VPWR VPWR _4821_/A sky130_fd_sc_hd__nand2_2
XFILLER_31_46 VGND VGND VPWR VPWR sky130_fd_sc_hd__decap_3
XFILLER_31_57 VGND VGND VPWR VPWR sky130_fd_sc_hd__decap_3
XFILLER_5_518 VGND VGND VPWR VPWR sky130_fd_sc_hd__fill_2
XFILLER_0_212 VGND VGND VPWR VPWR sky130_fd_sc_hd__decap_3
Xoutput57 _5148_/Q VGND VGND VPWR VPWR INSTR_ADDR[11] sky130_fd_sc_hd__clkdlybuf4s25_1
XFILLER_0_223 VGND VGND VPWR VPWR sky130_fd_sc_hd__fill_1
XFILLER_0_234 VGND VGND VPWR VPWR sky130_fd_sc_hd__decap_3
Xoutput68 _5144_/Q VGND VGND VPWR VPWR INSTR_ADDR[7] sky130_fd_sc_hd__clkdlybuf4s25_1
Xoutput79 _2889_/X VGND VGND VPWR VPWR MEM_ADDR[12] sky130_fd_sc_hd__clkdlybuf4s25_1
XFILLER_88_341 VGND VGND VPWR VPWR sky130_fd_sc_hd__decap_3
XFILLER_0_256 VGND VGND VPWR VPWR sky130_fd_sc_hd__decap_3
XFILLER_88_396 VGND VGND VPWR VPWR sky130_fd_sc_hd__decap_3
XFILLER_76_547 VGND VGND VPWR VPWR sky130_fd_sc_hd__decap_3
XFILLER_29_441 VGND VGND VPWR VPWR sky130_fd_sc_hd__decap_3
XFILLER_29_452 VGND VGND VPWR VPWR sky130_fd_sc_hd__decap_3
XFILLER_16_113 VGND VGND VPWR VPWR sky130_fd_sc_hd__decap_3
XFILLER_56_76 VGND VGND VPWR VPWR sky130_fd_sc_hd__decap_3
XPHY_EDGE_ROW_19_Right_19 VGND VGND VPWR VPWR sky130_fd_sc_hd__decap_3
XFILLER_31_116 VGND VGND VPWR VPWR sky130_fd_sc_hd__decap_3
XFILLER_44_477 VGND VGND VPWR VPWR sky130_fd_sc_hd__decap_3
XTAP_TAPCELL_ROW_42_601 VGND VPWR sky130_fd_sc_hd__tapvpwrvgnd_1
XFILLER_72_64 VGND VGND VPWR VPWR sky130_fd_sc_hd__decap_3
XTAP_TAPCELL_ROW_14_336 VGND VPWR sky130_fd_sc_hd__tapvpwrvgnd_1
XFILLER_12_363 VGND VGND VPWR VPWR sky130_fd_sc_hd__fill_1
XFILLER_8_389 VGND VGND VPWR VPWR sky130_fd_sc_hd__decap_3
XFILLER_4_551 VGND VGND VPWR VPWR sky130_fd_sc_hd__decap_3
XPHY_EDGE_ROW_28_Right_28 VGND VGND VPWR VPWR sky130_fd_sc_hd__decap_3
XFILLER_79_352 VGND VGND VPWR VPWR sky130_fd_sc_hd__decap_3
XFILLER_67_514 VGND VGND VPWR VPWR sky130_fd_sc_hd__decap_3
X_3150_ _2934_/X _3155_/A2 _3139_/Y _5057_/Q VGND VGND VPWR VPWR _5057_/D sky130_fd_sc_hd__a22o_2
X_3081_ _2947_/X _3065_/Y _3066_/Y _4997_/Q VGND VGND VPWR VPWR _4997_/D sky130_fd_sc_hd__a22o_2
XPHY_EDGE_ROW_37_Right_37 VGND VGND VPWR VPWR sky130_fd_sc_hd__decap_3
XFILLER_35_444 VGND VGND VPWR VPWR sky130_fd_sc_hd__decap_3
XFILLER_62_230 VGND VGND VPWR VPWR sky130_fd_sc_hd__decap_3
XFILLER_62_263 VGND VGND VPWR VPWR sky130_fd_sc_hd__decap_3
XFILLER_22_127 VGND VGND VPWR VPWR sky130_fd_sc_hd__decap_3
XFILLER_50_458 VGND VGND VPWR VPWR sky130_fd_sc_hd__fill_1
X_3983_ _4275_/B _3983_/B VGND VGND VPWR VPWR _3983_/Y sky130_fd_sc_hd__nand2_2
XFILLER_50_469 VGND VGND VPWR VPWR sky130_fd_sc_hd__decap_3
X_2934_ _5275_/Q _5204_/Q _2947_/B1 _5236_/Q _2933_/X VGND VGND VPWR VPWR _2934_/X
+ sky130_fd_sc_hd__a221o_2
X_2865_ _2873_/A _2865_/B VGND VGND VPWR VPWR _2865_/Y sky130_fd_sc_hd__nor2_2
X_4604_ _4604_/A _4604_/B _4604_/C VGND VGND VPWR VPWR _4604_/X sky130_fd_sc_hd__and3_2
XPHY_EDGE_ROW_46_Right_46 VGND VGND VPWR VPWR sky130_fd_sc_hd__decap_3
X_4535_ _4535_/A _4681_/S VGND VGND VPWR VPWR _4595_/C sky130_fd_sc_hd__or2_2
X_2796_ _5072_/Q _5056_/Q _5040_/Q _5024_/Q _2851_/S0 _2854_/S1 VGND VGND VPWR VPWR
+ _2797_/B sky130_fd_sc_hd__mux4_2
X_4466_ _4467_/B _4467_/A VGND VGND VPWR VPWR _4466_/Y sky130_fd_sc_hd__nand2b_2
XFILLER_89_116 VGND VGND VPWR VPWR sky130_fd_sc_hd__decap_3
X_4397_ _4397_/A _4397_/B _4397_/C _4397_/D VGND VGND VPWR VPWR _4458_/B sky130_fd_sc_hd__nand4_2
X_3417_ _5199_/Q _4854_/B _3458_/A _3416_/Y VGND VGND VPWR VPWR _3418_/B sky130_fd_sc_hd__o2bb2a_2
X_3348_ _5283_/Q _3366_/A _3348_/C VGND VGND VPWR VPWR _3348_/X sky130_fd_sc_hd__and3_2
XFILLER_58_536 VGND VGND VPWR VPWR sky130_fd_sc_hd__decap_3
XFILLER_85_344 VGND VGND VPWR VPWR sky130_fd_sc_hd__decap_3
XFILLER_85_333 VGND VGND VPWR VPWR sky130_fd_sc_hd__decap_3
XFILLER_73_517 VGND VGND VPWR VPWR sky130_fd_sc_hd__decap_3
X_3279_ _3278_/X _3310_/S _5265_/Q _3305_/B VGND VGND VPWR VPWR _3279_/X sky130_fd_sc_hd__o2bb2a_2
XPHY_EDGE_ROW_55_Right_55 VGND VGND VPWR VPWR sky130_fd_sc_hd__decap_3
XFILLER_85_366 VGND VGND VPWR VPWR sky130_fd_sc_hd__decap_3
XFILLER_26_24 VGND VGND VPWR VPWR sky130_fd_sc_hd__decap_3
XFILLER_26_411 VGND VGND VPWR VPWR sky130_fd_sc_hd__decap_3
X_5018_ _5069_/CLK _5018_/D VGND VGND VPWR VPWR _5018_/Q sky130_fd_sc_hd__dfxtp_2
XTAP_TAPCELL_ROW_56_737 VGND VPWR sky130_fd_sc_hd__tapvpwrvgnd_1
XFILLER_53_230 VGND VGND VPWR VPWR sky130_fd_sc_hd__decap_3
XFILLER_81_550 VGND VGND VPWR VPWR sky130_fd_sc_hd__decap_3
XFILLER_26_466 VGND VGND VPWR VPWR sky130_fd_sc_hd__decap_3
XFILLER_26_499 VGND VGND VPWR VPWR sky130_fd_sc_hd__decap_3
XFILLER_26_68 VGND VGND VPWR VPWR sky130_fd_sc_hd__decap_3
XFILLER_53_263 VGND VGND VPWR VPWR sky130_fd_sc_hd__decap_3
XFILLER_13_138 VGND VGND VPWR VPWR sky130_fd_sc_hd__decap_3
XFILLER_41_447 VGND VGND VPWR VPWR sky130_fd_sc_hd__fill_1
XFILLER_41_458 VGND VGND VPWR VPWR sky130_fd_sc_hd__decap_3
XFILLER_53_296 VGND VGND VPWR VPWR sky130_fd_sc_hd__decap_3
XFILLER_9_109 VGND VGND VPWR VPWR sky130_fd_sc_hd__decap_3
XFILLER_42_67 VGND VGND VPWR VPWR sky130_fd_sc_hd__fill_2
XTAP_TAPCELL_ROW_11_306 VGND VPWR sky130_fd_sc_hd__tapvpwrvgnd_1
XPHY_EDGE_ROW_64_Right_64 VGND VGND VPWR VPWR sky130_fd_sc_hd__decap_3
XFILLER_5_337 VGND VGND VPWR VPWR sky130_fd_sc_hd__decap_3
XFILLER_1_532 VGND VGND VPWR VPWR sky130_fd_sc_hd__decap_3
XFILLER_49_503 VGND VGND VPWR VPWR sky130_fd_sc_hd__fill_1
XFILLER_49_514 VGND VGND VPWR VPWR sky130_fd_sc_hd__decap_3
XFILLER_49_525 VGND VGND VPWR VPWR sky130_fd_sc_hd__decap_3
XPHY_EDGE_ROW_73_Right_73 VGND VGND VPWR VPWR sky130_fd_sc_hd__decap_3
XFILLER_88_182 VGND VGND VPWR VPWR sky130_fd_sc_hd__decap_3
XFILLER_91_303 VGND VGND VPWR VPWR sky130_fd_sc_hd__decap_3
XFILLER_76_377 VGND VGND VPWR VPWR sky130_fd_sc_hd__decap_3
XFILLER_76_344 VGND VGND VPWR VPWR sky130_fd_sc_hd__decap_3
XFILLER_29_260 VGND VGND VPWR VPWR sky130_fd_sc_hd__decap_3
XFILLER_64_528 VGND VGND VPWR VPWR sky130_fd_sc_hd__decap_3
XFILLER_64_539 VGND VGND VPWR VPWR sky130_fd_sc_hd__fill_1
XFILLER_17_433 VGND VGND VPWR VPWR sky130_fd_sc_hd__decap_3
XFILLER_83_52 VGND VGND VPWR VPWR sky130_fd_sc_hd__decap_3
XFILLER_17_488 VGND VGND VPWR VPWR sky130_fd_sc_hd__decap_3
XTAP_TAPCELL_ROW_27_461 VGND VPWR sky130_fd_sc_hd__tapvpwrvgnd_1
XFILLER_32_458 VGND VGND VPWR VPWR sky130_fd_sc_hd__fill_1
XFILLER_32_469 VGND VGND VPWR VPWR sky130_fd_sc_hd__decap_3
XPHY_EDGE_ROW_82_Right_82 VGND VGND VPWR VPWR sky130_fd_sc_hd__decap_3
XFILLER_40_480 VGND VGND VPWR VPWR sky130_fd_sc_hd__decap_3
X_2650_ _5119_/Q _5007_/Q _4991_/Q _4975_/Q _5127_/Q _5128_/Q VGND VGND VPWR VPWR
+ _2650_/X sky130_fd_sc_hd__mux4_2
XFILLER_8_153 VGND VGND VPWR VPWR sky130_fd_sc_hd__fill_1
X_2581_ _2677_/S _2580_/X _5130_/Q VGND VGND VPWR VPWR _2581_/X sky130_fd_sc_hd__o21a_2
X_4320_ _4320_/A _4320_/B VGND VGND VPWR VPWR _4320_/Y sky130_fd_sc_hd__nor2_2
X_4251_ _3778_/B _3815_/A _3844_/Y _4686_/B1 VGND VGND VPWR VPWR _4251_/X sky130_fd_sc_hd__a31o_2
X_3202_ _2927_/X _3192_/Y _3193_/Y _5103_/Q VGND VGND VPWR VPWR _5103_/D sky130_fd_sc_hd__a22o_2
XPHY_EDGE_ROW_91_Right_91 VGND VGND VPWR VPWR sky130_fd_sc_hd__decap_3
X_4182_ _4267_/S _4081_/X _4181_/Y _4051_/A VGND VGND VPWR VPWR _4182_/X sky130_fd_sc_hd__a211o_2
XFILLER_55_517 VGND VGND VPWR VPWR sky130_fd_sc_hd__decap_3
X_3133_ _2937_/X _3121_/B _3121_/Y _5042_/Q VGND VGND VPWR VPWR _5042_/D sky130_fd_sc_hd__a22o_2
XFILLER_67_399 VGND VGND VPWR VPWR sky130_fd_sc_hd__decap_3
X_3064_ _2950_/X _3048_/B _3048_/Y _4982_/Q VGND VGND VPWR VPWR _4982_/D sky130_fd_sc_hd__a22o_2
XFILLER_82_303 VGND VGND VPWR VPWR sky130_fd_sc_hd__decap_3
XFILLER_50_200 VGND VGND VPWR VPWR sky130_fd_sc_hd__decap_3
XTAP_TAPCELL_ROW_53_707 VGND VPWR sky130_fd_sc_hd__tapvpwrvgnd_1
XFILLER_23_436 VGND VGND VPWR VPWR sky130_fd_sc_hd__decap_3
XFILLER_90_391 VGND VGND VPWR VPWR sky130_fd_sc_hd__decap_3
XFILLER_50_244 VGND VGND VPWR VPWR sky130_fd_sc_hd__decap_3
XFILLER_50_266 VGND VGND VPWR VPWR sky130_fd_sc_hd__decap_3
X_3966_ _3969_/S _3966_/B VGND VGND VPWR VPWR _4078_/C sky130_fd_sc_hd__or2_2
XFILLER_31_480 VGND VGND VPWR VPWR sky130_fd_sc_hd__decap_3
XFILLER_50_288 VGND VGND VPWR VPWR sky130_fd_sc_hd__decap_3
X_2917_ _5277_/Q _5247_/Q _5231_/Q _4854_/A VGND VGND VPWR VPWR _2918_/B sky130_fd_sc_hd__a22o_2
XTAP_TAPCELL_ROW_61_784 VGND VPWR sky130_fd_sc_hd__tapvpwrvgnd_1
X_3897_ _4213_/A _3888_/Y _3889_/Y _2863_/B _2443_/X VGND VGND VPWR VPWR _3898_/C
+ sky130_fd_sc_hd__o32a_2
XFILLER_12_59 VGND VGND VPWR VPWR sky130_fd_sc_hd__decap_3
X_2848_ _2857_/A _4834_/B VGND VGND VPWR VPWR _2848_/X sky130_fd_sc_hd__and2_2
X_2779_ _2777_/X _2778_/X _2832_/A VGND VGND VPWR VPWR _2779_/X sky130_fd_sc_hd__mux2_1
X_4518_ _4518_/A _4518_/B _4518_/C VGND VGND VPWR VPWR _4518_/X sky130_fd_sc_hd__and3_2
XFILLER_5_9 VGND VGND VPWR VPWR sky130_fd_sc_hd__decap_3
X_4449_ _3840_/B _3852_/A _4449_/S VGND VGND VPWR VPWR _4449_/X sky130_fd_sc_hd__mux2_1
XFILLER_37_34 VGND VGND VPWR VPWR sky130_fd_sc_hd__decap_3
XFILLER_46_528 VGND VGND VPWR VPWR sky130_fd_sc_hd__decap_3
XFILLER_58_377 VGND VGND VPWR VPWR sky130_fd_sc_hd__fill_1
XFILLER_85_174 VGND VGND VPWR VPWR sky130_fd_sc_hd__fill_2
XFILLER_26_230 VGND VGND VPWR VPWR sky130_fd_sc_hd__decap_3
XFILLER_73_358 VGND VGND VPWR VPWR sky130_fd_sc_hd__decap_3
XFILLER_85_196 VGND VGND VPWR VPWR sky130_fd_sc_hd__decap_3
XFILLER_41_233 VGND VGND VPWR VPWR sky130_fd_sc_hd__decap_3
XFILLER_53_44 VGND VGND VPWR VPWR sky130_fd_sc_hd__decap_3
XFILLER_81_391 VGND VGND VPWR VPWR sky130_fd_sc_hd__fill_1
XFILLER_14_469 VGND VGND VPWR VPWR sky130_fd_sc_hd__decap_3
XFILLER_53_88 VGND VGND VPWR VPWR sky130_fd_sc_hd__fill_1
XTAP_TAPCELL_ROW_24_431 VGND VPWR sky130_fd_sc_hd__tapvpwrvgnd_1
XFILLER_22_480 VGND VGND VPWR VPWR sky130_fd_sc_hd__decap_3
XFILLER_53_99 VGND VGND VPWR VPWR sky130_fd_sc_hd__decap_3
XFILLER_5_101 VGND VGND VPWR VPWR sky130_fd_sc_hd__decap_3
XFILLER_5_134 VGND VGND VPWR VPWR sky130_fd_sc_hd__decap_3
XFILLER_5_167 VGND VGND VPWR VPWR sky130_fd_sc_hd__fill_1
XFILLER_1_340 VGND VGND VPWR VPWR sky130_fd_sc_hd__fill_2
XFILLER_1_362 VGND VGND VPWR VPWR sky130_fd_sc_hd__decap_3
XFILLER_78_85 VGND VGND VPWR VPWR sky130_fd_sc_hd__decap_3
XFILLER_49_333 VGND VGND VPWR VPWR sky130_fd_sc_hd__decap_3
Xclkbuf_leaf_10_CLK clkload1/A VGND VGND VPWR VPWR _5263_/CLK sky130_fd_sc_hd__clkbuf_8
XFILLER_89_480 VGND VGND VPWR VPWR sky130_fd_sc_hd__decap_3
XFILLER_49_355 VGND VGND VPWR VPWR sky130_fd_sc_hd__decap_3
XFILLER_49_388 VGND VGND VPWR VPWR sky130_fd_sc_hd__decap_3
XFILLER_49_399 VGND VGND VPWR VPWR sky130_fd_sc_hd__fill_2
XFILLER_52_509 VGND VGND VPWR VPWR sky130_fd_sc_hd__decap_3
XFILLER_17_274 VGND VGND VPWR VPWR sky130_fd_sc_hd__decap_3
XFILLER_32_200 VGND VGND VPWR VPWR sky130_fd_sc_hd__decap_3
XFILLER_60_520 VGND VGND VPWR VPWR sky130_fd_sc_hd__decap_3
XFILLER_32_233 VGND VGND VPWR VPWR sky130_fd_sc_hd__decap_3
X_3820_ _3820_/A _3820_/B VGND VGND VPWR VPWR _3820_/Y sky130_fd_sc_hd__nor2_2
XFILLER_32_299 VGND VGND VPWR VPWR sky130_fd_sc_hd__decap_3
X_3751_ _5181_/Q _3891_/A _5182_/Q VGND VGND VPWR VPWR _4103_/A sky130_fd_sc_hd__and3b_2
XFILLER_13_480 VGND VGND VPWR VPWR sky130_fd_sc_hd__decap_3
X_2702_ _2887_/A _2702_/B VGND VGND VPWR VPWR _2702_/Y sky130_fd_sc_hd__nor2_2
X_3682_ _3693_/A _3681_/X _5134_/Q VGND VGND VPWR VPWR _3682_/Y sky130_fd_sc_hd__o21ai_2
XTAP_TAPCELL_ROW_30_489 VGND VPWR sky130_fd_sc_hd__tapvpwrvgnd_1
X_2633_ _2677_/S _2633_/B VGND VGND VPWR VPWR _2633_/X sky130_fd_sc_hd__or2_2
X_2564_ _5160_/Q _4393_/D VGND VGND VPWR VPWR _2567_/A sky130_fd_sc_hd__and2_2
X_4303_ _4302_/X _4299_/X _4309_/S VGND VGND VPWR VPWR _4312_/A sky130_fd_sc_hd__mux2_1
XFILLER_59_108 VGND VGND VPWR VPWR sky130_fd_sc_hd__decap_3
X_5283_ _5283_/CLK _5283_/D VGND VGND VPWR VPWR _5283_/Q sky130_fd_sc_hd__dfxtp_2
X_2495_ _2695_/B _2495_/B VGND VGND VPWR VPWR _2495_/Y sky130_fd_sc_hd__nand2_2
XFILLER_87_417 VGND VGND VPWR VPWR sky130_fd_sc_hd__decap_3
X_4234_ _3666_/A _4207_/A _4207_/B _4233_/X _3631_/B VGND VGND VPWR VPWR _4235_/B
+ sky130_fd_sc_hd__a311o_2
X_4165_ _4854_/B _4163_/X _4164_/X _3366_/A VGND VGND VPWR VPWR _5220_/D sky130_fd_sc_hd__o211a_2
XFILLER_28_539 VGND VGND VPWR VPWR sky130_fd_sc_hd__decap_3
X_3116_ _2941_/X _3119_/A2 _3103_/Y _5027_/Q VGND VGND VPWR VPWR _5027_/D sky130_fd_sc_hd__a22o_2
XFILLER_55_358 VGND VGND VPWR VPWR sky130_fd_sc_hd__decap_3
X_4096_ _3884_/D _3714_/A _4155_/B _3886_/B VGND VGND VPWR VPWR _4096_/X sky130_fd_sc_hd__a211o_2
XTAP_TAPCELL_ROW_66_832 VGND VPWR sky130_fd_sc_hd__tapvpwrvgnd_1
XFILLER_82_144 VGND VGND VPWR VPWR sky130_fd_sc_hd__decap_3
X_3047_ _3174_/B _3210_/B VGND VGND VPWR VPWR _3047_/Y sky130_fd_sc_hd__nor2_4
XTAP_TAPCELL_ROW_38_567 VGND VPWR sky130_fd_sc_hd__tapvpwrvgnd_1
XFILLER_11_439 VGND VGND VPWR VPWR sky130_fd_sc_hd__decap_3
XFILLER_23_266 VGND VGND VPWR VPWR sky130_fd_sc_hd__decap_3
XFILLER_23_299 VGND VGND VPWR VPWR sky130_fd_sc_hd__decap_3
X_4998_ clkload8/A _4998_/D VGND VGND VPWR VPWR _4998_/Q sky130_fd_sc_hd__dfxtp_2
XTAP_TAPCELL_ROW_21_401 VGND VPWR sky130_fd_sc_hd__tapvpwrvgnd_1
X_3949_ _3848_/A _3778_/D _3847_/Y _3924_/X _3948_/X VGND VGND VPWR VPWR _3949_/X
+ sky130_fd_sc_hd__o311a_2
XFILLER_2_137 VGND VGND VPWR VPWR sky130_fd_sc_hd__decap_3
XFILLER_78_406 VGND VGND VPWR VPWR sky130_fd_sc_hd__decap_3
XFILLER_78_439 VGND VGND VPWR VPWR sky130_fd_sc_hd__decap_3
XFILLER_58_141 VGND VGND VPWR VPWR sky130_fd_sc_hd__decap_3
XFILLER_19_517 VGND VGND VPWR VPWR sky130_fd_sc_hd__decap_3
XFILLER_48_88 VGND VGND VPWR VPWR sky130_fd_sc_hd__fill_1
XPHY_EDGE_ROW_45_Left_139 VGND VGND VPWR VPWR sky130_fd_sc_hd__decap_3
XFILLER_0_18 VGND VGND VPWR VPWR sky130_fd_sc_hd__decap_3
XFILLER_0_29 VGND VGND VPWR VPWR sky130_fd_sc_hd__decap_3
XFILLER_73_111 VGND VGND VPWR VPWR sky130_fd_sc_hd__fill_1
XFILLER_61_306 VGND VGND VPWR VPWR sky130_fd_sc_hd__decap_3
XFILLER_14_211 VGND VGND VPWR VPWR sky130_fd_sc_hd__decap_3
XFILLER_54_380 VGND VGND VPWR VPWR sky130_fd_sc_hd__decap_3
XFILLER_9_27 VGND VGND VPWR VPWR sky130_fd_sc_hd__decap_3
XFILLER_14_299 VGND VGND VPWR VPWR sky130_fd_sc_hd__decap_3
XPHY_EDGE_ROW_54_Left_148 VGND VGND VPWR VPWR sky130_fd_sc_hd__decap_3
XFILLER_10_450 VGND VGND VPWR VPWR sky130_fd_sc_hd__fill_2
XFILLER_10_483 VGND VGND VPWR VPWR sky130_fd_sc_hd__decap_3
XFILLER_6_421 VGND VGND VPWR VPWR sky130_fd_sc_hd__decap_3
XFILLER_6_454 VGND VGND VPWR VPWR sky130_fd_sc_hd__decap_3
XFILLER_6_498 VGND VGND VPWR VPWR sky130_fd_sc_hd__decap_3
XFILLER_36_6 VGND VGND VPWR VPWR sky130_fd_sc_hd__decap_3
XPHY_EDGE_ROW_63_Left_157 VGND VGND VPWR VPWR sky130_fd_sc_hd__decap_3
XFILLER_49_130 VGND VGND VPWR VPWR sky130_fd_sc_hd__decap_3
XFILLER_37_314 VGND VGND VPWR VPWR sky130_fd_sc_hd__decap_3
XFILLER_49_163 VGND VGND VPWR VPWR sky130_fd_sc_hd__decap_3
XFILLER_49_185 VGND VGND VPWR VPWR sky130_fd_sc_hd__decap_3
XFILLER_64_144 VGND VGND VPWR VPWR sky130_fd_sc_hd__decap_3
XFILLER_64_177 VGND VGND VPWR VPWR sky130_fd_sc_hd__decap_3
XTAP_TAPCELL_ROW_63_802 VGND VPWR sky130_fd_sc_hd__tapvpwrvgnd_1
XFILLER_92_475 VGND VGND VPWR VPWR sky130_fd_sc_hd__fill_1
X_4921_ _4994_/CLK _4921_/D VGND VGND VPWR VPWR _4921_/Q sky130_fd_sc_hd__dfxtp_2
XTAP_TAPCELL_ROW_35_537 VGND VPWR sky130_fd_sc_hd__tapvpwrvgnd_1
XFILLER_92_497 VGND VGND VPWR VPWR sky130_fd_sc_hd__decap_3
XFILLER_45_391 VGND VGND VPWR VPWR sky130_fd_sc_hd__fill_1
X_4852_ _5282_/Q _4854_/B _5277_/Q VGND VGND VPWR VPWR _4852_/Y sky130_fd_sc_hd__o21ai_2
XFILLER_20_203 VGND VGND VPWR VPWR sky130_fd_sc_hd__decap_3
XFILLER_60_361 VGND VGND VPWR VPWR sky130_fd_sc_hd__decap_3
XFILLER_60_383 VGND VGND VPWR VPWR sky130_fd_sc_hd__decap_3
X_3803_ _3803_/A _3803_/B VGND VGND VPWR VPWR _3804_/B sky130_fd_sc_hd__nand2_2
XPHY_EDGE_ROW_72_Left_166 VGND VGND VPWR VPWR sky130_fd_sc_hd__decap_3
X_4783_ _5164_/Q _4784_/B VGND VGND VPWR VPWR _4785_/A sky130_fd_sc_hd__and2_2
X_3734_ _3729_/X _3730_/X _3733_/X _2430_/Y VGND VGND VPWR VPWR _3739_/B sky130_fd_sc_hd__a22o_2
X_3665_ _4669_/S _3665_/B VGND VGND VPWR VPWR _4239_/A sky130_fd_sc_hd__nor2_2
XFILLER_9_292 VGND VGND VPWR VPWR sky130_fd_sc_hd__decap_3
XFILLER_9_281 VGND VGND VPWR VPWR sky130_fd_sc_hd__decap_3
X_2616_ _5159_/Q _4318_/A VGND VGND VPWR VPWR _4505_/S sky130_fd_sc_hd__nor2_2
X_3596_ _4957_/Q _4941_/Q _4925_/Q _4909_/Q _3732_/S0 _3732_/S1 VGND VGND VPWR VPWR
+ _3596_/X sky130_fd_sc_hd__mux4_2
X_2547_ _2677_/S _2544_/X _5130_/Q VGND VGND VPWR VPWR _2547_/X sky130_fd_sc_hd__o21a_2
XPHY_EDGE_ROW_81_Left_175 VGND VGND VPWR VPWR sky130_fd_sc_hd__decap_3
X_5266_ _5270_/CLK _5266_/D VGND VGND VPWR VPWR _5266_/Q sky130_fd_sc_hd__dfxtp_2
X_2478_ _5130_/Q _2475_/Y _2477_/Y _2473_/Y VGND VGND VPWR VPWR _4378_/A sky130_fd_sc_hd__o31a_2
XFILLER_87_225 VGND VGND VPWR VPWR sky130_fd_sc_hd__fill_2
X_4217_ _3884_/D _3631_/A _3631_/B _3886_/B VGND VGND VPWR VPWR _4217_/X sky130_fd_sc_hd__a211o_2
XFILLER_87_258 VGND VGND VPWR VPWR sky130_fd_sc_hd__decap_3
XFILLER_28_303 VGND VGND VPWR VPWR sky130_fd_sc_hd__decap_3
XFILLER_68_461 VGND VGND VPWR VPWR sky130_fd_sc_hd__decap_3
XFILLER_68_483 VGND VGND VPWR VPWR sky130_fd_sc_hd__decap_3
X_5197_ _5216_/CLK _5197_/D VGND VGND VPWR VPWR _5197_/Q sky130_fd_sc_hd__dfxtp_2
XFILLER_28_336 VGND VGND VPWR VPWR sky130_fd_sc_hd__fill_2
XFILLER_55_122 VGND VGND VPWR VPWR sky130_fd_sc_hd__decap_3
X_4148_ _4397_/D _4449_/S _4147_/Y VGND VGND VPWR VPWR _4148_/X sky130_fd_sc_hd__o21a_2
XFILLER_83_431 VGND VGND VPWR VPWR sky130_fd_sc_hd__decap_3
XFILLER_28_358 VGND VGND VPWR VPWR sky130_fd_sc_hd__decap_3
XFILLER_43_306 VGND VGND VPWR VPWR sky130_fd_sc_hd__fill_1
XFILLER_43_317 VGND VGND VPWR VPWR sky130_fd_sc_hd__decap_3
XFILLER_55_155 VGND VGND VPWR VPWR sky130_fd_sc_hd__decap_3
X_4079_ _4079_/A _4449_/S VGND VGND VPWR VPWR _4079_/Y sky130_fd_sc_hd__nand2_2
XFILLER_70_125 VGND VGND VPWR VPWR sky130_fd_sc_hd__decap_3
XFILLER_83_486 VGND VGND VPWR VPWR sky130_fd_sc_hd__decap_3
XPHY_EDGE_ROW_90_Left_184 VGND VGND VPWR VPWR sky130_fd_sc_hd__decap_3
Xclkload1 clkload1/A VGND VGND VPWR VPWR clkload1/Y sky130_fd_sc_hd__inv_6
XFILLER_50_78 VGND VGND VPWR VPWR sky130_fd_sc_hd__decap_3
XFILLER_1_3 VGND VGND VPWR VPWR sky130_fd_sc_hd__decap_3
XFILLER_78_225 VGND VGND VPWR VPWR sky130_fd_sc_hd__decap_3
XFILLER_78_203 VGND VGND VPWR VPWR sky130_fd_sc_hd__fill_1
XFILLER_66_409 VGND VGND VPWR VPWR sky130_fd_sc_hd__decap_3
XTAP_TAPCELL_ROW_6_262 VGND VPWR sky130_fd_sc_hd__tapvpwrvgnd_1
XFILLER_59_483 VGND VGND VPWR VPWR sky130_fd_sc_hd__decap_3
XFILLER_75_20 VGND VGND VPWR VPWR sky130_fd_sc_hd__fill_1
XPHY_EDGE_ROW_3_Left_97 VGND VGND VPWR VPWR sky130_fd_sc_hd__decap_3
XFILLER_74_442 VGND VGND VPWR VPWR sky130_fd_sc_hd__decap_3
XFILLER_75_64 VGND VGND VPWR VPWR sky130_fd_sc_hd__decap_3
XFILLER_15_520 VGND VGND VPWR VPWR sky130_fd_sc_hd__decap_3
XFILLER_27_380 VGND VGND VPWR VPWR sky130_fd_sc_hd__decap_3
XFILLER_74_486 VGND VGND VPWR VPWR sky130_fd_sc_hd__decap_3
XFILLER_27_391 VGND VGND VPWR VPWR sky130_fd_sc_hd__fill_1
XFILLER_61_147 VGND VGND VPWR VPWR sky130_fd_sc_hd__decap_3
XFILLER_61_169 VGND VGND VPWR VPWR sky130_fd_sc_hd__decap_3
XFILLER_91_30 VGND VGND VPWR VPWR sky130_fd_sc_hd__decap_3
XTAP_TAPCELL_ROW_32_507 VGND VPWR sky130_fd_sc_hd__tapvpwrvgnd_1
XFILLER_91_74 VGND VGND VPWR VPWR sky130_fd_sc_hd__decap_3
XFILLER_30_523 VGND VGND VPWR VPWR sky130_fd_sc_hd__decap_3
XFILLER_42_383 VGND VGND VPWR VPWR sky130_fd_sc_hd__fill_1
XFILLER_10_280 VGND VGND VPWR VPWR sky130_fd_sc_hd__decap_3
XTAP_TAPCELL_ROW_40_584 VGND VPWR sky130_fd_sc_hd__tapvpwrvgnd_1
XFILLER_6_251 VGND VGND VPWR VPWR sky130_fd_sc_hd__fill_1
XFILLER_6_284 VGND VGND VPWR VPWR sky130_fd_sc_hd__decap_3
X_3450_ _3494_/A _3450_/B VGND VGND VPWR VPWR _5203_/D sky130_fd_sc_hd__nor2_2
X_3381_ _3494_/A _3381_/B VGND VGND VPWR VPWR _5194_/D sky130_fd_sc_hd__nor2_2
XFILLER_34_3 VGND VGND VPWR VPWR sky130_fd_sc_hd__decap_3
X_5120_ clkload5/A _5120_/D VGND VGND VPWR VPWR _5120_/Q sky130_fd_sc_hd__dfxtp_2
X_5051_ _5101_/CLK _5051_/D VGND VGND VPWR VPWR _5051_/Q sky130_fd_sc_hd__dfxtp_2
X_4002_ _4016_/A _4002_/B VGND VGND VPWR VPWR _4002_/Y sky130_fd_sc_hd__nor2_2
XFILLER_84_206 VGND VGND VPWR VPWR sky130_fd_sc_hd__fill_2
XFILLER_37_100 VGND VGND VPWR VPWR sky130_fd_sc_hd__decap_3
XTAP_TAPCELL_ROW_48_662 VGND VPWR sky130_fd_sc_hd__tapvpwrvgnd_1
XFILLER_52_103 VGND VGND VPWR VPWR sky130_fd_sc_hd__decap_3
X_4904_ _5010_/CLK _4904_/D VGND VGND VPWR VPWR _4904_/Q sky130_fd_sc_hd__dfxtp_2
XFILLER_80_489 VGND VGND VPWR VPWR sky130_fd_sc_hd__decap_3
XFILLER_33_383 VGND VGND VPWR VPWR sky130_fd_sc_hd__decap_3
XFILLER_60_191 VGND VGND VPWR VPWR sky130_fd_sc_hd__decap_3
X_4835_ _4835_/A _4835_/B VGND VGND VPWR VPWR _4839_/A sky130_fd_sc_hd__and2_2
X_4766_ _4761_/X _4764_/Y _4765_/Y VGND VGND VPWR VPWR _4766_/Y sky130_fd_sc_hd__o21ai_2
X_3717_ _5070_/Q _5054_/Q _5038_/Q _5022_/Q _5131_/Q _5132_/Q VGND VGND VPWR VPWR
+ _3718_/B sky130_fd_sc_hd__mux4_2
XFILLER_20_15 VGND VGND VPWR VPWR sky130_fd_sc_hd__decap_3
X_4697_ _5243_/Q _4725_/B VGND VGND VPWR VPWR _4697_/X sky130_fd_sc_hd__or2_2
X_3648_ _4966_/Q _4950_/Q _4934_/Q _4918_/Q _5131_/Q _5132_/Q VGND VGND VPWR VPWR
+ _3648_/X sky130_fd_sc_hd__mux4_2
X_3579_ _3577_/X _3578_/X _3961_/S VGND VGND VPWR VPWR _3579_/X sky130_fd_sc_hd__mux2_1
XFILLER_0_405 VGND VGND VPWR VPWR sky130_fd_sc_hd__decap_3
XTAP_TAPCELL_ROW_93_1093 VGND VPWR sky130_fd_sc_hd__tapvpwrvgnd_1
XTAP_TAPCELL_ROW_93_1082 VGND VPWR sky130_fd_sc_hd__tapvpwrvgnd_1
XFILLER_88_556 VGND VGND VPWR VPWR sky130_fd_sc_hd__fill_2
XFILLER_29_57 VGND VGND VPWR VPWR sky130_fd_sc_hd__fill_1
X_5249_ _5253_/CLK _5249_/D VGND VGND VPWR VPWR _5249_/Q sky130_fd_sc_hd__dfxtp_2
XFILLER_28_100 VGND VGND VPWR VPWR sky130_fd_sc_hd__decap_3
XFILLER_68_280 VGND VGND VPWR VPWR sky130_fd_sc_hd__decap_3
XFILLER_75_228 VGND VGND VPWR VPWR sky130_fd_sc_hd__fill_2
XTAP_TAPCELL_ROW_3_232 VGND VPWR sky130_fd_sc_hd__tapvpwrvgnd_1
XTAP_TAPCELL_ROW_74_908 VGND VPWR sky130_fd_sc_hd__tapvpwrvgnd_1
XFILLER_16_317 VGND VGND VPWR VPWR sky130_fd_sc_hd__fill_2
XFILLER_16_339 VGND VGND VPWR VPWR sky130_fd_sc_hd__decap_3
XFILLER_71_445 VGND VGND VPWR VPWR sky130_fd_sc_hd__decap_3
XFILLER_12_512 VGND VGND VPWR VPWR sky130_fd_sc_hd__decap_3
XFILLER_24_361 VGND VGND VPWR VPWR sky130_fd_sc_hd__decap_3
XFILLER_43_169 VGND VGND VPWR VPWR sky130_fd_sc_hd__fill_2
XTAP_TAPCELL_ROW_82_985 VGND VPWR sky130_fd_sc_hd__tapvpwrvgnd_1
XFILLER_24_383 VGND VGND VPWR VPWR sky130_fd_sc_hd__fill_1
XFILLER_61_11 VGND VGND VPWR VPWR sky130_fd_sc_hd__decap_3
XFILLER_61_66 VGND VGND VPWR VPWR sky130_fd_sc_hd__decap_3
XFILLER_8_527 VGND VGND VPWR VPWR sky130_fd_sc_hd__decap_3
XFILLER_3_243 VGND VGND VPWR VPWR sky130_fd_sc_hd__decap_3
XFILLER_10_81 VGND VGND VPWR VPWR sky130_fd_sc_hd__decap_3
XFILLER_79_523 VGND VGND VPWR VPWR sky130_fd_sc_hd__fill_2
XFILLER_20_9 VGND VGND VPWR VPWR sky130_fd_sc_hd__decap_3
XFILLER_66_217 VGND VGND VPWR VPWR sky130_fd_sc_hd__decap_3
XFILLER_86_52 VGND VGND VPWR VPWR sky130_fd_sc_hd__fill_2
XFILLER_47_431 VGND VGND VPWR VPWR sky130_fd_sc_hd__decap_3
XFILLER_59_291 VGND VGND VPWR VPWR sky130_fd_sc_hd__decap_3
XFILLER_86_85 VGND VGND VPWR VPWR sky130_fd_sc_hd__fill_2
XFILLER_47_464 VGND VGND VPWR VPWR sky130_fd_sc_hd__decap_3
XFILLER_74_250 VGND VGND VPWR VPWR sky130_fd_sc_hd__fill_2
XFILLER_19_166 VGND VGND VPWR VPWR sky130_fd_sc_hd__fill_2
XFILLER_34_103 VGND VGND VPWR VPWR sky130_fd_sc_hd__decap_3
XFILLER_34_147 VGND VGND VPWR VPWR sky130_fd_sc_hd__fill_1
XFILLER_62_434 VGND VGND VPWR VPWR sky130_fd_sc_hd__decap_3
XTAP_TAPCELL_ROW_45_632 VGND VPWR sky130_fd_sc_hd__tapvpwrvgnd_1
XFILLER_22_309 VGND VGND VPWR VPWR sky130_fd_sc_hd__decap_3
X_2950_ _5277_/Q _5257_/Q _5241_/Q _4854_/A _2949_/X VGND VGND VPWR VPWR _2950_/X
+ sky130_fd_sc_hd__a221o_2
XTAP_TAPCELL_ROW_17_367 VGND VPWR sky130_fd_sc_hd__tapvpwrvgnd_1
XFILLER_15_383 VGND VGND VPWR VPWR sky130_fd_sc_hd__decap_3
X_2881_ _2887_/A _2881_/B VGND VGND VPWR VPWR _2881_/Y sky130_fd_sc_hd__nor2_2
X_4620_ _4200_/B _4189_/A _4174_/C _4145_/A _4619_/X VGND VGND VPWR VPWR _4620_/Y
+ sky130_fd_sc_hd__a221oi_2
XFILLER_30_386 VGND VGND VPWR VPWR sky130_fd_sc_hd__decap_3
X_4551_ _4551_/A _4571_/B VGND VGND VPWR VPWR _4551_/X sky130_fd_sc_hd__or2_2
X_4482_ _4291_/X _4293_/Y _4515_/B VGND VGND VPWR VPWR _4482_/X sky130_fd_sc_hd__mux2_1
X_3502_ _4954_/Q _4938_/Q _4922_/Q _4906_/Q _5131_/Q _5132_/Q VGND VGND VPWR VPWR
+ _3502_/X sky130_fd_sc_hd__mux4_2
X_3433_ _3433_/A _3458_/A _3431_/X VGND VGND VPWR VPWR _3433_/X sky130_fd_sc_hd__or3b_2
X_5103_ _5103_/CLK _5103_/D VGND VGND VPWR VPWR _5103_/Q sky130_fd_sc_hd__dfxtp_2
X_3364_ _3364_/A _3364_/B _3378_/B VGND VGND VPWR VPWR _3366_/B sky130_fd_sc_hd__or3b_2
X_3295_ _5269_/Q _3305_/B _3294_/X _3338_/B VGND VGND VPWR VPWR _5148_/D sky130_fd_sc_hd__o211a_2
XFILLER_85_515 VGND VGND VPWR VPWR sky130_fd_sc_hd__decap_3
XFILLER_57_228 VGND VGND VPWR VPWR sky130_fd_sc_hd__fill_1
X_5034_ _5101_/CLK _5034_/D VGND VGND VPWR VPWR _5034_/Q sky130_fd_sc_hd__dfxtp_2
XFILLER_85_548 VGND VGND VPWR VPWR sky130_fd_sc_hd__decap_3
XTAP_TAPCELL_ROW_0_202 VGND VPWR sky130_fd_sc_hd__tapvpwrvgnd_1
XFILLER_38_486 VGND VGND VPWR VPWR sky130_fd_sc_hd__decap_3
XFILLER_53_423 VGND VGND VPWR VPWR sky130_fd_sc_hd__fill_1
XTAP_TAPCELL_ROW_84_1004 VGND VPWR sky130_fd_sc_hd__tapvpwrvgnd_1
XFILLER_80_220 VGND VGND VPWR VPWR sky130_fd_sc_hd__decap_3
XFILLER_25_169 VGND VGND VPWR VPWR sky130_fd_sc_hd__decap_3
XFILLER_40_117 VGND VGND VPWR VPWR sky130_fd_sc_hd__decap_3
XFILLER_53_478 VGND VGND VPWR VPWR sky130_fd_sc_hd__decap_3
XFILLER_21_320 VGND VGND VPWR VPWR sky130_fd_sc_hd__decap_3
XFILLER_80_297 VGND VGND VPWR VPWR sky130_fd_sc_hd__decap_3
XFILLER_21_331 VGND VGND VPWR VPWR sky130_fd_sc_hd__decap_3
XFILLER_21_364 VGND VGND VPWR VPWR sky130_fd_sc_hd__decap_3
XFILLER_33_191 VGND VGND VPWR VPWR sky130_fd_sc_hd__decap_3
X_4818_ _4818_/A _4818_/B VGND VGND VPWR VPWR _4823_/A sky130_fd_sc_hd__nand2_2
XFILLER_5_508 VGND VGND VPWR VPWR sky130_fd_sc_hd__fill_2
X_4749_ _4750_/A _4750_/B VGND VGND VPWR VPWR _4749_/Y sky130_fd_sc_hd__nand2_2
XFILLER_31_69 VGND VGND VPWR VPWR sky130_fd_sc_hd__decap_3
Xoutput58 _5149_/Q VGND VGND VPWR VPWR INSTR_ADDR[12] sky130_fd_sc_hd__clkdlybuf4s25_1
XFILLER_0_246 VGND VGND VPWR VPWR sky130_fd_sc_hd__decap_3
Xoutput69 _5145_/Q VGND VGND VPWR VPWR INSTR_ADDR[8] sky130_fd_sc_hd__clkdlybuf4s25_1
XFILLER_88_320 VGND VGND VPWR VPWR sky130_fd_sc_hd__decap_3
XFILLER_0_268 VGND VGND VPWR VPWR sky130_fd_sc_hd__decap_3
XFILLER_88_353 VGND VGND VPWR VPWR sky130_fd_sc_hd__decap_3
XFILLER_29_420 VGND VGND VPWR VPWR sky130_fd_sc_hd__decap_3
XFILLER_29_486 VGND VGND VPWR VPWR sky130_fd_sc_hd__decap_3
XFILLER_56_250 VGND VGND VPWR VPWR sky130_fd_sc_hd__fill_2
XFILLER_56_261 VGND VGND VPWR VPWR sky130_fd_sc_hd__decap_3
XFILLER_56_283 VGND VGND VPWR VPWR sky130_fd_sc_hd__decap_3
XFILLER_16_125 VGND VGND VPWR VPWR sky130_fd_sc_hd__decap_3
XFILLER_16_147 VGND VGND VPWR VPWR sky130_fd_sc_hd__decap_3
XFILLER_44_445 VGND VGND VPWR VPWR sky130_fd_sc_hd__decap_3
XFILLER_71_220 VGND VGND VPWR VPWR sky130_fd_sc_hd__decap_3
XFILLER_72_32 VGND VGND VPWR VPWR sky130_fd_sc_hd__decap_3
XTAP_TAPCELL_ROW_42_602 VGND VPWR sky130_fd_sc_hd__tapvpwrvgnd_1
XTAP_TAPCELL_ROW_14_337 VGND VPWR sky130_fd_sc_hd__tapvpwrvgnd_1
XFILLER_12_342 VGND VGND VPWR VPWR sky130_fd_sc_hd__decap_3
XFILLER_8_346 VGND VGND VPWR VPWR sky130_fd_sc_hd__decap_3
XFILLER_8_324 VGND VGND VPWR VPWR sky130_fd_sc_hd__fill_2
XFILLER_4_530 VGND VGND VPWR VPWR sky130_fd_sc_hd__fill_2
XFILLER_79_364 VGND VGND VPWR VPWR sky130_fd_sc_hd__decap_3
X_3080_ _2944_/X _3065_/Y _3066_/Y _4996_/Q VGND VGND VPWR VPWR _4996_/D sky130_fd_sc_hd__a22o_2
XFILLER_82_518 VGND VGND VPWR VPWR sky130_fd_sc_hd__decap_3
XFILLER_82_507 VGND VGND VPWR VPWR sky130_fd_sc_hd__fill_2
XFILLER_90_551 VGND VGND VPWR VPWR sky130_fd_sc_hd__decap_3
XFILLER_35_467 VGND VGND VPWR VPWR sky130_fd_sc_hd__fill_2
XFILLER_50_404 VGND VGND VPWR VPWR sky130_fd_sc_hd__decap_3
XFILLER_62_275 VGND VGND VPWR VPWR sky130_fd_sc_hd__decap_3
X_3982_ _3964_/X _3972_/X _3981_/X _3954_/Y _4503_/A VGND VGND VPWR VPWR _3983_/B
+ sky130_fd_sc_hd__a32o_2
XFILLER_22_139 VGND VGND VPWR VPWR sky130_fd_sc_hd__fill_1
X_2933_ _5277_/Q _5252_/Q _5220_/Q _5276_/Q VGND VGND VPWR VPWR _2933_/X sky130_fd_sc_hd__a22o_2
XFILLER_30_150 VGND VGND VPWR VPWR sky130_fd_sc_hd__decap_3
X_2864_ _3820_/A _2864_/B VGND VGND VPWR VPWR _2865_/B sky130_fd_sc_hd__xnor2_2
X_4603_ _4199_/C _4261_/C _4686_/B1 _3776_/A _4602_/X VGND VGND VPWR VPWR _4604_/C
+ sky130_fd_sc_hd__o221a_2
X_2795_ _4896_/Q _4880_/Q _5104_/Q _5088_/Q _2851_/S0 _2854_/S1 VGND VGND VPWR VPWR
+ _2795_/X sky130_fd_sc_hd__mux4_2
X_4534_ _4533_/X _4470_/X _4681_/S VGND VGND VPWR VPWR _4534_/X sky130_fd_sc_hd__mux2_1
XFILLER_7_71 VGND VGND VPWR VPWR sky130_fd_sc_hd__decap_3
X_4465_ _4408_/A _4408_/B _4406_/X VGND VGND VPWR VPWR _4467_/B sky130_fd_sc_hd__a21oi_2
X_4396_ _4394_/X _4395_/X _4458_/A VGND VGND VPWR VPWR _4402_/A sky130_fd_sc_hd__o21a_2
X_3416_ _3416_/A _3416_/B VGND VGND VPWR VPWR _3416_/Y sky130_fd_sc_hd__xnor2_2
XFILLER_58_504 VGND VGND VPWR VPWR sky130_fd_sc_hd__decap_3
X_3347_ _5183_/Q _3230_/B _3230_/Y _3346_/X VGND VGND VPWR VPWR _5183_/D sky130_fd_sc_hd__o22a_2
XTAP_TAPCELL_ROW_90_1052 VGND VPWR sky130_fd_sc_hd__tapvpwrvgnd_1
X_5017_ _5107_/CLK _5017_/D VGND VGND VPWR VPWR _5017_/Q sky130_fd_sc_hd__dfxtp_2
X_3278_ _3311_/S _3308_/B VGND VGND VPWR VPWR _3278_/X sky130_fd_sc_hd__and2_2
XFILLER_85_356 VGND VGND VPWR VPWR sky130_fd_sc_hd__fill_1
XFILLER_73_529 VGND VGND VPWR VPWR sky130_fd_sc_hd__decap_3
XTAP_TAPCELL_ROW_56_738 VGND VPWR sky130_fd_sc_hd__tapvpwrvgnd_1
XFILLER_85_389 VGND VGND VPWR VPWR sky130_fd_sc_hd__decap_3
XFILLER_41_404 VGND VGND VPWR VPWR sky130_fd_sc_hd__decap_3
XFILLER_53_275 VGND VGND VPWR VPWR sky130_fd_sc_hd__decap_3
XFILLER_42_35 VGND VGND VPWR VPWR sky130_fd_sc_hd__fill_2
XFILLER_21_172 VGND VGND VPWR VPWR sky130_fd_sc_hd__decap_3
XTAP_TAPCELL_ROW_11_307 VGND VPWR sky130_fd_sc_hd__tapvpwrvgnd_1
XFILLER_5_305 VGND VGND VPWR VPWR sky130_fd_sc_hd__decap_3
XFILLER_1_500 VGND VGND VPWR VPWR sky130_fd_sc_hd__decap_3
XFILLER_1_511 VGND VGND VPWR VPWR sky130_fd_sc_hd__decap_3
XFILLER_1_544 VGND VGND VPWR VPWR sky130_fd_sc_hd__decap_3
XFILLER_3_29 VGND VGND VPWR VPWR sky130_fd_sc_hd__decap_3
XFILLER_49_537 VGND VGND VPWR VPWR sky130_fd_sc_hd__decap_3
XFILLER_67_65 VGND VGND VPWR VPWR sky130_fd_sc_hd__decap_3
XFILLER_88_161 VGND VGND VPWR VPWR sky130_fd_sc_hd__decap_3
XFILLER_76_312 VGND VGND VPWR VPWR sky130_fd_sc_hd__decap_3
XFILLER_76_389 VGND VGND VPWR VPWR sky130_fd_sc_hd__decap_3
XFILLER_17_445 VGND VGND VPWR VPWR sky130_fd_sc_hd__decap_3
XFILLER_44_231 VGND VGND VPWR VPWR sky130_fd_sc_hd__fill_1
XFILLER_83_31 VGND VGND VPWR VPWR sky130_fd_sc_hd__decap_3
XFILLER_32_404 VGND VGND VPWR VPWR sky130_fd_sc_hd__decap_3
XFILLER_44_242 VGND VGND VPWR VPWR sky130_fd_sc_hd__decap_3
XFILLER_44_253 VGND VGND VPWR VPWR sky130_fd_sc_hd__decap_3
XFILLER_72_551 VGND VGND VPWR VPWR sky130_fd_sc_hd__decap_3
XTAP_TAPCELL_ROW_27_462 VGND VPWR sky130_fd_sc_hd__tapvpwrvgnd_1
XFILLER_83_86 VGND VGND VPWR VPWR sky130_fd_sc_hd__decap_3
XFILLER_8_121 VGND VGND VPWR VPWR sky130_fd_sc_hd__fill_2
XFILLER_40_492 VGND VGND VPWR VPWR sky130_fd_sc_hd__decap_3
XFILLER_66_6 VGND VGND VPWR VPWR sky130_fd_sc_hd__fill_1
XFILLER_8_187 VGND VGND VPWR VPWR sky130_fd_sc_hd__decap_3
X_2580_ _5065_/Q _5049_/Q _5033_/Q _5017_/Q _2672_/S0 _2672_/S1 VGND VGND VPWR VPWR
+ _2580_/X sky130_fd_sc_hd__mux4_2
X_4250_ _4249_/X _4250_/B _4250_/C VGND VGND VPWR VPWR _4250_/X sky130_fd_sc_hd__and3b_2
X_4181_ _4267_/S _4181_/B VGND VGND VPWR VPWR _4181_/Y sky130_fd_sc_hd__nor2_2
X_3201_ _2924_/X _3193_/B _3193_/Y _5102_/Q VGND VGND VPWR VPWR _5102_/D sky130_fd_sc_hd__a22o_2
X_3132_ _2934_/X _3121_/B _3121_/Y _5041_/Q VGND VGND VPWR VPWR _5041_/D sky130_fd_sc_hd__a22o_2
XFILLER_79_183 VGND VGND VPWR VPWR sky130_fd_sc_hd__fill_1
XFILLER_67_356 VGND VGND VPWR VPWR sky130_fd_sc_hd__decap_3
XFILLER_55_529 VGND VGND VPWR VPWR sky130_fd_sc_hd__decap_3
XFILLER_67_378 VGND VGND VPWR VPWR sky130_fd_sc_hd__decap_3
X_3063_ _2947_/X _3047_/Y _3048_/Y _4981_/Q VGND VGND VPWR VPWR _4981_/D sky130_fd_sc_hd__a22o_2
XFILLER_82_315 VGND VGND VPWR VPWR sky130_fd_sc_hd__decap_3
XFILLER_63_540 VGND VGND VPWR VPWR sky130_fd_sc_hd__decap_3
XFILLER_35_264 VGND VGND VPWR VPWR sky130_fd_sc_hd__decap_3
XTAP_TAPCELL_ROW_53_708 VGND VPWR sky130_fd_sc_hd__tapvpwrvgnd_1
XFILLER_50_212 VGND VGND VPWR VPWR sky130_fd_sc_hd__decap_3
X_3965_ _3853_/Y _3856_/Y _3969_/S VGND VGND VPWR VPWR _3965_/X sky130_fd_sc_hd__mux2_1
X_3896_ _2862_/A _3817_/Y _3895_/Y VGND VGND VPWR VPWR _3898_/B sky130_fd_sc_hd__o21ai_2
X_2916_ _5276_/Q _5215_/Q _5199_/Q _5275_/Q VGND VGND VPWR VPWR _2918_/A sky130_fd_sc_hd__a22o_2
XTAP_TAPCELL_ROW_61_785 VGND VPWR sky130_fd_sc_hd__tapvpwrvgnd_1
XFILLER_12_27 VGND VGND VPWR VPWR sky130_fd_sc_hd__fill_1
X_2847_ _5138_/Q _2842_/X _2844_/X _2846_/X VGND VGND VPWR VPWR _4834_/B sky130_fd_sc_hd__a22o_2
X_2778_ _4894_/Q _4878_/Q _5102_/Q _5086_/Q _2851_/S0 _2854_/S1 VGND VGND VPWR VPWR
+ _2778_/X sky130_fd_sc_hd__mux4_2
X_4517_ _4312_/Y _4513_/X _4516_/X _4304_/X VGND VGND VPWR VPWR _4518_/C sky130_fd_sc_hd__o22a_2
X_4448_ _4147_/A _3834_/B _4449_/S VGND VGND VPWR VPWR _4448_/X sky130_fd_sc_hd__mux2_1
XFILLER_58_323 VGND VGND VPWR VPWR sky130_fd_sc_hd__fill_2
X_4379_ _4379_/A _4382_/A _4382_/B VGND VGND VPWR VPWR _4379_/X sky130_fd_sc_hd__or3_2
XFILLER_46_507 VGND VGND VPWR VPWR sky130_fd_sc_hd__decap_3
XFILLER_85_142 VGND VGND VPWR VPWR sky130_fd_sc_hd__decap_3
XFILLER_37_57 VGND VGND VPWR VPWR sky130_fd_sc_hd__decap_3
XFILLER_73_315 VGND VGND VPWR VPWR sky130_fd_sc_hd__decap_3
XFILLER_26_253 VGND VGND VPWR VPWR sky130_fd_sc_hd__decap_3
XFILLER_81_370 VGND VGND VPWR VPWR sky130_fd_sc_hd__fill_1
XFILLER_41_245 VGND VGND VPWR VPWR sky130_fd_sc_hd__decap_3
XFILLER_53_78 VGND VGND VPWR VPWR sky130_fd_sc_hd__decap_3
XTAP_TAPCELL_ROW_24_432 VGND VPWR sky130_fd_sc_hd__tapvpwrvgnd_1
XFILLER_1_330 VGND VGND VPWR VPWR sky130_fd_sc_hd__decap_3
XFILLER_78_53 VGND VGND VPWR VPWR sky130_fd_sc_hd__decap_3
XFILLER_1_385 VGND VGND VPWR VPWR sky130_fd_sc_hd__decap_3
XFILLER_49_367 VGND VGND VPWR VPWR sky130_fd_sc_hd__decap_3
XFILLER_64_315 VGND VGND VPWR VPWR sky130_fd_sc_hd__decap_3
XFILLER_76_153 VGND VGND VPWR VPWR sky130_fd_sc_hd__decap_3
XFILLER_64_337 VGND VGND VPWR VPWR sky130_fd_sc_hd__decap_3
XFILLER_76_197 VGND VGND VPWR VPWR sky130_fd_sc_hd__decap_3
XFILLER_45_540 VGND VGND VPWR VPWR sky130_fd_sc_hd__decap_3
XFILLER_32_212 VGND VGND VPWR VPWR sky130_fd_sc_hd__decap_3
XFILLER_32_245 VGND VGND VPWR VPWR sky130_fd_sc_hd__decap_3
X_3750_ _3750_/A _3934_/A _3715_/Y VGND VGND VPWR VPWR _3777_/C sky130_fd_sc_hd__or3b_2
X_2701_ _2894_/A _4168_/A _2702_/B VGND VGND VPWR VPWR _2701_/X sky130_fd_sc_hd__and3_2
XFILLER_9_452 VGND VGND VPWR VPWR sky130_fd_sc_hd__fill_1
XFILLER_9_430 VGND VGND VPWR VPWR sky130_fd_sc_hd__decap_3
X_3681_ _5073_/Q _5057_/Q _5041_/Q _5025_/Q _3706_/S0 _3706_/S1 VGND VGND VPWR VPWR
+ _3681_/X sky130_fd_sc_hd__mux4_2
X_2632_ _5072_/Q _5056_/Q _5040_/Q _5024_/Q _2672_/S0 _2672_/S1 VGND VGND VPWR VPWR
+ _2633_/B sky130_fd_sc_hd__mux4_2
X_2563_ _2557_/X _2558_/X _2561_/X _2433_/Y VGND VGND VPWR VPWR _4393_/D sky130_fd_sc_hd__a22o_2
X_4302_ _4302_/A _4302_/B VGND VGND VPWR VPWR _4302_/X sky130_fd_sc_hd__or2_2
X_5282_ _5285_/CLK _5282_/D VGND VGND VPWR VPWR _5282_/Q sky130_fd_sc_hd__dfxtp_2
X_4233_ _3631_/A _4233_/B VGND VGND VPWR VPWR _4233_/X sky130_fd_sc_hd__and2b_2
X_2494_ _2695_/B _2495_/B VGND VGND VPWR VPWR _3778_/B sky130_fd_sc_hd__and2_2
XFILLER_4_94 VGND VGND VPWR VPWR sky130_fd_sc_hd__fill_1
XFILLER_87_429 VGND VGND VPWR VPWR sky130_fd_sc_hd__decap_3
XFILLER_67_131 VGND VGND VPWR VPWR sky130_fd_sc_hd__fill_2
X_4164_ _5220_/Q _4847_/B VGND VGND VPWR VPWR _4164_/X sky130_fd_sc_hd__or2_2
XFILLER_28_518 VGND VGND VPWR VPWR sky130_fd_sc_hd__decap_3
XFILLER_55_304 VGND VGND VPWR VPWR sky130_fd_sc_hd__decap_3
XFILLER_67_164 VGND VGND VPWR VPWR sky130_fd_sc_hd__decap_3
X_4095_ _4175_/A _3584_/B _4070_/X VGND VGND VPWR VPWR _4107_/A sky130_fd_sc_hd__o21a_2
X_3115_ _2937_/X _3119_/A2 _3103_/Y _5026_/Q VGND VGND VPWR VPWR _5026_/D sky130_fd_sc_hd__a22o_2
XFILLER_55_337 VGND VGND VPWR VPWR sky130_fd_sc_hd__decap_3
X_3046_ _5193_/Q _5192_/Q _3046_/C VGND VGND VPWR VPWR _3210_/B sky130_fd_sc_hd__or3_2
XTAP_TAPCELL_ROW_66_833 VGND VPWR sky130_fd_sc_hd__tapvpwrvgnd_1
XFILLER_82_123 VGND VGND VPWR VPWR sky130_fd_sc_hd__decap_3
XFILLER_70_318 VGND VGND VPWR VPWR sky130_fd_sc_hd__decap_3
XFILLER_82_178 VGND VGND VPWR VPWR sky130_fd_sc_hd__decap_3
X_4997_ _5008_/CLK _4997_/D VGND VGND VPWR VPWR _4997_/Q sky130_fd_sc_hd__dfxtp_2
XTAP_TAPCELL_ROW_21_402 VGND VPWR sky130_fd_sc_hd__tapvpwrvgnd_1
X_3948_ _3932_/X _3948_/B _3948_/C _3948_/D VGND VGND VPWR VPWR _3948_/X sky130_fd_sc_hd__and4b_2
X_3879_ _4320_/A _4449_/S VGND VGND VPWR VPWR _3879_/Y sky130_fd_sc_hd__nor2_2
XFILLER_78_418 VGND VGND VPWR VPWR sky130_fd_sc_hd__fill_2
XFILLER_86_440 VGND VGND VPWR VPWR sky130_fd_sc_hd__decap_3
XFILLER_46_315 VGND VGND VPWR VPWR sky130_fd_sc_hd__decap_3
XFILLER_58_164 VGND VGND VPWR VPWR sky130_fd_sc_hd__decap_3
XFILLER_61_318 VGND VGND VPWR VPWR sky130_fd_sc_hd__decap_3
XFILLER_73_156 VGND VGND VPWR VPWR sky130_fd_sc_hd__decap_3
XFILLER_42_521 VGND VGND VPWR VPWR sky130_fd_sc_hd__decap_3
XFILLER_64_66 VGND VGND VPWR VPWR sky130_fd_sc_hd__decap_3
XFILLER_64_88 VGND VGND VPWR VPWR sky130_fd_sc_hd__decap_3
XFILLER_73_178 VGND VGND VPWR VPWR sky130_fd_sc_hd__decap_3
XFILLER_14_223 VGND VGND VPWR VPWR sky130_fd_sc_hd__decap_3
XFILLER_42_554 VGND VGND VPWR VPWR sky130_fd_sc_hd__decap_3
XFILLER_54_392 VGND VGND VPWR VPWR sky130_fd_sc_hd__decap_3
XFILLER_6_411 VGND VGND VPWR VPWR sky130_fd_sc_hd__decap_3
XFILLER_10_473 VGND VGND VPWR VPWR sky130_fd_sc_hd__decap_3
XFILLER_13_92 VGND VGND VPWR VPWR sky130_fd_sc_hd__decap_3
XFILLER_6_433 VGND VGND VPWR VPWR sky130_fd_sc_hd__decap_3
XFILLER_6_477 VGND VGND VPWR VPWR sky130_fd_sc_hd__decap_3
XFILLER_89_52 VGND VGND VPWR VPWR sky130_fd_sc_hd__decap_3
XFILLER_89_30 VGND VGND VPWR VPWR sky130_fd_sc_hd__decap_3
XFILLER_29_6 VGND VGND VPWR VPWR sky130_fd_sc_hd__decap_3
XFILLER_77_440 VGND VGND VPWR VPWR sky130_fd_sc_hd__fill_2
XFILLER_49_142 VGND VGND VPWR VPWR sky130_fd_sc_hd__decap_3
XFILLER_49_175 VGND VGND VPWR VPWR sky130_fd_sc_hd__decap_3
XFILLER_92_410 VGND VGND VPWR VPWR sky130_fd_sc_hd__fill_2
XFILLER_77_473 VGND VGND VPWR VPWR sky130_fd_sc_hd__decap_3
XFILLER_77_462 VGND VGND VPWR VPWR sky130_fd_sc_hd__fill_2
XFILLER_37_326 VGND VGND VPWR VPWR sky130_fd_sc_hd__decap_3
XFILLER_37_348 VGND VGND VPWR VPWR sky130_fd_sc_hd__decap_3
XFILLER_64_112 VGND VGND VPWR VPWR sky130_fd_sc_hd__decap_3
XFILLER_92_443 VGND VGND VPWR VPWR sky130_fd_sc_hd__decap_3
XFILLER_92_421 VGND VGND VPWR VPWR sky130_fd_sc_hd__decap_3
XFILLER_64_156 VGND VGND VPWR VPWR sky130_fd_sc_hd__fill_1
XTAP_TAPCELL_ROW_63_803 VGND VPWR sky130_fd_sc_hd__tapvpwrvgnd_1
XFILLER_45_370 VGND VGND VPWR VPWR sky130_fd_sc_hd__decap_3
XFILLER_52_318 VGND VGND VPWR VPWR sky130_fd_sc_hd__fill_2
X_4920_ _5010_/CLK _4920_/D VGND VGND VPWR VPWR _4920_/Q sky130_fd_sc_hd__dfxtp_2
XTAP_TAPCELL_ROW_35_538 VGND VPWR sky130_fd_sc_hd__tapvpwrvgnd_1
X_4851_ _5286_/Q _2465_/X _4694_/Y VGND VGND VPWR VPWR _4851_/X sky130_fd_sc_hd__a21o_2
X_3802_ _3616_/A _3741_/Y _3800_/Y _3793_/Y _3735_/X VGND VGND VPWR VPWR _3803_/B
+ sky130_fd_sc_hd__a311o_2
XFILLER_20_215 VGND VGND VPWR VPWR sky130_fd_sc_hd__decap_3
XFILLER_60_395 VGND VGND VPWR VPWR sky130_fd_sc_hd__decap_3
X_4782_ _4854_/B _4780_/X _4781_/X _3338_/B VGND VGND VPWR VPWR _5265_/D sky130_fd_sc_hd__o211a_2
XTAP_TAPCELL_ROW_71_880 VGND VPWR sky130_fd_sc_hd__tapvpwrvgnd_1
XFILLER_20_259 VGND VGND VPWR VPWR sky130_fd_sc_hd__fill_1
X_3733_ _3731_/X _3732_/X _3733_/S VGND VGND VPWR VPWR _3733_/X sky130_fd_sc_hd__mux2_1
X_3664_ _4365_/A _3808_/B VGND VGND VPWR VPWR _3665_/B sky130_fd_sc_hd__and2_2
Xclkload30 _5241_/CLK VGND VGND VPWR VPWR clkload30/X sky130_fd_sc_hd__clkbuf_8
X_2615_ _3820_/A _2864_/B _2589_/A VGND VGND VPWR VPWR _2866_/A sky130_fd_sc_hd__a21o_2
X_3595_ _5117_/Q _5005_/Q _4989_/Q _4973_/Q _3732_/S0 _3732_/S1 VGND VGND VPWR VPWR
+ _3595_/X sky130_fd_sc_hd__mux4_2
X_2546_ _5129_/Q _2546_/B VGND VGND VPWR VPWR _2546_/X sky130_fd_sc_hd__or2_2
X_5265_ _5286_/CLK _5265_/D VGND VGND VPWR VPWR _5265_/Q sky130_fd_sc_hd__dfxtp_2
X_2477_ _2677_/S _2477_/B VGND VGND VPWR VPWR _2477_/Y sky130_fd_sc_hd__nor2_2
XFILLER_87_204 VGND VGND VPWR VPWR sky130_fd_sc_hd__decap_3
X_4216_ _4175_/A _4018_/X _4070_/X VGND VGND VPWR VPWR _4219_/A sky130_fd_sc_hd__o21a_2
X_5196_ _5283_/CLK _5196_/D VGND VGND VPWR VPWR _5196_/Q sky130_fd_sc_hd__dfxtp_2
XFILLER_68_473 VGND VGND VPWR VPWR sky130_fd_sc_hd__decap_3
X_4147_ _4147_/A _4449_/S VGND VGND VPWR VPWR _4147_/Y sky130_fd_sc_hd__nand2_2
XFILLER_55_134 VGND VGND VPWR VPWR sky130_fd_sc_hd__decap_3
XTAP_TAPCELL_ROW_87_1024 VGND VPWR sky130_fd_sc_hd__tapvpwrvgnd_1
XFILLER_83_410 VGND VGND VPWR VPWR sky130_fd_sc_hd__decap_3
XFILLER_55_167 VGND VGND VPWR VPWR sky130_fd_sc_hd__fill_1
X_4078_ _4078_/A _4078_/B _4078_/C VGND VGND VPWR VPWR _4078_/X sky130_fd_sc_hd__or3_2
XFILLER_83_465 VGND VGND VPWR VPWR sky130_fd_sc_hd__decap_3
XFILLER_24_521 VGND VGND VPWR VPWR sky130_fd_sc_hd__decap_3
XFILLER_36_370 VGND VGND VPWR VPWR sky130_fd_sc_hd__decap_3
XFILLER_43_329 VGND VGND VPWR VPWR sky130_fd_sc_hd__decap_3
XFILLER_55_189 VGND VGND VPWR VPWR sky130_fd_sc_hd__decap_3
XFILLER_70_104 VGND VGND VPWR VPWR sky130_fd_sc_hd__decap_3
X_3029_ _3494_/A _3029_/B VGND VGND VPWR VPWR _3029_/Y sky130_fd_sc_hd__nor2_4
XFILLER_24_554 VGND VGND VPWR VPWR sky130_fd_sc_hd__decap_3
XFILLER_51_340 VGND VGND VPWR VPWR sky130_fd_sc_hd__decap_3
XFILLER_51_373 VGND VGND VPWR VPWR sky130_fd_sc_hd__decap_3
XFILLER_11_259 VGND VGND VPWR VPWR sky130_fd_sc_hd__decap_3
Xclkload2 clkload2/A VGND VGND VPWR VPWR clkload2/Y sky130_fd_sc_hd__inv_12
XFILLER_7_219 VGND VGND VPWR VPWR sky130_fd_sc_hd__fill_1
XFILLER_50_35 VGND VGND VPWR VPWR sky130_fd_sc_hd__decap_3
XFILLER_3_447 VGND VGND VPWR VPWR sky130_fd_sc_hd__fill_1
XFILLER_59_55 VGND VGND VPWR VPWR sky130_fd_sc_hd__fill_1
XFILLER_59_99 VGND VGND VPWR VPWR sky130_fd_sc_hd__decap_3
XFILLER_78_259 VGND VGND VPWR VPWR sky130_fd_sc_hd__decap_3
XFILLER_78_237 VGND VGND VPWR VPWR sky130_fd_sc_hd__decap_3
XTAP_TAPCELL_ROW_6_263 VGND VPWR sky130_fd_sc_hd__tapvpwrvgnd_1
XFILLER_19_337 VGND VGND VPWR VPWR sky130_fd_sc_hd__decap_3
XFILLER_59_495 VGND VGND VPWR VPWR sky130_fd_sc_hd__fill_1
XFILLER_74_410 VGND VGND VPWR VPWR sky130_fd_sc_hd__fill_2
XFILLER_74_421 VGND VGND VPWR VPWR sky130_fd_sc_hd__fill_1
XFILLER_46_167 VGND VGND VPWR VPWR sky130_fd_sc_hd__fill_2
XFILLER_15_532 VGND VGND VPWR VPWR sky130_fd_sc_hd__decap_3
XFILLER_15_554 VGND VGND VPWR VPWR sky130_fd_sc_hd__decap_3
XFILLER_42_340 VGND VGND VPWR VPWR sky130_fd_sc_hd__decap_3
XFILLER_42_362 VGND VGND VPWR VPWR sky130_fd_sc_hd__fill_2
XTAP_TAPCELL_ROW_32_508 VGND VPWR sky130_fd_sc_hd__tapvpwrvgnd_1
XFILLER_24_80 VGND VGND VPWR VPWR sky130_fd_sc_hd__decap_3
XTAP_TAPCELL_ROW_40_585 VGND VPWR sky130_fd_sc_hd__tapvpwrvgnd_1
X_3380_ _5194_/Q _4854_/B _3458_/A _3379_/Y VGND VGND VPWR VPWR _3381_/B sky130_fd_sc_hd__o2bb2a_2
XFILLER_69_204 VGND VGND VPWR VPWR sky130_fd_sc_hd__decap_3
X_5050_ _5099_/CLK _5050_/D VGND VGND VPWR VPWR _5050_/Q sky130_fd_sc_hd__dfxtp_2
XFILLER_27_3 VGND VGND VPWR VPWR sky130_fd_sc_hd__decap_3
X_4001_ _3615_/B _4434_/A _4000_/X VGND VGND VPWR VPWR _4001_/X sky130_fd_sc_hd__o21ba_2
XFILLER_37_134 VGND VGND VPWR VPWR sky130_fd_sc_hd__decap_3
XFILLER_92_251 VGND VGND VPWR VPWR sky130_fd_sc_hd__fill_1
XFILLER_25_329 VGND VGND VPWR VPWR sky130_fd_sc_hd__decap_3
XFILLER_65_476 VGND VGND VPWR VPWR sky130_fd_sc_hd__decap_3
X_4903_ _5111_/CLK _4903_/D VGND VGND VPWR VPWR _4903_/Q sky130_fd_sc_hd__dfxtp_2
XFILLER_92_295 VGND VGND VPWR VPWR sky130_fd_sc_hd__decap_3
XFILLER_80_457 VGND VGND VPWR VPWR sky130_fd_sc_hd__decap_3
XFILLER_80_435 VGND VGND VPWR VPWR sky130_fd_sc_hd__decap_3
XFILLER_21_502 VGND VGND VPWR VPWR sky130_fd_sc_hd__fill_2
XFILLER_21_513 VGND VGND VPWR VPWR sky130_fd_sc_hd__decap_3
XFILLER_33_351 VGND VGND VPWR VPWR sky130_fd_sc_hd__decap_3
X_4834_ _5170_/Q _4834_/B VGND VGND VPWR VPWR _4835_/B sky130_fd_sc_hd__or2_2
X_4765_ _4761_/X _4764_/Y _4854_/B VGND VGND VPWR VPWR _4765_/Y sky130_fd_sc_hd__a21oi_2
X_3716_ _4894_/Q _4878_/Q _5102_/Q _5086_/Q _5131_/Q _5132_/Q VGND VGND VPWR VPWR
+ _3716_/X sky130_fd_sc_hd__mux4_2
X_4696_ input33/X _4694_/Y _4695_/X _3366_/A VGND VGND VPWR VPWR _5242_/D sky130_fd_sc_hd__o211a_2
XFILLER_20_27 VGND VGND VPWR VPWR sky130_fd_sc_hd__fill_1
XFILLER_20_38 VGND VGND VPWR VPWR sky130_fd_sc_hd__decap_3
X_3647_ _3733_/S _3646_/X _5134_/Q VGND VGND VPWR VPWR _3647_/X sky130_fd_sc_hd__o21a_2
X_3578_ _4376_/B _4376_/A _3874_/S VGND VGND VPWR VPWR _3578_/X sky130_fd_sc_hd__mux2_1
XFILLER_0_417 VGND VGND VPWR VPWR sky130_fd_sc_hd__decap_3
X_2529_ _2524_/X _2525_/X _2528_/X _2433_/Y VGND VGND VPWR VPWR _4393_/A sky130_fd_sc_hd__a22o_2
XTAP_TAPCELL_ROW_93_1094 VGND VPWR sky130_fd_sc_hd__tapvpwrvgnd_1
XTAP_TAPCELL_ROW_93_1083 VGND VPWR sky130_fd_sc_hd__tapvpwrvgnd_1
X_5248_ _5283_/CLK _5248_/D VGND VGND VPWR VPWR _5248_/Q sky130_fd_sc_hd__dfxtp_2
XFILLER_56_421 VGND VGND VPWR VPWR sky130_fd_sc_hd__fill_2
X_5179_ _5260_/CLK _5179_/D VGND VGND VPWR VPWR _5179_/Q sky130_fd_sc_hd__dfxtp_2
XTAP_TAPCELL_ROW_3_233 VGND VPWR sky130_fd_sc_hd__tapvpwrvgnd_1
XFILLER_56_443 VGND VGND VPWR VPWR sky130_fd_sc_hd__decap_3
XTAP_TAPCELL_ROW_74_909 VGND VPWR sky130_fd_sc_hd__tapvpwrvgnd_1
XFILLER_83_240 VGND VGND VPWR VPWR sky130_fd_sc_hd__decap_3
XFILLER_71_424 VGND VGND VPWR VPWR sky130_fd_sc_hd__decap_3
XFILLER_83_284 VGND VGND VPWR VPWR sky130_fd_sc_hd__decap_3
XFILLER_83_273 VGND VGND VPWR VPWR sky130_fd_sc_hd__decap_3
XFILLER_43_137 VGND VGND VPWR VPWR sky130_fd_sc_hd__decap_3
XFILLER_45_57 VGND VGND VPWR VPWR sky130_fd_sc_hd__decap_3
XFILLER_12_546 VGND VGND VPWR VPWR sky130_fd_sc_hd__decap_3
XFILLER_61_45 VGND VGND VPWR VPWR sky130_fd_sc_hd__decap_3
XFILLER_6_29 VGND VGND VPWR VPWR sky130_fd_sc_hd__fill_2
XFILLER_3_277 VGND VGND VPWR VPWR sky130_fd_sc_hd__decap_3
XFILLER_79_557 VGND VGND VPWR VPWR sky130_fd_sc_hd__fill_1
XFILLER_19_123 VGND VGND VPWR VPWR sky130_fd_sc_hd__decap_3
XFILLER_47_410 VGND VGND VPWR VPWR sky130_fd_sc_hd__decap_3
XFILLER_59_281 VGND VGND VPWR VPWR sky130_fd_sc_hd__decap_3
XFILLER_66_229 VGND VGND VPWR VPWR sky130_fd_sc_hd__decap_3
XFILLER_19_80 VGND VGND VPWR VPWR sky130_fd_sc_hd__decap_3
XFILLER_47_443 VGND VGND VPWR VPWR sky130_fd_sc_hd__decap_3
XFILLER_47_476 VGND VGND VPWR VPWR sky130_fd_sc_hd__decap_3
XFILLER_62_402 VGND VGND VPWR VPWR sky130_fd_sc_hd__decap_3
XFILLER_62_446 VGND VGND VPWR VPWR sky130_fd_sc_hd__decap_3
XTAP_TAPCELL_ROW_45_633 VGND VPWR sky130_fd_sc_hd__tapvpwrvgnd_1
XFILLER_15_340 VGND VGND VPWR VPWR sky130_fd_sc_hd__fill_1
XFILLER_70_490 VGND VGND VPWR VPWR sky130_fd_sc_hd__fill_1
X_2880_ _3776_/A _2880_/B VGND VGND VPWR VPWR _2881_/B sky130_fd_sc_hd__xnor2_2
XFILLER_30_398 VGND VGND VPWR VPWR sky130_fd_sc_hd__decap_3
X_4550_ _4550_/A _4550_/B _4550_/C _4550_/D VGND VGND VPWR VPWR _4550_/X sky130_fd_sc_hd__and4_2
X_4481_ _4481_/A _4481_/B _4481_/C VGND VGND VPWR VPWR _4481_/X sky130_fd_sc_hd__and3_2
X_3501_ _5114_/Q _5002_/Q _4986_/Q _4970_/Q _5131_/Q _5132_/Q VGND VGND VPWR VPWR
+ _3501_/X sky130_fd_sc_hd__mux4_2
X_3432_ _3432_/A _3432_/B _3432_/C VGND VGND VPWR VPWR _3433_/A sky130_fd_sc_hd__and3_2
X_3363_ _3363_/A _4847_/A _3363_/C VGND VGND VPWR VPWR _3378_/B sky130_fd_sc_hd__or3_2
X_5102_ _5102_/CLK _5102_/D VGND VGND VPWR VPWR _5102_/Q sky130_fd_sc_hd__dfxtp_2
X_3294_ _3291_/X _3293_/Y _3315_/B VGND VGND VPWR VPWR _3294_/X sky130_fd_sc_hd__a21o_2
XFILLER_85_505 VGND VGND VPWR VPWR sky130_fd_sc_hd__decap_3
XFILLER_38_421 VGND VGND VPWR VPWR sky130_fd_sc_hd__decap_3
X_5033_ _5069_/CLK _5033_/D VGND VGND VPWR VPWR _5033_/Q sky130_fd_sc_hd__dfxtp_2
XFILLER_85_527 VGND VGND VPWR VPWR sky130_fd_sc_hd__decap_3
XFILLER_38_465 VGND VGND VPWR VPWR sky130_fd_sc_hd__decap_3
XTAP_TAPCELL_ROW_0_203 VGND VPWR sky130_fd_sc_hd__tapvpwrvgnd_1
XFILLER_65_284 VGND VGND VPWR VPWR sky130_fd_sc_hd__fill_2
XFILLER_53_435 VGND VGND VPWR VPWR sky130_fd_sc_hd__decap_3
XFILLER_15_27 VGND VGND VPWR VPWR sky130_fd_sc_hd__decap_3
XFILLER_80_276 VGND VGND VPWR VPWR sky130_fd_sc_hd__decap_3
XFILLER_21_343 VGND VGND VPWR VPWR sky130_fd_sc_hd__decap_3
X_4817_ _4800_/A _4809_/B _4815_/B _4816_/Y _4807_/Y VGND VGND VPWR VPWR _4818_/B
+ sky130_fd_sc_hd__o221a_2
XFILLER_31_15 VGND VGND VPWR VPWR sky130_fd_sc_hd__decap_3
XFILLER_31_26 VGND VGND VPWR VPWR sky130_fd_sc_hd__decap_3
X_4748_ _4742_/A _4742_/B _4739_/A VGND VGND VPWR VPWR _4750_/B sky130_fd_sc_hd__a21o_2
X_4679_ _4677_/X _4678_/Y _4692_/A VGND VGND VPWR VPWR _5240_/D sky130_fd_sc_hd__a21oi_2
XPHY_EDGE_ROW_1_Right_1 VGND VGND VPWR VPWR sky130_fd_sc_hd__decap_3
XFILLER_0_203 VGND VGND VPWR VPWR sky130_fd_sc_hd__decap_3
XFILLER_0_225 VGND VGND VPWR VPWR sky130_fd_sc_hd__decap_3
Xoutput59 _5150_/Q VGND VGND VPWR VPWR INSTR_ADDR[13] sky130_fd_sc_hd__clkdlybuf4s25_1
XFILLER_88_332 VGND VGND VPWR VPWR sky130_fd_sc_hd__decap_3
XFILLER_88_365 VGND VGND VPWR VPWR sky130_fd_sc_hd__decap_3
XFILLER_29_410 VGND VGND VPWR VPWR sky130_fd_sc_hd__fill_2
XFILLER_88_387 VGND VGND VPWR VPWR sky130_fd_sc_hd__decap_3
XFILLER_29_432 VGND VGND VPWR VPWR sky130_fd_sc_hd__decap_3
XTAP_TAPCELL_ROW_59_758 VGND VPWR sky130_fd_sc_hd__tapvpwrvgnd_1
XFILLER_91_508 VGND VGND VPWR VPWR sky130_fd_sc_hd__decap_3
XFILLER_56_67 VGND VGND VPWR VPWR sky130_fd_sc_hd__fill_1
XFILLER_16_137 VGND VGND VPWR VPWR sky130_fd_sc_hd__decap_3
XFILLER_44_457 VGND VGND VPWR VPWR sky130_fd_sc_hd__decap_3
XFILLER_56_295 VGND VGND VPWR VPWR sky130_fd_sc_hd__decap_3
XFILLER_16_159 VGND VGND VPWR VPWR sky130_fd_sc_hd__decap_3
XFILLER_31_107 VGND VGND VPWR VPWR sky130_fd_sc_hd__decap_3
XFILLER_71_276 VGND VGND VPWR VPWR sky130_fd_sc_hd__decap_3
XTAP_TAPCELL_ROW_42_603 VGND VPWR sky130_fd_sc_hd__tapvpwrvgnd_1
XFILLER_12_321 VGND VGND VPWR VPWR sky130_fd_sc_hd__fill_1
XFILLER_71_287 VGND VGND VPWR VPWR sky130_fd_sc_hd__fill_1
XFILLER_12_354 VGND VGND VPWR VPWR sky130_fd_sc_hd__decap_3
XTAP_TAPCELL_ROW_14_338 VGND VPWR sky130_fd_sc_hd__tapvpwrvgnd_1
XFILLER_12_376 VGND VGND VPWR VPWR sky130_fd_sc_hd__fill_2
XTAP_TAPCELL_ROW_50_680 VGND VPWR sky130_fd_sc_hd__tapvpwrvgnd_1
XFILLER_8_358 VGND VGND VPWR VPWR sky130_fd_sc_hd__decap_3
XFILLER_4_542 VGND VGND VPWR VPWR sky130_fd_sc_hd__decap_3
XFILLER_21_92 VGND VGND VPWR VPWR sky130_fd_sc_hd__fill_1
XFILLER_79_343 VGND VGND VPWR VPWR sky130_fd_sc_hd__decap_3
XFILLER_67_505 VGND VGND VPWR VPWR sky130_fd_sc_hd__decap_3
XFILLER_79_376 VGND VGND VPWR VPWR sky130_fd_sc_hd__decap_3
XFILLER_67_527 VGND VGND VPWR VPWR sky130_fd_sc_hd__decap_3
XFILLER_79_398 VGND VGND VPWR VPWR sky130_fd_sc_hd__decap_3
XFILLER_47_240 VGND VGND VPWR VPWR sky130_fd_sc_hd__decap_3
XFILLER_35_402 VGND VGND VPWR VPWR sky130_fd_sc_hd__decap_3
XFILLER_35_435 VGND VGND VPWR VPWR sky130_fd_sc_hd__decap_3
XFILLER_47_295 VGND VGND VPWR VPWR sky130_fd_sc_hd__decap_3
XFILLER_50_416 VGND VGND VPWR VPWR sky130_fd_sc_hd__decap_3
X_3981_ _3973_/X _4518_/A _3981_/C _3981_/D VGND VGND VPWR VPWR _3981_/X sky130_fd_sc_hd__and4b_2
XFILLER_22_118 VGND VGND VPWR VPWR sky130_fd_sc_hd__decap_3
X_2932_ _4880_/Q _2902_/Y _2931_/X _2951_/B2 VGND VGND VPWR VPWR _4880_/D sky130_fd_sc_hd__a22o_2
XFILLER_15_181 VGND VGND VPWR VPWR sky130_fd_sc_hd__decap_3
X_2863_ _2873_/A _2863_/B VGND VGND VPWR VPWR _2863_/Y sky130_fd_sc_hd__nor2_2
X_4602_ _3567_/S _4191_/A _4602_/S VGND VGND VPWR VPWR _4602_/X sky130_fd_sc_hd__mux2_1
X_2794_ _2857_/A _4784_/B VGND VGND VPWR VPWR _2794_/X sky130_fd_sc_hd__and2_2
X_4533_ _4346_/B _4390_/A _4638_/S VGND VGND VPWR VPWR _4533_/X sky130_fd_sc_hd__mux2_1
XFILLER_7_50 VGND VGND VPWR VPWR sky130_fd_sc_hd__decap_3
XFILLER_7_391 VGND VGND VPWR VPWR sky130_fd_sc_hd__fill_1
X_4464_ _4464_/A _4464_/B VGND VGND VPWR VPWR _4467_/A sky130_fd_sc_hd__xnor2_2
X_4395_ _4393_/B _4393_/C _4393_/D _4393_/A VGND VGND VPWR VPWR _4395_/X sky130_fd_sc_hd__a22o_2
X_3415_ _3415_/A _3415_/B VGND VGND VPWR VPWR _3416_/B sky130_fd_sc_hd__nor2_2
X_3346_ _5283_/Q _3366_/A _3346_/C VGND VGND VPWR VPWR _3346_/X sky130_fd_sc_hd__and3_2
XTAP_TAPCELL_ROW_90_1053 VGND VPWR sky130_fd_sc_hd__tapvpwrvgnd_1
XFILLER_58_527 VGND VGND VPWR VPWR sky130_fd_sc_hd__decap_3
XFILLER_58_549 VGND VGND VPWR VPWR sky130_fd_sc_hd__decap_3
XFILLER_85_302 VGND VGND VPWR VPWR sky130_fd_sc_hd__fill_2
XFILLER_73_508 VGND VGND VPWR VPWR sky130_fd_sc_hd__decap_3
X_5016_ _5069_/CLK _5016_/D VGND VGND VPWR VPWR _5016_/Q sky130_fd_sc_hd__dfxtp_2
X_3277_ _5144_/Q _5143_/Q _5142_/Q _3277_/D VGND VGND VPWR VPWR _3308_/B sky130_fd_sc_hd__and4_2
XFILLER_26_15 VGND VGND VPWR VPWR sky130_fd_sc_hd__fill_1
XFILLER_26_402 VGND VGND VPWR VPWR sky130_fd_sc_hd__decap_3
XFILLER_26_446 VGND VGND VPWR VPWR sky130_fd_sc_hd__decap_3
XFILLER_53_221 VGND VGND VPWR VPWR sky130_fd_sc_hd__decap_3
XFILLER_81_541 VGND VGND VPWR VPWR sky130_fd_sc_hd__decap_3
XFILLER_26_59 VGND VGND VPWR VPWR sky130_fd_sc_hd__decap_3
XFILLER_13_107 VGND VGND VPWR VPWR sky130_fd_sc_hd__decap_3
XFILLER_41_449 VGND VGND VPWR VPWR sky130_fd_sc_hd__decap_3
XFILLER_42_58 VGND VGND VPWR VPWR sky130_fd_sc_hd__decap_3
XTAP_TAPCELL_ROW_11_308 VGND VPWR sky130_fd_sc_hd__tapvpwrvgnd_1
XFILLER_21_195 VGND VGND VPWR VPWR sky130_fd_sc_hd__fill_2
XFILLER_5_317 VGND VGND VPWR VPWR sky130_fd_sc_hd__fill_1
XFILLER_1_523 VGND VGND VPWR VPWR sky130_fd_sc_hd__decap_3
XFILLER_1_556 VGND VGND VPWR VPWR sky130_fd_sc_hd__fill_2
XFILLER_49_505 VGND VGND VPWR VPWR sky130_fd_sc_hd__decap_3
XFILLER_88_173 VGND VGND VPWR VPWR sky130_fd_sc_hd__decap_3
XFILLER_76_324 VGND VGND VPWR VPWR sky130_fd_sc_hd__fill_2
XFILLER_67_77 VGND VGND VPWR VPWR sky130_fd_sc_hd__fill_2
XFILLER_76_368 VGND VGND VPWR VPWR sky130_fd_sc_hd__decap_3
XFILLER_29_251 VGND VGND VPWR VPWR sky130_fd_sc_hd__decap_3
XFILLER_17_424 VGND VGND VPWR VPWR sky130_fd_sc_hd__decap_3
XFILLER_29_295 VGND VGND VPWR VPWR sky130_fd_sc_hd__decap_3
XFILLER_44_210 VGND VGND VPWR VPWR sky130_fd_sc_hd__decap_3
XFILLER_83_43 VGND VGND VPWR VPWR sky130_fd_sc_hd__decap_3
XFILLER_17_457 VGND VGND VPWR VPWR sky130_fd_sc_hd__decap_3
XFILLER_17_479 VGND VGND VPWR VPWR sky130_fd_sc_hd__decap_3
XFILLER_83_76 VGND VGND VPWR VPWR sky130_fd_sc_hd__fill_2
XFILLER_32_416 VGND VGND VPWR VPWR sky130_fd_sc_hd__decap_3
XFILLER_32_427 VGND VGND VPWR VPWR sky130_fd_sc_hd__fill_2
XFILLER_44_287 VGND VGND VPWR VPWR sky130_fd_sc_hd__decap_3
XFILLER_32_449 VGND VGND VPWR VPWR sky130_fd_sc_hd__decap_3
XFILLER_12_162 VGND VGND VPWR VPWR sky130_fd_sc_hd__decap_3
XFILLER_8_100 VGND VGND VPWR VPWR sky130_fd_sc_hd__decap_3
XFILLER_32_80 VGND VGND VPWR VPWR sky130_fd_sc_hd__decap_3
XFILLER_4_383 VGND VGND VPWR VPWR sky130_fd_sc_hd__decap_3
X_4180_ _4179_/X _4129_/A _4266_/S VGND VGND VPWR VPWR _4181_/B sky130_fd_sc_hd__mux2_1
X_3200_ _2921_/X _3193_/B _3193_/Y _5101_/Q VGND VGND VPWR VPWR _5101_/D sky130_fd_sc_hd__a22o_2
XFILLER_79_140 VGND VGND VPWR VPWR sky130_fd_sc_hd__fill_2
XFILLER_67_302 VGND VGND VPWR VPWR sky130_fd_sc_hd__decap_3
XFILLER_67_324 VGND VGND VPWR VPWR sky130_fd_sc_hd__fill_2
X_3131_ _2931_/X _3121_/B _3121_/Y _5040_/Q VGND VGND VPWR VPWR _5040_/D sky130_fd_sc_hd__a22o_2
XFILLER_55_508 VGND VGND VPWR VPWR sky130_fd_sc_hd__decap_3
XFILLER_67_346 VGND VGND VPWR VPWR sky130_fd_sc_hd__fill_2
X_3062_ _2944_/X _3047_/Y _3048_/Y _4980_/Q VGND VGND VPWR VPWR _4980_/D sky130_fd_sc_hd__a22o_2
XFILLER_82_349 VGND VGND VPWR VPWR sky130_fd_sc_hd__decap_3
XTAP_TAPCELL_ROW_53_709 VGND VPWR sky130_fd_sc_hd__tapvpwrvgnd_1
XFILLER_23_427 VGND VGND VPWR VPWR sky130_fd_sc_hd__decap_3
XFILLER_90_382 VGND VGND VPWR VPWR sky130_fd_sc_hd__fill_1
XFILLER_23_449 VGND VGND VPWR VPWR sky130_fd_sc_hd__decap_3
XFILLER_50_235 VGND VGND VPWR VPWR sky130_fd_sc_hd__decap_3
X_3964_ _2443_/X _2867_/B _3959_/X _3963_/Y VGND VGND VPWR VPWR _3964_/X sky130_fd_sc_hd__o211a_2
XFILLER_31_471 VGND VGND VPWR VPWR sky130_fd_sc_hd__decap_3
XFILLER_50_279 VGND VGND VPWR VPWR sky130_fd_sc_hd__decap_3
X_3895_ _2862_/A _3817_/Y _3894_/X VGND VGND VPWR VPWR _3895_/Y sky130_fd_sc_hd__a21oi_2
X_2915_ _4875_/Q _2942_/A2 _2914_/X _2951_/B2 VGND VGND VPWR VPWR _4875_/D sky130_fd_sc_hd__a22o_2
X_2846_ _2832_/A _2845_/X _2435_/Y VGND VGND VPWR VPWR _2846_/X sky130_fd_sc_hd__o21a_2
X_2777_ _5070_/Q _5054_/Q _5038_/Q _5022_/Q _2851_/S0 _2854_/S1 VGND VGND VPWR VPWR
+ _2777_/X sky130_fd_sc_hd__mux4_2
XFILLER_2_309 VGND VGND VPWR VPWR sky130_fd_sc_hd__fill_1
X_4516_ _4514_/X _4571_/A _4572_/S VGND VGND VPWR VPWR _4516_/X sky130_fd_sc_hd__mux2_1
X_4447_ _4487_/A _4441_/X _4446_/Y _4312_/Y VGND VGND VPWR VPWR _4447_/X sky130_fd_sc_hd__a211o_2
X_4378_ _4378_/A _4378_/B VGND VGND VPWR VPWR _4382_/B sky130_fd_sc_hd__nand2_2
XFILLER_58_335 VGND VGND VPWR VPWR sky130_fd_sc_hd__decap_3
X_3329_ _5162_/Q _4868_/A2 _3230_/Y _3328_/X VGND VGND VPWR VPWR _5162_/D sky130_fd_sc_hd__o22a_2
XTAP_TAPCELL_ROW_69_853 VGND VPWR sky130_fd_sc_hd__tapvpwrvgnd_1
XFILLER_46_519 VGND VGND VPWR VPWR sky130_fd_sc_hd__decap_3
XFILLER_58_368 VGND VGND VPWR VPWR sky130_fd_sc_hd__decap_3
XFILLER_26_221 VGND VGND VPWR VPWR sky130_fd_sc_hd__decap_3
XFILLER_37_69 VGND VGND VPWR VPWR sky130_fd_sc_hd__decap_3
XFILLER_73_349 VGND VGND VPWR VPWR sky130_fd_sc_hd__decap_3
XFILLER_54_552 VGND VGND VPWR VPWR sky130_fd_sc_hd__decap_3
XFILLER_14_416 VGND VGND VPWR VPWR sky130_fd_sc_hd__decap_3
XFILLER_26_265 VGND VGND VPWR VPWR sky130_fd_sc_hd__decap_3
XFILLER_81_382 VGND VGND VPWR VPWR sky130_fd_sc_hd__decap_3
XFILLER_53_57 VGND VGND VPWR VPWR sky130_fd_sc_hd__decap_3
XTAP_TAPCELL_ROW_24_433 VGND VPWR sky130_fd_sc_hd__tapvpwrvgnd_1
XFILLER_81_393 VGND VGND VPWR VPWR sky130_fd_sc_hd__decap_3
XFILLER_5_169 VGND VGND VPWR VPWR sky130_fd_sc_hd__decap_3
XFILLER_78_32 VGND VGND VPWR VPWR sky130_fd_sc_hd__fill_1
XFILLER_78_21 VGND VGND VPWR VPWR sky130_fd_sc_hd__fill_2
XFILLER_1_353 VGND VGND VPWR VPWR sky130_fd_sc_hd__decap_3
XFILLER_78_76 VGND VGND VPWR VPWR sky130_fd_sc_hd__decap_3
XFILLER_49_324 VGND VGND VPWR VPWR sky130_fd_sc_hd__decap_3
XFILLER_49_346 VGND VGND VPWR VPWR sky130_fd_sc_hd__decap_3
XFILLER_76_121 VGND VGND VPWR VPWR sky130_fd_sc_hd__decap_3
XFILLER_37_519 VGND VGND VPWR VPWR sky130_fd_sc_hd__fill_1
XFILLER_49_379 VGND VGND VPWR VPWR sky130_fd_sc_hd__decap_3
XFILLER_76_165 VGND VGND VPWR VPWR sky130_fd_sc_hd__decap_3
XFILLER_57_390 VGND VGND VPWR VPWR sky130_fd_sc_hd__fill_2
XFILLER_64_327 VGND VGND VPWR VPWR sky130_fd_sc_hd__decap_3
XFILLER_64_349 VGND VGND VPWR VPWR sky130_fd_sc_hd__decap_3
XFILLER_45_552 VGND VGND VPWR VPWR sky130_fd_sc_hd__decap_3
XFILLER_91_146 VGND VGND VPWR VPWR sky130_fd_sc_hd__fill_2
XFILLER_17_265 VGND VGND VPWR VPWR sky130_fd_sc_hd__decap_3
XFILLER_72_360 VGND VGND VPWR VPWR sky130_fd_sc_hd__decap_3
XFILLER_72_382 VGND VGND VPWR VPWR sky130_fd_sc_hd__decap_3
XFILLER_32_224 VGND VGND VPWR VPWR sky130_fd_sc_hd__decap_3
XFILLER_60_533 VGND VGND VPWR VPWR sky130_fd_sc_hd__decap_3
XFILLER_60_555 VGND VGND VPWR VPWR sky130_fd_sc_hd__decap_3
XFILLER_20_408 VGND VGND VPWR VPWR sky130_fd_sc_hd__fill_1
XFILLER_43_90 VGND VGND VPWR VPWR sky130_fd_sc_hd__decap_3
X_2700_ _2894_/A _2706_/B _2702_/B VGND VGND VPWR VPWR _2700_/X sky130_fd_sc_hd__and3_2
X_3680_ _3705_/A _3680_/B VGND VGND VPWR VPWR _3680_/Y sky130_fd_sc_hd__nor2_2
X_2631_ _2872_/A _3831_/A _4086_/A _2543_/Y VGND VGND VPWR VPWR _2877_/A sky130_fd_sc_hd__a31o_2
X_2562_ _2557_/X _2558_/X _2561_/X _2433_/Y VGND VGND VPWR VPWR _3828_/B sky130_fd_sc_hd__a22oi_2
X_4301_ _5159_/Q _4301_/B VGND VGND VPWR VPWR _4302_/B sky130_fd_sc_hd__and2_2
X_5281_ _5283_/CLK _5281_/D VGND VGND VPWR VPWR _5281_/Q sky130_fd_sc_hd__dfxtp_2
X_4232_ _5223_/Q _4275_/B _4213_/Y _4231_/X _3366_/A VGND VGND VPWR VPWR _5223_/D
+ sky130_fd_sc_hd__o221a_2
X_2493_ _5170_/Q _4365_/A VGND VGND VPWR VPWR _2495_/B sky130_fd_sc_hd__or2_2
XFILLER_87_408 VGND VGND VPWR VPWR sky130_fd_sc_hd__decap_3
XFILLER_4_62 VGND VGND VPWR VPWR sky130_fd_sc_hd__decap_3
X_4163_ _4143_/X _4161_/X _4162_/Y _4158_/Y _4213_/A VGND VGND VPWR VPWR _4163_/X
+ sky130_fd_sc_hd__o32a_2
XFILLER_55_316 VGND VGND VPWR VPWR sky130_fd_sc_hd__decap_3
X_4094_ _4199_/D _4094_/B VGND VGND VPWR VPWR _4094_/X sky130_fd_sc_hd__xor2_2
X_3114_ _2934_/X _3119_/A2 _3103_/Y _5025_/Q VGND VGND VPWR VPWR _5025_/D sky130_fd_sc_hd__a22o_2
XFILLER_55_349 VGND VGND VPWR VPWR sky130_fd_sc_hd__decap_3
XFILLER_67_187 VGND VGND VPWR VPWR sky130_fd_sc_hd__decap_3
X_3045_ _2950_/X _3028_/Y _3029_/Y _4966_/Q VGND VGND VPWR VPWR _4966_/D sky130_fd_sc_hd__a22o_2
XFILLER_48_390 VGND VGND VPWR VPWR sky130_fd_sc_hd__decap_3
XTAP_TAPCELL_ROW_38_558 VGND VPWR sky130_fd_sc_hd__tapvpwrvgnd_1
XFILLER_51_511 VGND VGND VPWR VPWR sky130_fd_sc_hd__decap_3
XFILLER_51_555 VGND VGND VPWR VPWR sky130_fd_sc_hd__decap_3
XFILLER_63_393 VGND VGND VPWR VPWR sky130_fd_sc_hd__decap_3
X_4996_ _5008_/CLK _4996_/D VGND VGND VPWR VPWR _4996_/Q sky130_fd_sc_hd__dfxtp_2
XFILLER_23_257 VGND VGND VPWR VPWR sky130_fd_sc_hd__decap_3
X_3947_ _3944_/X _3947_/B _3947_/C _3947_/D VGND VGND VPWR VPWR _3948_/D sky130_fd_sc_hd__and4b_2
XTAP_TAPCELL_ROW_21_403 VGND VPWR sky130_fd_sc_hd__tapvpwrvgnd_1
X_3878_ _3873_/X _3877_/X _4016_/A VGND VGND VPWR VPWR _3878_/X sky130_fd_sc_hd__mux2_1
X_2829_ _5138_/Q _2824_/X _2826_/X _2828_/X VGND VGND VPWR VPWR _4820_/B sky130_fd_sc_hd__a22o_2
XFILLER_2_128 VGND VGND VPWR VPWR sky130_fd_sc_hd__decap_3
XFILLER_48_35 VGND VGND VPWR VPWR sky130_fd_sc_hd__fill_2
XFILLER_46_305 VGND VGND VPWR VPWR sky130_fd_sc_hd__decap_3
XFILLER_46_349 VGND VGND VPWR VPWR sky130_fd_sc_hd__fill_2
XFILLER_73_113 VGND VGND VPWR VPWR sky130_fd_sc_hd__decap_3
XFILLER_86_496 VGND VGND VPWR VPWR sky130_fd_sc_hd__decap_3
XFILLER_27_552 VGND VGND VPWR VPWR sky130_fd_sc_hd__decap_3
XFILLER_64_45 VGND VGND VPWR VPWR sky130_fd_sc_hd__fill_1
XFILLER_54_371 VGND VGND VPWR VPWR sky130_fd_sc_hd__decap_3
XFILLER_64_78 VGND VGND VPWR VPWR sky130_fd_sc_hd__decap_3
XFILLER_14_246 VGND VGND VPWR VPWR sky130_fd_sc_hd__decap_3
XFILLER_9_18 VGND VGND VPWR VPWR sky130_fd_sc_hd__decap_3
Xclkbuf_2_3__f_CLK clkbuf_0_CLK/X VGND VGND VPWR VPWR clkload2/A sky130_fd_sc_hd__clkbuf_16
XFILLER_80_55 VGND VGND VPWR VPWR sky130_fd_sc_hd__decap_3
XFILLER_10_441 VGND VGND VPWR VPWR sky130_fd_sc_hd__decap_3
XFILLER_13_60 VGND VGND VPWR VPWR sky130_fd_sc_hd__decap_3
XFILLER_80_88 VGND VGND VPWR VPWR sky130_fd_sc_hd__decap_3
XFILLER_6_445 VGND VGND VPWR VPWR sky130_fd_sc_hd__decap_3
XFILLER_6_489 VGND VGND VPWR VPWR sky130_fd_sc_hd__decap_3
XFILLER_69_408 VGND VGND VPWR VPWR sky130_fd_sc_hd__decap_3
XTAP_TAPCELL_ROW_9_283 VGND VPWR sky130_fd_sc_hd__tapvpwrvgnd_1
XFILLER_1_172 VGND VGND VPWR VPWR sky130_fd_sc_hd__fill_1
XFILLER_49_110 VGND VGND VPWR VPWR sky130_fd_sc_hd__fill_2
XFILLER_49_154 VGND VGND VPWR VPWR sky130_fd_sc_hd__decap_3
XFILLER_77_452 VGND VGND VPWR VPWR sky130_fd_sc_hd__fill_2
XFILLER_18_552 VGND VGND VPWR VPWR sky130_fd_sc_hd__decap_3
XTAP_TAPCELL_ROW_63_804 VGND VPWR sky130_fd_sc_hd__tapvpwrvgnd_1
XFILLER_92_455 VGND VGND VPWR VPWR sky130_fd_sc_hd__decap_3
XFILLER_33_500 VGND VGND VPWR VPWR sky130_fd_sc_hd__decap_3
XFILLER_33_511 VGND VGND VPWR VPWR sky130_fd_sc_hd__decap_3
XFILLER_45_360 VGND VGND VPWR VPWR sky130_fd_sc_hd__decap_3
XFILLER_92_488 VGND VGND VPWR VPWR sky130_fd_sc_hd__decap_3
XFILLER_45_393 VGND VGND VPWR VPWR sky130_fd_sc_hd__decap_3
X_4850_ _5276_/Q _4847_/B _4849_/X _3366_/A VGND VGND VPWR VPWR _5276_/D sky130_fd_sc_hd__o211a_2
XFILLER_60_352 VGND VGND VPWR VPWR sky130_fd_sc_hd__decap_3
XFILLER_60_374 VGND VGND VPWR VPWR sky130_fd_sc_hd__decap_3
X_3801_ _3616_/A _3741_/Y _3800_/Y _3793_/Y VGND VGND VPWR VPWR _4023_/S sky130_fd_sc_hd__a31o_2
X_4781_ _5265_/Q _4847_/B VGND VGND VPWR VPWR _4781_/X sky130_fd_sc_hd__or2_2
XFILLER_20_249 VGND VGND VPWR VPWR sky130_fd_sc_hd__decap_3
X_3732_ _5116_/Q _5004_/Q _4988_/Q _4972_/Q _3732_/S0 _3732_/S1 VGND VGND VPWR VPWR
+ _3732_/X sky130_fd_sc_hd__mux4_2
Xclkload20 _5103_/CLK VGND VGND VPWR VPWR clkload20/Y sky130_fd_sc_hd__bufinv_16
X_3663_ _4365_/A _3808_/B VGND VGND VPWR VPWR _4669_/S sky130_fd_sc_hd__nor2_2
Xclkload31 _5233_/CLK VGND VGND VPWR VPWR clkload31/X sky130_fd_sc_hd__clkbuf_4
X_2614_ _2862_/A _2862_/B _2599_/Y VGND VGND VPWR VPWR _2864_/B sky130_fd_sc_hd__o21ai_2
X_3594_ _3733_/S _3593_/X _5134_/Q VGND VGND VPWR VPWR _3594_/X sky130_fd_sc_hd__o21a_2
X_2545_ _4892_/Q _4876_/Q _5100_/Q _5084_/Q _2676_/S0 _2676_/S1 VGND VGND VPWR VPWR
+ _2546_/B sky130_fd_sc_hd__mux4_2
X_5264_ _5286_/CLK _5264_/D VGND VGND VPWR VPWR _5264_/Q sky130_fd_sc_hd__dfxtp_2
X_2476_ _4966_/Q _4950_/Q _4934_/Q _4918_/Q _2676_/S0 _2676_/S1 VGND VGND VPWR VPWR
+ _2477_/B sky130_fd_sc_hd__mux4_2
XFILLER_87_216 VGND VGND VPWR VPWR sky130_fd_sc_hd__decap_3
XFILLER_68_430 VGND VGND VPWR VPWR sky130_fd_sc_hd__decap_3
X_4215_ _3842_/A _3842_/B _3841_/X _4174_/C VGND VGND VPWR VPWR _4215_/X sky130_fd_sc_hd__o31a_2
X_5195_ _5216_/CLK _5195_/D VGND VGND VPWR VPWR _5195_/Q sky130_fd_sc_hd__dfxtp_2
XFILLER_68_452 VGND VGND VPWR VPWR sky130_fd_sc_hd__decap_3
X_4146_ _4145_/A _4145_/B _4145_/Y _4686_/B1 VGND VGND VPWR VPWR _4146_/X sky130_fd_sc_hd__a211o_2
XFILLER_28_327 VGND VGND VPWR VPWR sky130_fd_sc_hd__decap_3
XFILLER_55_113 VGND VGND VPWR VPWR sky130_fd_sc_hd__decap_3
XTAP_TAPCELL_ROW_87_1025 VGND VPWR sky130_fd_sc_hd__tapvpwrvgnd_1
XFILLER_55_146 VGND VGND VPWR VPWR sky130_fd_sc_hd__decap_3
X_4077_ _4078_/B _3965_/X _4076_/Y _4225_/A VGND VGND VPWR VPWR _4077_/X sky130_fd_sc_hd__a211o_2
XFILLER_70_116 VGND VGND VPWR VPWR sky130_fd_sc_hd__decap_3
X_3028_ _3210_/A _3028_/B VGND VGND VPWR VPWR _3028_/Y sky130_fd_sc_hd__nor2_4
XFILLER_83_477 VGND VGND VPWR VPWR sky130_fd_sc_hd__decap_3
XFILLER_24_533 VGND VGND VPWR VPWR sky130_fd_sc_hd__fill_1
XFILLER_36_382 VGND VGND VPWR VPWR sky130_fd_sc_hd__decap_3
XFILLER_51_352 VGND VGND VPWR VPWR sky130_fd_sc_hd__decap_3
XFILLER_11_216 VGND VGND VPWR VPWR sky130_fd_sc_hd__decap_3
XFILLER_51_385 VGND VGND VPWR VPWR sky130_fd_sc_hd__decap_3
X_4979_ clkload6/A _4979_/D VGND VGND VPWR VPWR _4979_/Q sky130_fd_sc_hd__dfxtp_2
Xclkload3 clkload3/A VGND VGND VPWR VPWR clkload3/Y sky130_fd_sc_hd__clkinv_2
XFILLER_50_25 VGND VGND VPWR VPWR sky130_fd_sc_hd__decap_3
XFILLER_50_47 VGND VGND VPWR VPWR sky130_fd_sc_hd__decap_3
XFILLER_78_216 VGND VGND VPWR VPWR sky130_fd_sc_hd__decap_3
XFILLER_78_249 VGND VGND VPWR VPWR sky130_fd_sc_hd__decap_3
XFILLER_19_305 VGND VGND VPWR VPWR sky130_fd_sc_hd__decap_3
XFILLER_59_452 VGND VGND VPWR VPWR sky130_fd_sc_hd__decap_3
XFILLER_59_474 VGND VGND VPWR VPWR sky130_fd_sc_hd__decap_3
XTAP_TAPCELL_ROW_77_929 VGND VPWR sky130_fd_sc_hd__tapvpwrvgnd_1
XFILLER_74_433 VGND VGND VPWR VPWR sky130_fd_sc_hd__fill_1
XFILLER_75_44 VGND VGND VPWR VPWR sky130_fd_sc_hd__decap_3
XFILLER_86_293 VGND VGND VPWR VPWR sky130_fd_sc_hd__fill_2
XFILLER_75_55 VGND VGND VPWR VPWR sky130_fd_sc_hd__fill_1
XFILLER_15_511 VGND VGND VPWR VPWR sky130_fd_sc_hd__decap_3
XFILLER_61_116 VGND VGND VPWR VPWR sky130_fd_sc_hd__decap_3
XFILLER_74_477 VGND VGND VPWR VPWR sky130_fd_sc_hd__decap_3
XFILLER_27_393 VGND VGND VPWR VPWR sky130_fd_sc_hd__decap_3
XTAP_TAPCELL_ROW_32_509 VGND VPWR sky130_fd_sc_hd__tapvpwrvgnd_1
XFILLER_30_514 VGND VGND VPWR VPWR sky130_fd_sc_hd__decap_3
XFILLER_30_547 VGND VGND VPWR VPWR sky130_fd_sc_hd__decap_3
XFILLER_42_374 VGND VGND VPWR VPWR sky130_fd_sc_hd__decap_3
XFILLER_42_396 VGND VGND VPWR VPWR sky130_fd_sc_hd__decap_3
XFILLER_24_70 VGND VGND VPWR VPWR sky130_fd_sc_hd__fill_1
XTAP_TAPCELL_ROW_40_586 VGND VPWR sky130_fd_sc_hd__tapvpwrvgnd_1
XFILLER_6_253 VGND VGND VPWR VPWR sky130_fd_sc_hd__fill_2
XFILLER_41_6 VGND VGND VPWR VPWR sky130_fd_sc_hd__decap_3
X_4000_ _2565_/Y _3764_/X _4278_/B _3986_/A _4503_/A VGND VGND VPWR VPWR _4000_/X
+ sky130_fd_sc_hd__a221o_2
XFILLER_84_219 VGND VGND VPWR VPWR sky130_fd_sc_hd__fill_2
XFILLER_1_30 VGND VGND VPWR VPWR sky130_fd_sc_hd__decap_3
XFILLER_37_113 VGND VGND VPWR VPWR sky130_fd_sc_hd__decap_3
XFILLER_65_411 VGND VGND VPWR VPWR sky130_fd_sc_hd__decap_3
XFILLER_37_146 VGND VGND VPWR VPWR sky130_fd_sc_hd__decap_3
XTAP_TAPCELL_ROW_48_653 VGND VPWR sky130_fd_sc_hd__tapvpwrvgnd_1
XFILLER_1_96 VGND VGND VPWR VPWR sky130_fd_sc_hd__decap_3
XFILLER_25_308 VGND VGND VPWR VPWR sky130_fd_sc_hd__fill_1
X_4902_ _5110_/CLK _4902_/D VGND VGND VPWR VPWR _4902_/Q sky130_fd_sc_hd__dfxtp_2
XFILLER_80_469 VGND VGND VPWR VPWR sky130_fd_sc_hd__fill_2
XFILLER_33_374 VGND VGND VPWR VPWR sky130_fd_sc_hd__decap_3
XFILLER_60_160 VGND VGND VPWR VPWR sky130_fd_sc_hd__fill_2
XFILLER_60_182 VGND VGND VPWR VPWR sky130_fd_sc_hd__decap_3
X_4833_ _5170_/Q _4834_/B VGND VGND VPWR VPWR _4835_/A sky130_fd_sc_hd__nand2_2
X_4764_ _4764_/A _4772_/A VGND VGND VPWR VPWR _4764_/Y sky130_fd_sc_hd__nand2_2
X_3715_ _3715_/A _4199_/C _4199_/D VGND VGND VPWR VPWR _3715_/Y sky130_fd_sc_hd__nor3_2
X_4695_ _5242_/Q _4725_/B VGND VGND VPWR VPWR _4695_/X sky130_fd_sc_hd__or2_2
X_3646_ _5078_/Q _5062_/Q _5046_/Q _5030_/Q _3706_/S0 _3706_/S1 VGND VGND VPWR VPWR
+ _3646_/X sky130_fd_sc_hd__mux4_2
X_3577_ _4365_/A _4362_/A _3874_/S VGND VGND VPWR VPWR _3577_/X sky130_fd_sc_hd__mux2_1
X_2528_ _2526_/X _2527_/X _5129_/Q VGND VGND VPWR VPWR _2528_/X sky130_fd_sc_hd__mux2_1
XTAP_TAPCELL_ROW_93_1084 VGND VPWR sky130_fd_sc_hd__tapvpwrvgnd_1
XFILLER_88_503 VGND VGND VPWR VPWR sky130_fd_sc_hd__decap_3
XFILLER_29_26 VGND VGND VPWR VPWR sky130_fd_sc_hd__fill_1
X_5247_ _5283_/CLK _5247_/D VGND VGND VPWR VPWR _5247_/Q sky130_fd_sc_hd__dfxtp_2
XTAP_TAPCELL_ROW_93_1095 VGND VPWR sky130_fd_sc_hd__tapvpwrvgnd_1
XFILLER_88_547 VGND VGND VPWR VPWR sky130_fd_sc_hd__decap_3
X_2459_ _3363_/A _4847_/A _2458_/X VGND VGND VPWR VPWR _2459_/Y sky130_fd_sc_hd__o21ai_2
XFILLER_68_271 VGND VGND VPWR VPWR sky130_fd_sc_hd__decap_3
X_5178_ _5260_/CLK _5178_/D VGND VGND VPWR VPWR _5178_/Q sky130_fd_sc_hd__dfxtp_2
XTAP_TAPCELL_ROW_3_234 VGND VPWR sky130_fd_sc_hd__tapvpwrvgnd_1
XFILLER_28_124 VGND VGND VPWR VPWR sky130_fd_sc_hd__decap_3
XFILLER_56_455 VGND VGND VPWR VPWR sky130_fd_sc_hd__fill_1
X_4129_ _4129_/A VGND VGND VPWR VPWR _4129_/Y sky130_fd_sc_hd__inv_2
XFILLER_43_116 VGND VGND VPWR VPWR sky130_fd_sc_hd__decap_3
XFILLER_71_414 VGND VGND VPWR VPWR sky130_fd_sc_hd__fill_2
XFILLER_83_252 VGND VGND VPWR VPWR sky130_fd_sc_hd__decap_3
XFILLER_71_436 VGND VGND VPWR VPWR sky130_fd_sc_hd__decap_3
XFILLER_71_458 VGND VGND VPWR VPWR sky130_fd_sc_hd__decap_3
XFILLER_83_296 VGND VGND VPWR VPWR sky130_fd_sc_hd__decap_3
XTAP_TAPCELL_ROW_82_976 VGND VPWR sky130_fd_sc_hd__tapvpwrvgnd_1
XFILLER_24_374 VGND VGND VPWR VPWR sky130_fd_sc_hd__fill_1
XFILLER_51_193 VGND VGND VPWR VPWR sky130_fd_sc_hd__decap_3
XFILLER_3_212 VGND VGND VPWR VPWR sky130_fd_sc_hd__decap_3
XFILLER_10_61 VGND VGND VPWR VPWR sky130_fd_sc_hd__decap_3
XFILLER_79_514 VGND VGND VPWR VPWR sky130_fd_sc_hd__decap_3
XFILLER_66_208 VGND VGND VPWR VPWR sky130_fd_sc_hd__decap_3
XFILLER_19_113 VGND VGND VPWR VPWR sky130_fd_sc_hd__fill_2
XFILLER_47_400 VGND VGND VPWR VPWR sky130_fd_sc_hd__fill_2
XFILLER_47_422 VGND VGND VPWR VPWR sky130_fd_sc_hd__decap_3
XFILLER_47_455 VGND VGND VPWR VPWR sky130_fd_sc_hd__decap_3
XFILLER_47_488 VGND VGND VPWR VPWR sky130_fd_sc_hd__decap_3
XFILLER_62_414 VGND VGND VPWR VPWR sky130_fd_sc_hd__fill_1
XFILLER_74_296 VGND VGND VPWR VPWR sky130_fd_sc_hd__decap_3
X_3500_ _3733_/S _3499_/X _5134_/Q VGND VGND VPWR VPWR _3500_/X sky130_fd_sc_hd__o21a_2
X_4480_ _3567_/S _2589_/B _4379_/X _4477_/Y _4479_/Y VGND VGND VPWR VPWR _4481_/C
+ sky130_fd_sc_hd__o221a_2
X_3431_ _3432_/A _3432_/B _3432_/C VGND VGND VPWR VPWR _3431_/X sky130_fd_sc_hd__a21o_2
X_3362_ _5184_/Q _3357_/B _2463_/B VGND VGND VPWR VPWR _3364_/B sky130_fd_sc_hd__a21o_2
X_5101_ _5101_/CLK _5101_/D VGND VGND VPWR VPWR _5101_/Q sky130_fd_sc_hd__dfxtp_2
X_3293_ _3297_/B _3307_/D VGND VGND VPWR VPWR _3293_/Y sky130_fd_sc_hd__nand2_2
X_5032_ _5069_/CLK _5032_/D VGND VGND VPWR VPWR _5032_/Q sky130_fd_sc_hd__dfxtp_2
XFILLER_38_433 VGND VGND VPWR VPWR sky130_fd_sc_hd__decap_3
XFILLER_65_241 VGND VGND VPWR VPWR sky130_fd_sc_hd__decap_3
XFILLER_38_477 VGND VGND VPWR VPWR sky130_fd_sc_hd__fill_1
XTAP_TAPCELL_ROW_0_204 VGND VPWR sky130_fd_sc_hd__tapvpwrvgnd_1
XPHY_EDGE_ROW_69_Left_163 VGND VGND VPWR VPWR sky130_fd_sc_hd__decap_3
XFILLER_25_116 VGND VGND VPWR VPWR sky130_fd_sc_hd__decap_3
XFILLER_53_447 VGND VGND VPWR VPWR sky130_fd_sc_hd__fill_1
XFILLER_53_469 VGND VGND VPWR VPWR sky130_fd_sc_hd__decap_3
XFILLER_80_288 VGND VGND VPWR VPWR sky130_fd_sc_hd__decap_3
XFILLER_21_355 VGND VGND VPWR VPWR sky130_fd_sc_hd__decap_3
XFILLER_61_491 VGND VGND VPWR VPWR sky130_fd_sc_hd__fill_1
X_4816_ _4785_/A _4793_/A _4793_/B VGND VGND VPWR VPWR _4816_/Y sky130_fd_sc_hd__a21boi_2
XFILLER_21_399 VGND VGND VPWR VPWR sky130_fd_sc_hd__decap_3
XFILLER_31_49 VGND VGND VPWR VPWR sky130_fd_sc_hd__decap_3
X_4747_ _4747_/A _4747_/B VGND VGND VPWR VPWR _4750_/A sky130_fd_sc_hd__and2_2
XPHY_EDGE_ROW_78_Left_172 VGND VGND VPWR VPWR sky130_fd_sc_hd__decap_3
X_4678_ _5240_/Q _4854_/B VGND VGND VPWR VPWR _4678_/Y sky130_fd_sc_hd__nand2_2
X_3629_ _4376_/A _3630_/B VGND VGND VPWR VPWR _3631_/A sky130_fd_sc_hd__nor2_2
XFILLER_0_237 VGND VGND VPWR VPWR sky130_fd_sc_hd__decap_3
XFILLER_0_259 VGND VGND VPWR VPWR sky130_fd_sc_hd__decap_3
XFILLER_88_344 VGND VGND VPWR VPWR sky130_fd_sc_hd__decap_3
XFILLER_88_399 VGND VGND VPWR VPWR sky130_fd_sc_hd__decap_3
XFILLER_29_444 VGND VGND VPWR VPWR sky130_fd_sc_hd__decap_3
XFILLER_29_455 VGND VGND VPWR VPWR sky130_fd_sc_hd__decap_3
XFILLER_56_46 VGND VGND VPWR VPWR sky130_fd_sc_hd__decap_3
XTAP_TAPCELL_ROW_59_759 VGND VPWR sky130_fd_sc_hd__tapvpwrvgnd_1
XPHY_EDGE_ROW_87_Left_181 VGND VGND VPWR VPWR sky130_fd_sc_hd__decap_3
XFILLER_56_241 VGND VGND VPWR VPWR sky130_fd_sc_hd__decap_3
XFILLER_56_79 VGND VGND VPWR VPWR sky130_fd_sc_hd__decap_3
XFILLER_71_200 VGND VGND VPWR VPWR sky130_fd_sc_hd__decap_3
XFILLER_16_116 VGND VGND VPWR VPWR sky130_fd_sc_hd__decap_3
XFILLER_71_244 VGND VGND VPWR VPWR sky130_fd_sc_hd__decap_3
XTAP_TAPCELL_ROW_42_604 VGND VPWR sky130_fd_sc_hd__tapvpwrvgnd_1
XFILLER_12_300 VGND VGND VPWR VPWR sky130_fd_sc_hd__decap_3
XFILLER_31_119 VGND VGND VPWR VPWR sky130_fd_sc_hd__fill_1
XFILLER_52_480 VGND VGND VPWR VPWR sky130_fd_sc_hd__decap_3
XFILLER_52_491 VGND VGND VPWR VPWR sky130_fd_sc_hd__decap_3
XTAP_TAPCELL_ROW_14_339 VGND VPWR sky130_fd_sc_hd__tapvpwrvgnd_1
XTAP_TAPCELL_ROW_50_681 VGND VPWR sky130_fd_sc_hd__tapvpwrvgnd_1
XFILLER_4_521 VGND VGND VPWR VPWR sky130_fd_sc_hd__decap_3
XFILLER_4_554 VGND VGND VPWR VPWR sky130_fd_sc_hd__decap_3
Xclkbuf_leaf_40_CLK clkbuf_leaf_5_CLK/A VGND VGND VPWR VPWR _5118_/CLK sky130_fd_sc_hd__clkbuf_8
XFILLER_79_355 VGND VGND VPWR VPWR sky130_fd_sc_hd__decap_3
XFILLER_39_208 VGND VGND VPWR VPWR sky130_fd_sc_hd__decap_3
XFILLER_67_517 VGND VGND VPWR VPWR sky130_fd_sc_hd__fill_2
XFILLER_67_539 VGND VGND VPWR VPWR sky130_fd_sc_hd__decap_3
XFILLER_35_447 VGND VGND VPWR VPWR sky130_fd_sc_hd__fill_1
XFILLER_62_233 VGND VGND VPWR VPWR sky130_fd_sc_hd__decap_3
XFILLER_90_520 VGND VGND VPWR VPWR sky130_fd_sc_hd__decap_3
XFILLER_62_266 VGND VGND VPWR VPWR sky130_fd_sc_hd__decap_3
X_3980_ _3958_/A _4278_/B _3979_/X VGND VGND VPWR VPWR _3981_/D sky130_fd_sc_hd__a21oi_2
X_2931_ _2931_/A _2931_/B VGND VGND VPWR VPWR _2931_/X sky130_fd_sc_hd__or2_2
XFILLER_43_491 VGND VGND VPWR VPWR sky130_fd_sc_hd__decap_3
XFILLER_30_141 VGND VGND VPWR VPWR sky130_fd_sc_hd__decap_3
X_4601_ _4684_/B1 _4155_/A _4200_/C _3363_/A VGND VGND VPWR VPWR _4604_/B sky130_fd_sc_hd__o2bb2a_2
X_2862_ _2862_/A _2862_/B VGND VGND VPWR VPWR _2863_/B sky130_fd_sc_hd__xnor2_2
XFILLER_87_3 VGND VGND VPWR VPWR sky130_fd_sc_hd__decap_3
X_2793_ _5138_/Q _2788_/X _2790_/X _2792_/X VGND VGND VPWR VPWR _4784_/B sky130_fd_sc_hd__a22o_2
X_4532_ _3886_/B _4502_/A _4502_/B _4531_/X VGND VGND VPWR VPWR _4532_/X sky130_fd_sc_hd__o31a_2
X_4463_ _4463_/A _4463_/B VGND VGND VPWR VPWR _4464_/B sky130_fd_sc_hd__nor2_2
XFILLER_7_370 VGND VGND VPWR VPWR sky130_fd_sc_hd__decap_3
X_3414_ _5161_/Q _5142_/Q VGND VGND VPWR VPWR _3415_/B sky130_fd_sc_hd__and2_2
XFILLER_89_119 VGND VGND VPWR VPWR sky130_fd_sc_hd__decap_3
X_4394_ _4393_/B _4393_/C _4393_/D _4393_/A VGND VGND VPWR VPWR _4394_/X sky130_fd_sc_hd__o22a_2
Xclkbuf_leaf_31_CLK clkload0/A VGND VGND VPWR VPWR _5110_/CLK sky130_fd_sc_hd__clkbuf_8
XPHY_EDGE_ROW_15_Right_15 VGND VGND VPWR VPWR sky130_fd_sc_hd__decap_3
X_3345_ _5182_/Q _3230_/B _3230_/Y _3344_/X VGND VGND VPWR VPWR _5182_/D sky130_fd_sc_hd__o22a_2
XTAP_TAPCELL_ROW_90_1054 VGND VPWR sky130_fd_sc_hd__tapvpwrvgnd_1
XFILLER_58_539 VGND VGND VPWR VPWR sky130_fd_sc_hd__fill_2
X_3276_ _3494_/A _3276_/B VGND VGND VPWR VPWR _5143_/D sky130_fd_sc_hd__nor2_2
X_5015_ _5069_/CLK _5015_/D VGND VGND VPWR VPWR _5015_/Q sky130_fd_sc_hd__dfxtp_2
XFILLER_85_347 VGND VGND VPWR VPWR sky130_fd_sc_hd__decap_3
XTAP_TAPCELL_ROW_56_729 VGND VPWR sky130_fd_sc_hd__tapvpwrvgnd_1
XFILLER_85_369 VGND VGND VPWR VPWR sky130_fd_sc_hd__decap_3
XFILLER_26_27 VGND VGND VPWR VPWR sky130_fd_sc_hd__fill_1
XFILLER_26_414 VGND VGND VPWR VPWR sky130_fd_sc_hd__fill_1
XFILLER_81_520 VGND VGND VPWR VPWR sky130_fd_sc_hd__decap_3
XFILLER_26_469 VGND VGND VPWR VPWR sky130_fd_sc_hd__decap_3
XFILLER_53_233 VGND VGND VPWR VPWR sky130_fd_sc_hd__decap_3
XPHY_EDGE_ROW_24_Right_24 VGND VGND VPWR VPWR sky130_fd_sc_hd__decap_3
XFILLER_81_553 VGND VGND VPWR VPWR sky130_fd_sc_hd__decap_3
XFILLER_53_299 VGND VGND VPWR VPWR sky130_fd_sc_hd__decap_3
XFILLER_21_130 VGND VGND VPWR VPWR sky130_fd_sc_hd__decap_3
XFILLER_21_152 VGND VGND VPWR VPWR sky130_fd_sc_hd__decap_3
XTAP_TAPCELL_ROW_11_309 VGND VPWR sky130_fd_sc_hd__tapvpwrvgnd_1
XPHY_EDGE_ROW_33_Right_33 VGND VGND VPWR VPWR sky130_fd_sc_hd__decap_3
XFILLER_1_535 VGND VGND VPWR VPWR sky130_fd_sc_hd__decap_3
Xclkbuf_leaf_22_CLK clkload2/A VGND VGND VPWR VPWR _5254_/CLK sky130_fd_sc_hd__clkbuf_8
XFILLER_88_141 VGND VGND VPWR VPWR sky130_fd_sc_hd__decap_3
XFILLER_49_517 VGND VGND VPWR VPWR sky130_fd_sc_hd__decap_3
XFILLER_88_185 VGND VGND VPWR VPWR sky130_fd_sc_hd__decap_3
XFILLER_76_347 VGND VGND VPWR VPWR sky130_fd_sc_hd__decap_3
XFILLER_91_306 VGND VGND VPWR VPWR sky130_fd_sc_hd__fill_2
XFILLER_17_436 VGND VGND VPWR VPWR sky130_fd_sc_hd__decap_3
XFILLER_44_200 VGND VGND VPWR VPWR sky130_fd_sc_hd__fill_2
XFILLER_44_222 VGND VGND VPWR VPWR sky130_fd_sc_hd__decap_3
XPHY_EDGE_ROW_42_Right_42 VGND VGND VPWR VPWR sky130_fd_sc_hd__decap_3
XFILLER_84_391 VGND VGND VPWR VPWR sky130_fd_sc_hd__fill_2
XFILLER_72_542 VGND VGND VPWR VPWR sky130_fd_sc_hd__decap_3
XFILLER_83_55 VGND VGND VPWR VPWR sky130_fd_sc_hd__fill_1
XFILLER_12_141 VGND VGND VPWR VPWR sky130_fd_sc_hd__decap_3
XFILLER_40_450 VGND VGND VPWR VPWR sky130_fd_sc_hd__decap_3
XFILLER_8_112 VGND VGND VPWR VPWR sky130_fd_sc_hd__decap_3
XFILLER_40_483 VGND VGND VPWR VPWR sky130_fd_sc_hd__decap_3
XPHY_EDGE_ROW_51_Right_51 VGND VGND VPWR VPWR sky130_fd_sc_hd__decap_3
Xclkbuf_leaf_13_CLK clkload1/A VGND VGND VPWR VPWR _5270_/CLK sky130_fd_sc_hd__clkbuf_8
X_3130_ _2927_/X _3121_/B _3121_/Y _5039_/Q VGND VGND VPWR VPWR _5039_/D sky130_fd_sc_hd__a22o_2
XFILLER_79_174 VGND VGND VPWR VPWR sky130_fd_sc_hd__decap_3
X_3061_ _2941_/X _3048_/B _3048_/Y _4979_/Q VGND VGND VPWR VPWR _4979_/D sky130_fd_sc_hd__a22o_2
XPHY_EDGE_ROW_60_Right_60 VGND VGND VPWR VPWR sky130_fd_sc_hd__decap_3
XFILLER_82_306 VGND VGND VPWR VPWR sky130_fd_sc_hd__fill_2
XFILLER_63_531 VGND VGND VPWR VPWR sky130_fd_sc_hd__decap_3
XFILLER_75_391 VGND VGND VPWR VPWR sky130_fd_sc_hd__fill_1
XFILLER_63_553 VGND VGND VPWR VPWR sky130_fd_sc_hd__decap_3
XFILLER_90_350 VGND VGND VPWR VPWR sky130_fd_sc_hd__decap_3
XFILLER_23_439 VGND VGND VPWR VPWR sky130_fd_sc_hd__decap_3
XFILLER_35_277 VGND VGND VPWR VPWR sky130_fd_sc_hd__decap_3
XFILLER_50_203 VGND VGND VPWR VPWR sky130_fd_sc_hd__decap_3
XFILLER_16_480 VGND VGND VPWR VPWR sky130_fd_sc_hd__decap_3
XFILLER_50_247 VGND VGND VPWR VPWR sky130_fd_sc_hd__decap_3
X_3963_ _3963_/A _4175_/B VGND VGND VPWR VPWR _3963_/Y sky130_fd_sc_hd__nand2_2
XFILLER_90_394 VGND VGND VPWR VPWR sky130_fd_sc_hd__fill_1
XFILLER_50_269 VGND VGND VPWR VPWR sky130_fd_sc_hd__decap_3
X_3894_ _5182_/Q _3894_/B VGND VGND VPWR VPWR _3894_/X sky130_fd_sc_hd__or2_2
X_2914_ _5276_/Q _5214_/Q _4854_/A _5230_/Q _2913_/X VGND VGND VPWR VPWR _2914_/X
+ sky130_fd_sc_hd__a221o_2
X_2845_ _4965_/Q _4949_/Q _4933_/Q _4917_/Q _2854_/S0 _2854_/S1 VGND VGND VPWR VPWR
+ _2845_/X sky130_fd_sc_hd__mux4_2
X_4515_ _4515_/A _4515_/B VGND VGND VPWR VPWR _4571_/A sky130_fd_sc_hd__or2_2
X_2776_ _2857_/A _4769_/B VGND VGND VPWR VPWR _2776_/X sky130_fd_sc_hd__and2_2
X_4446_ _4444_/Y _4445_/X _4487_/A VGND VGND VPWR VPWR _4446_/Y sky130_fd_sc_hd__a21oi_2
X_4377_ _4382_/A VGND VGND VPWR VPWR _4377_/Y sky130_fd_sc_hd__inv_2
XFILLER_58_314 VGND VGND VPWR VPWR sky130_fd_sc_hd__decap_3
X_3328_ _5283_/Q _3338_/B _3328_/C VGND VGND VPWR VPWR _3328_/X sky130_fd_sc_hd__and3_2
XTAP_TAPCELL_ROW_69_854 VGND VPWR sky130_fd_sc_hd__tapvpwrvgnd_1
XFILLER_85_122 VGND VGND VPWR VPWR sky130_fd_sc_hd__fill_2
XFILLER_37_37 VGND VGND VPWR VPWR sky130_fd_sc_hd__fill_1
XFILLER_73_306 VGND VGND VPWR VPWR sky130_fd_sc_hd__decap_3
X_3259_ _5260_/Q _5189_/Q _3305_/B _3258_/Y VGND VGND VPWR VPWR _3259_/X sky130_fd_sc_hd__a22o_2
XFILLER_26_200 VGND VGND VPWR VPWR sky130_fd_sc_hd__decap_3
XFILLER_85_199 VGND VGND VPWR VPWR sky130_fd_sc_hd__fill_2
XFILLER_26_233 VGND VGND VPWR VPWR sky130_fd_sc_hd__fill_2
XFILLER_66_391 VGND VGND VPWR VPWR sky130_fd_sc_hd__decap_3
XFILLER_26_288 VGND VGND VPWR VPWR sky130_fd_sc_hd__decap_3
XFILLER_81_361 VGND VGND VPWR VPWR sky130_fd_sc_hd__decap_3
XFILLER_53_47 VGND VGND VPWR VPWR sky130_fd_sc_hd__decap_3
XTAP_TAPCELL_ROW_24_434 VGND VPWR sky130_fd_sc_hd__tapvpwrvgnd_1
XFILLER_22_472 VGND VGND VPWR VPWR sky130_fd_sc_hd__decap_3
XFILLER_22_483 VGND VGND VPWR VPWR sky130_fd_sc_hd__decap_3
XFILLER_5_137 VGND VGND VPWR VPWR sky130_fd_sc_hd__fill_1
XFILLER_1_365 VGND VGND VPWR VPWR sky130_fd_sc_hd__decap_3
XFILLER_89_483 VGND VGND VPWR VPWR sky130_fd_sc_hd__fill_1
XFILLER_78_88 VGND VGND VPWR VPWR sky130_fd_sc_hd__decap_3
XFILLER_76_100 VGND VGND VPWR VPWR sky130_fd_sc_hd__decap_3
XFILLER_49_358 VGND VGND VPWR VPWR sky130_fd_sc_hd__decap_3
XFILLER_17_277 VGND VGND VPWR VPWR sky130_fd_sc_hd__decap_3
XFILLER_32_203 VGND VGND VPWR VPWR sky130_fd_sc_hd__fill_1
XFILLER_60_523 VGND VGND VPWR VPWR sky130_fd_sc_hd__decap_3
XFILLER_32_236 VGND VGND VPWR VPWR sky130_fd_sc_hd__decap_3
Xclkbuf_leaf_2_CLK clkbuf_leaf_5_CLK/A VGND VGND VPWR VPWR clkload4/A sky130_fd_sc_hd__clkbuf_8
XFILLER_13_461 VGND VGND VPWR VPWR sky130_fd_sc_hd__fill_2
XFILLER_9_410 VGND VGND VPWR VPWR sky130_fd_sc_hd__decap_3
XFILLER_13_483 VGND VGND VPWR VPWR sky130_fd_sc_hd__decap_3
X_2630_ _2630_/A _2630_/B VGND VGND VPWR VPWR _4086_/A sky130_fd_sc_hd__nor2_2
X_2561_ _2559_/X _2560_/X _5129_/Q VGND VGND VPWR VPWR _2561_/X sky130_fd_sc_hd__mux2_1
X_4300_ _5159_/Q _4301_/B VGND VGND VPWR VPWR _4302_/A sky130_fd_sc_hd__nor2_2
X_5280_ _5283_/CLK _5280_/D VGND VGND VPWR VPWR _5280_/Q sky130_fd_sc_hd__dfxtp_2
X_2492_ _5170_/Q _4365_/A VGND VGND VPWR VPWR _2695_/B sky130_fd_sc_hd__nand2_2
X_4231_ _3666_/A _4189_/A _4214_/Y _4230_/X VGND VGND VPWR VPWR _4231_/X sky130_fd_sc_hd__a31o_2
XFILLER_4_85 VGND VGND VPWR VPWR sky130_fd_sc_hd__decap_3
XFILLER_67_111 VGND VGND VPWR VPWR sky130_fd_sc_hd__fill_1
XFILLER_67_122 VGND VGND VPWR VPWR sky130_fd_sc_hd__decap_3
X_4162_ _4191_/A _2884_/B _4146_/X VGND VGND VPWR VPWR _4162_/Y sky130_fd_sc_hd__o21ai_2
X_4093_ _4199_/D _4094_/B VGND VGND VPWR VPWR _4119_/B sky130_fd_sc_hd__and2b_2
X_3113_ _2931_/X _3119_/A2 _3103_/Y _5024_/Q VGND VGND VPWR VPWR _5024_/D sky130_fd_sc_hd__a22o_2
X_3044_ _2947_/X _3029_/B _3029_/Y _4965_/Q VGND VGND VPWR VPWR _4965_/D sky130_fd_sc_hd__a22o_2
XTAP_TAPCELL_ROW_66_824 VGND VPWR sky130_fd_sc_hd__tapvpwrvgnd_1
XFILLER_70_309 VGND VGND VPWR VPWR sky130_fd_sc_hd__decap_3
XTAP_TAPCELL_ROW_38_559 VGND VPWR sky130_fd_sc_hd__tapvpwrvgnd_1
XFILLER_82_147 VGND VGND VPWR VPWR sky130_fd_sc_hd__decap_3
XFILLER_82_136 VGND VGND VPWR VPWR sky130_fd_sc_hd__decap_3
XFILLER_51_501 VGND VGND VPWR VPWR sky130_fd_sc_hd__decap_3
XFILLER_63_350 VGND VGND VPWR VPWR sky130_fd_sc_hd__decap_3
X_4995_ clkload5/A _4995_/D VGND VGND VPWR VPWR _4995_/Q sky130_fd_sc_hd__dfxtp_2
XFILLER_23_269 VGND VGND VPWR VPWR sky130_fd_sc_hd__decap_3
X_3946_ _2589_/A _4522_/A _3945_/X _3747_/A VGND VGND VPWR VPWR _3947_/B sky130_fd_sc_hd__o211a_2
XTAP_TAPCELL_ROW_21_404 VGND VPWR sky130_fd_sc_hd__tapvpwrvgnd_1
X_3877_ _3874_/X _3876_/A _3961_/S VGND VGND VPWR VPWR _3877_/X sky130_fd_sc_hd__mux2_1
X_2828_ _2832_/A _2827_/X _2435_/Y VGND VGND VPWR VPWR _2828_/X sky130_fd_sc_hd__o21a_2
X_2759_ _4892_/Q _4876_/Q _5100_/Q _5084_/Q _2854_/S0 _2854_/S1 VGND VGND VPWR VPWR
+ _2759_/X sky130_fd_sc_hd__mux4_2
X_4429_ _4325_/C _4428_/X _4331_/Y VGND VGND VPWR VPWR _4429_/X sky130_fd_sc_hd__o21a_2
XFILLER_78_409 VGND VGND VPWR VPWR sky130_fd_sc_hd__decap_3
XFILLER_58_100 VGND VGND VPWR VPWR sky130_fd_sc_hd__fill_1
XFILLER_58_122 VGND VGND VPWR VPWR sky130_fd_sc_hd__decap_3
XFILLER_58_144 VGND VGND VPWR VPWR sky130_fd_sc_hd__fill_1
XFILLER_27_520 VGND VGND VPWR VPWR sky130_fd_sc_hd__decap_3
XFILLER_61_309 VGND VGND VPWR VPWR sky130_fd_sc_hd__decap_3
XFILLER_73_147 VGND VGND VPWR VPWR sky130_fd_sc_hd__decap_3
XFILLER_42_512 VGND VGND VPWR VPWR sky130_fd_sc_hd__decap_3
XFILLER_54_361 VGND VGND VPWR VPWR sky130_fd_sc_hd__decap_3
XFILLER_73_169 VGND VGND VPWR VPWR sky130_fd_sc_hd__fill_2
XPHY_EDGE_ROW_14_Left_108 VGND VGND VPWR VPWR sky130_fd_sc_hd__decap_3
XFILLER_14_214 VGND VGND VPWR VPWR sky130_fd_sc_hd__decap_3
XFILLER_54_383 VGND VGND VPWR VPWR sky130_fd_sc_hd__decap_3
XFILLER_10_486 VGND VGND VPWR VPWR sky130_fd_sc_hd__decap_3
XFILLER_6_424 VGND VGND VPWR VPWR sky130_fd_sc_hd__fill_1
XFILLER_6_457 VGND VGND VPWR VPWR sky130_fd_sc_hd__decap_3
XPHY_EDGE_ROW_23_Left_117 VGND VGND VPWR VPWR sky130_fd_sc_hd__decap_3
XFILLER_36_9 VGND VGND VPWR VPWR sky130_fd_sc_hd__fill_2
XTAP_TAPCELL_ROW_9_284 VGND VPWR sky130_fd_sc_hd__tapvpwrvgnd_1
XFILLER_77_431 VGND VGND VPWR VPWR sky130_fd_sc_hd__decap_3
XFILLER_49_133 VGND VGND VPWR VPWR sky130_fd_sc_hd__decap_3
XFILLER_49_166 VGND VGND VPWR VPWR sky130_fd_sc_hd__fill_2
XFILLER_37_317 VGND VGND VPWR VPWR sky130_fd_sc_hd__decap_3
XFILLER_49_188 VGND VGND VPWR VPWR sky130_fd_sc_hd__fill_2
XFILLER_64_103 VGND VGND VPWR VPWR sky130_fd_sc_hd__decap_3
XFILLER_92_401 VGND VGND VPWR VPWR sky130_fd_sc_hd__decap_3
XFILLER_18_531 VGND VGND VPWR VPWR sky130_fd_sc_hd__fill_1
XFILLER_64_147 VGND VGND VPWR VPWR sky130_fd_sc_hd__decap_3
XPHY_EDGE_ROW_32_Left_126 VGND VGND VPWR VPWR sky130_fd_sc_hd__decap_3
XFILLER_52_309 VGND VGND VPWR VPWR sky130_fd_sc_hd__decap_3
X_4780_ _4780_/A _4780_/B VGND VGND VPWR VPWR _4780_/X sky130_fd_sc_hd__xor2_2
X_3800_ _3741_/A _4298_/A _3934_/A _3797_/B _3799_/B VGND VGND VPWR VPWR _3800_/Y
+ sky130_fd_sc_hd__o221ai_2
XFILLER_20_206 VGND VGND VPWR VPWR sky130_fd_sc_hd__decap_3
XFILLER_60_386 VGND VGND VPWR VPWR sky130_fd_sc_hd__fill_1
X_3731_ _4956_/Q _4940_/Q _4924_/Q _4908_/Q _3732_/S0 _3732_/S1 VGND VGND VPWR VPWR
+ _3731_/X sky130_fd_sc_hd__mux4_2
Xclkload10 _5111_/CLK VGND VGND VPWR VPWR clkload10/X sky130_fd_sc_hd__clkbuf_4
X_3662_ _3656_/X _3658_/X _3661_/X _2430_/Y VGND VGND VPWR VPWR _3808_/B sky130_fd_sc_hd__a22o_2
XPHY_EDGE_ROW_41_Left_135 VGND VGND VPWR VPWR sky130_fd_sc_hd__decap_3
XFILLER_9_295 VGND VGND VPWR VPWR sky130_fd_sc_hd__decap_3
Xclkload32 _5257_/CLK VGND VGND VPWR VPWR clkload32/X sky130_fd_sc_hd__clkbuf_8
Xclkload21 _5109_/CLK VGND VGND VPWR VPWR clkload21/Y sky130_fd_sc_hd__bufinv_16
X_3593_ _5069_/Q _5053_/Q _5037_/Q _5021_/Q _3706_/S0 _3706_/S1 VGND VGND VPWR VPWR
+ _3593_/X sky130_fd_sc_hd__mux4_2
X_2613_ _2862_/B VGND VGND VPWR VPWR _2860_/A sky130_fd_sc_hd__inv_2
X_2544_ _5068_/Q _5052_/Q _5036_/Q _5020_/Q _2676_/S0 _2676_/S1 VGND VGND VPWR VPWR
+ _2544_/X sky130_fd_sc_hd__mux4_2
X_5263_ _5263_/CLK _5263_/D VGND VGND VPWR VPWR _5263_/Q sky130_fd_sc_hd__dfxtp_2
X_2475_ _2660_/A _2475_/B VGND VGND VPWR VPWR _2475_/Y sky130_fd_sc_hd__nor2_2
X_4214_ _3810_/B _4214_/B VGND VGND VPWR VPWR _4214_/Y sky130_fd_sc_hd__nand2b_2
X_5194_ _5216_/CLK _5194_/D VGND VGND VPWR VPWR _5194_/Q sky130_fd_sc_hd__dfxtp_2
XFILLER_28_306 VGND VGND VPWR VPWR sky130_fd_sc_hd__fill_2
XFILLER_68_464 VGND VGND VPWR VPWR sky130_fd_sc_hd__decap_3
X_4145_ _4145_/A _4145_/B VGND VGND VPWR VPWR _4145_/Y sky130_fd_sc_hd__nor2_2
XFILLER_55_125 VGND VGND VPWR VPWR sky130_fd_sc_hd__decap_3
XFILLER_68_486 VGND VGND VPWR VPWR sky130_fd_sc_hd__decap_3
XPHY_EDGE_ROW_50_Left_144 VGND VGND VPWR VPWR sky130_fd_sc_hd__decap_3
XFILLER_83_434 VGND VGND VPWR VPWR sky130_fd_sc_hd__decap_3
XFILLER_55_158 VGND VGND VPWR VPWR sky130_fd_sc_hd__decap_3
X_4076_ _4078_/B _4076_/B VGND VGND VPWR VPWR _4076_/Y sky130_fd_sc_hd__nor2_2
XTAP_TAPCELL_ROW_87_1026 VGND VPWR sky130_fd_sc_hd__tapvpwrvgnd_1
XFILLER_83_456 VGND VGND VPWR VPWR sky130_fd_sc_hd__decap_3
X_3027_ _2950_/X _3011_/B _3011_/Y _4950_/Q VGND VGND VPWR VPWR _4950_/D sky130_fd_sc_hd__a22o_2
XFILLER_36_394 VGND VGND VPWR VPWR sky130_fd_sc_hd__decap_3
XFILLER_70_128 VGND VGND VPWR VPWR sky130_fd_sc_hd__decap_3
XFILLER_51_364 VGND VGND VPWR VPWR sky130_fd_sc_hd__decap_3
X_4978_ _5010_/CLK _4978_/D VGND VGND VPWR VPWR _4978_/Q sky130_fd_sc_hd__dfxtp_2
Xclkload4 clkload4/A VGND VGND VPWR VPWR clkload4/X sky130_fd_sc_hd__clkbuf_4
X_3929_ _4016_/A _3929_/B VGND VGND VPWR VPWR _3929_/X sky130_fd_sc_hd__or2_2
XFILLER_1_6 VGND VGND VPWR VPWR sky130_fd_sc_hd__decap_3
XFILLER_3_449 VGND VGND VPWR VPWR sky130_fd_sc_hd__decap_3
XFILLER_59_46 VGND VGND VPWR VPWR sky130_fd_sc_hd__decap_3
XFILLER_78_228 VGND VGND VPWR VPWR sky130_fd_sc_hd__decap_3
XTAP_TAPCELL_ROW_6_254 VGND VPWR sky130_fd_sc_hd__tapvpwrvgnd_1
XFILLER_19_328 VGND VGND VPWR VPWR sky130_fd_sc_hd__decap_3
XFILLER_59_486 VGND VGND VPWR VPWR sky130_fd_sc_hd__decap_3
XFILLER_74_401 VGND VGND VPWR VPWR sky130_fd_sc_hd__decap_3
XFILLER_86_272 VGND VGND VPWR VPWR sky130_fd_sc_hd__decap_3
XFILLER_74_445 VGND VGND VPWR VPWR sky130_fd_sc_hd__decap_3
XFILLER_34_309 VGND VGND VPWR VPWR sky130_fd_sc_hd__decap_3
XFILLER_74_489 VGND VGND VPWR VPWR sky130_fd_sc_hd__decap_3
XFILLER_15_523 VGND VGND VPWR VPWR sky130_fd_sc_hd__decap_3
XFILLER_15_545 VGND VGND VPWR VPWR sky130_fd_sc_hd__decap_3
XFILLER_27_383 VGND VGND VPWR VPWR sky130_fd_sc_hd__decap_3
XFILLER_61_128 VGND VGND VPWR VPWR sky130_fd_sc_hd__fill_2
XFILLER_91_66 VGND VGND VPWR VPWR sky130_fd_sc_hd__decap_3
XFILLER_30_526 VGND VGND VPWR VPWR sky130_fd_sc_hd__fill_1
XFILLER_91_77 VGND VGND VPWR VPWR sky130_fd_sc_hd__decap_3
XFILLER_6_210 VGND VGND VPWR VPWR sky130_fd_sc_hd__decap_3
XFILLER_6_287 VGND VGND VPWR VPWR sky130_fd_sc_hd__decap_3
XFILLER_34_6 VGND VGND VPWR VPWR sky130_fd_sc_hd__decap_3
XFILLER_37_125 VGND VGND VPWR VPWR sky130_fd_sc_hd__decap_3
XFILLER_77_294 VGND VGND VPWR VPWR sky130_fd_sc_hd__decap_3
XFILLER_37_169 VGND VGND VPWR VPWR sky130_fd_sc_hd__decap_3
XFILLER_52_106 VGND VGND VPWR VPWR sky130_fd_sc_hd__decap_3
XFILLER_65_467 VGND VGND VPWR VPWR sky130_fd_sc_hd__decap_3
XTAP_TAPCELL_ROW_48_654 VGND VPWR sky130_fd_sc_hd__tapvpwrvgnd_1
XFILLER_92_253 VGND VGND VPWR VPWR sky130_fd_sc_hd__decap_3
X_4901_ _5215_/CLK _4901_/D VGND VGND VPWR VPWR _4901_/Q sky130_fd_sc_hd__dfxtp_2
XFILLER_33_386 VGND VGND VPWR VPWR sky130_fd_sc_hd__fill_1
X_4832_ _5271_/Q _4847_/B _4830_/Y _4831_/X _3338_/B VGND VGND VPWR VPWR _5271_/D
+ sky130_fd_sc_hd__o221a_2
XFILLER_60_194 VGND VGND VPWR VPWR sky130_fd_sc_hd__fill_2
X_4763_ _5161_/Q _4763_/B VGND VGND VPWR VPWR _4772_/A sky130_fd_sc_hd__or2_2
X_4694_ _5282_/Q _5274_/Q VGND VGND VPWR VPWR _4694_/Y sky130_fd_sc_hd__nand2_2
X_3714_ _3714_/A _4155_/B VGND VGND VPWR VPWR _4199_/D sky130_fd_sc_hd__nor2_2
XFILLER_20_18 VGND VGND VPWR VPWR sky130_fd_sc_hd__decap_3
XFILLER_20_29 VGND VGND VPWR VPWR sky130_fd_sc_hd__decap_3
X_3645_ _3705_/A _3645_/B VGND VGND VPWR VPWR _3645_/X sky130_fd_sc_hd__or2_2
X_3576_ _3576_/A _4175_/A VGND VGND VPWR VPWR _3963_/A sky130_fd_sc_hd__and2_2
XFILLER_0_408 VGND VGND VPWR VPWR sky130_fd_sc_hd__decap_3
X_2527_ _4958_/Q _4942_/Q _4926_/Q _4910_/Q _5127_/Q _5128_/Q VGND VGND VPWR VPWR
+ _2527_/X sky130_fd_sc_hd__mux4_2
XTAP_TAPCELL_ROW_93_1085 VGND VPWR sky130_fd_sc_hd__tapvpwrvgnd_1
X_5246_ _5253_/CLK _5246_/D VGND VGND VPWR VPWR _5246_/Q sky130_fd_sc_hd__dfxtp_2
X_2458_ _5175_/Q _5174_/Q _5173_/Q _5172_/Q VGND VGND VPWR VPWR _2458_/X sky130_fd_sc_hd__and4_2
XTAP_TAPCELL_ROW_93_1096 VGND VPWR sky130_fd_sc_hd__tapvpwrvgnd_1
XPHY_EDGE_ROW_89_Right_89 VGND VGND VPWR VPWR sky130_fd_sc_hd__decap_3
XFILLER_28_103 VGND VGND VPWR VPWR sky130_fd_sc_hd__decap_3
XFILLER_56_401 VGND VGND VPWR VPWR sky130_fd_sc_hd__decap_3
XFILLER_68_283 VGND VGND VPWR VPWR sky130_fd_sc_hd__decap_3
X_5177_ _5177_/CLK _5177_/D VGND VGND VPWR VPWR _5177_/Q sky130_fd_sc_hd__dfxtp_2
XFILLER_56_434 VGND VGND VPWR VPWR sky130_fd_sc_hd__decap_3
X_4128_ _3701_/A _4449_/S _4127_/Y VGND VGND VPWR VPWR _4129_/A sky130_fd_sc_hd__o21a_2
XFILLER_83_220 VGND VGND VPWR VPWR sky130_fd_sc_hd__decap_3
X_4059_ _4084_/C _4041_/X _4058_/X VGND VGND VPWR VPWR _4059_/X sky130_fd_sc_hd__o21a_2
XTAP_TAPCELL_ROW_82_977 VGND VPWR sky130_fd_sc_hd__tapvpwrvgnd_1
XFILLER_12_515 VGND VGND VPWR VPWR sky130_fd_sc_hd__fill_2
XFILLER_51_172 VGND VGND VPWR VPWR sky130_fd_sc_hd__decap_3
XFILLER_61_14 VGND VGND VPWR VPWR sky130_fd_sc_hd__fill_2
XFILLER_61_69 VGND VGND VPWR VPWR sky130_fd_sc_hd__decap_3
XFILLER_3_246 VGND VGND VPWR VPWR sky130_fd_sc_hd__decap_3
XFILLER_19_60 VGND VGND VPWR VPWR sky130_fd_sc_hd__fill_2
XFILLER_19_71 VGND VGND VPWR VPWR sky130_fd_sc_hd__decap_3
XFILLER_47_434 VGND VGND VPWR VPWR sky130_fd_sc_hd__decap_3
XFILLER_59_294 VGND VGND VPWR VPWR sky130_fd_sc_hd__decap_3
XFILLER_19_169 VGND VGND VPWR VPWR sky130_fd_sc_hd__decap_3
XFILLER_34_106 VGND VGND VPWR VPWR sky130_fd_sc_hd__decap_3
XFILLER_47_467 VGND VGND VPWR VPWR sky130_fd_sc_hd__decap_3
XFILLER_74_253 VGND VGND VPWR VPWR sky130_fd_sc_hd__fill_2
XFILLER_62_437 VGND VGND VPWR VPWR sky130_fd_sc_hd__decap_3
XTAP_TAPCELL_ROW_17_359 VGND VPWR sky130_fd_sc_hd__tapvpwrvgnd_1
XFILLER_15_386 VGND VGND VPWR VPWR sky130_fd_sc_hd__decap_3
XFILLER_30_301 VGND VGND VPWR VPWR sky130_fd_sc_hd__decap_3
XFILLER_30_389 VGND VGND VPWR VPWR sky130_fd_sc_hd__decap_3
XFILLER_51_80 VGND VGND VPWR VPWR sky130_fd_sc_hd__decap_3
X_3430_ _3424_/A _3424_/C _3424_/D _3419_/X VGND VGND VPWR VPWR _3432_/C sky130_fd_sc_hd__a31o_2
X_3361_ _4854_/B _3361_/B VGND VGND VPWR VPWR _3364_/A sky130_fd_sc_hd__or2_2
XFILLER_32_3 VGND VGND VPWR VPWR sky130_fd_sc_hd__decap_3
X_5100_ _5114_/CLK _5100_/D VGND VGND VPWR VPWR _5100_/Q sky130_fd_sc_hd__dfxtp_2
X_5031_ _5069_/CLK _5031_/D VGND VGND VPWR VPWR _5031_/Q sky130_fd_sc_hd__dfxtp_2
X_3292_ _5148_/Q _5147_/Q _5146_/Q VGND VGND VPWR VPWR _3307_/D sky130_fd_sc_hd__and3_2
XFILLER_38_401 VGND VGND VPWR VPWR sky130_fd_sc_hd__decap_3
XFILLER_85_518 VGND VGND VPWR VPWR sky130_fd_sc_hd__decap_3
XFILLER_65_220 VGND VGND VPWR VPWR sky130_fd_sc_hd__decap_3
XFILLER_38_489 VGND VGND VPWR VPWR sky130_fd_sc_hd__decap_3
XTAP_TAPCELL_ROW_0_205 VGND VPWR sky130_fd_sc_hd__tapvpwrvgnd_1
XFILLER_93_551 VGND VGND VPWR VPWR sky130_fd_sc_hd__decap_3
XFILLER_80_223 VGND VGND VPWR VPWR sky130_fd_sc_hd__fill_1
XFILLER_15_18 VGND VGND VPWR VPWR sky130_fd_sc_hd__decap_3
XFILLER_33_150 VGND VGND VPWR VPWR sky130_fd_sc_hd__decap_3
XFILLER_33_161 VGND VGND VPWR VPWR sky130_fd_sc_hd__decap_3
XFILLER_33_172 VGND VGND VPWR VPWR sky130_fd_sc_hd__decap_3
XFILLER_61_470 VGND VGND VPWR VPWR sky130_fd_sc_hd__decap_3
XFILLER_21_334 VGND VGND VPWR VPWR sky130_fd_sc_hd__fill_2
XFILLER_33_194 VGND VGND VPWR VPWR sky130_fd_sc_hd__decap_3
X_4815_ _4815_/A _4815_/B _4788_/B _4795_/A VGND VGND VPWR VPWR _4818_/A sky130_fd_sc_hd__or4bb_2
XFILLER_21_367 VGND VGND VPWR VPWR sky130_fd_sc_hd__decap_3
X_4746_ _5159_/Q _4746_/B VGND VGND VPWR VPWR _4747_/B sky130_fd_sc_hd__or2_2
X_4677_ _4246_/X _4666_/X _4676_/X _4541_/X VGND VGND VPWR VPWR _4677_/X sky130_fd_sc_hd__a31o_2
X_3628_ _3623_/X _3624_/X _3627_/X _2430_/Y VGND VGND VPWR VPWR _3630_/B sky130_fd_sc_hd__a22o_2
X_3559_ _3956_/S VGND VGND VPWR VPWR _3961_/S sky130_fd_sc_hd__inv_2
XFILLER_88_323 VGND VGND VPWR VPWR sky130_fd_sc_hd__decap_3
XFILLER_88_301 VGND VGND VPWR VPWR sky130_fd_sc_hd__decap_3
XFILLER_0_249 VGND VGND VPWR VPWR sky130_fd_sc_hd__decap_3
XFILLER_88_356 VGND VGND VPWR VPWR sky130_fd_sc_hd__decap_3
XFILLER_29_401 VGND VGND VPWR VPWR sky130_fd_sc_hd__fill_1
X_5229_ _5241_/CLK _5229_/D VGND VGND VPWR VPWR _5229_/Q sky130_fd_sc_hd__dfxtp_2
XFILLER_76_518 VGND VGND VPWR VPWR sky130_fd_sc_hd__decap_3
XFILLER_29_423 VGND VGND VPWR VPWR sky130_fd_sc_hd__decap_3
XFILLER_29_489 VGND VGND VPWR VPWR sky130_fd_sc_hd__decap_3
XFILLER_56_264 VGND VGND VPWR VPWR sky130_fd_sc_hd__decap_3
XFILLER_56_58 VGND VGND VPWR VPWR sky130_fd_sc_hd__fill_2
XFILLER_16_128 VGND VGND VPWR VPWR sky130_fd_sc_hd__fill_2
XFILLER_44_415 VGND VGND VPWR VPWR sky130_fd_sc_hd__decap_3
XFILLER_44_426 VGND VGND VPWR VPWR sky130_fd_sc_hd__fill_2
XFILLER_44_448 VGND VGND VPWR VPWR sky130_fd_sc_hd__decap_3
XFILLER_56_286 VGND VGND VPWR VPWR sky130_fd_sc_hd__decap_3
XFILLER_71_223 VGND VGND VPWR VPWR sky130_fd_sc_hd__fill_1
XFILLER_71_267 VGND VGND VPWR VPWR sky130_fd_sc_hd__decap_3
XFILLER_12_312 VGND VGND VPWR VPWR sky130_fd_sc_hd__decap_3
XFILLER_72_35 VGND VGND VPWR VPWR sky130_fd_sc_hd__decap_3
XTAP_TAPCELL_ROW_42_605 VGND VPWR sky130_fd_sc_hd__tapvpwrvgnd_1
XFILLER_12_345 VGND VGND VPWR VPWR sky130_fd_sc_hd__decap_3
XFILLER_8_349 VGND VGND VPWR VPWR sky130_fd_sc_hd__fill_1
XFILLER_4_500 VGND VGND VPWR VPWR sky130_fd_sc_hd__decap_3
XFILLER_4_533 VGND VGND VPWR VPWR sky130_fd_sc_hd__decap_3
XFILLER_21_83 VGND VGND VPWR VPWR sky130_fd_sc_hd__decap_3
XFILLER_79_312 VGND VGND VPWR VPWR sky130_fd_sc_hd__fill_2
XFILLER_79_367 VGND VGND VPWR VPWR sky130_fd_sc_hd__decap_3
XFILLER_62_212 VGND VGND VPWR VPWR sky130_fd_sc_hd__decap_3
XFILLER_50_407 VGND VGND VPWR VPWR sky130_fd_sc_hd__decap_3
XFILLER_90_554 VGND VGND VPWR VPWR sky130_fd_sc_hd__decap_3
XFILLER_15_161 VGND VGND VPWR VPWR sky130_fd_sc_hd__decap_3
XFILLER_22_109 VGND VGND VPWR VPWR sky130_fd_sc_hd__decap_3
XFILLER_62_278 VGND VGND VPWR VPWR sky130_fd_sc_hd__decap_3
X_2930_ _5277_/Q _5251_/Q _5235_/Q _2947_/B1 VGND VGND VPWR VPWR _2931_/B sky130_fd_sc_hd__a22o_2
XFILLER_15_172 VGND VGND VPWR VPWR sky130_fd_sc_hd__decap_3
X_4600_ _4168_/A _4200_/C _3778_/D _2642_/Y VGND VGND VPWR VPWR _4604_/A sky130_fd_sc_hd__o2bb2a_2
X_2861_ _2873_/A _2861_/B VGND VGND VPWR VPWR _2861_/Y sky130_fd_sc_hd__nor2_2
XFILLER_30_197 VGND VGND VPWR VPWR sky130_fd_sc_hd__decap_3
X_2792_ _2832_/A _2791_/X _2435_/Y VGND VGND VPWR VPWR _2792_/X sky130_fd_sc_hd__o21a_2
X_4531_ _4531_/A _4531_/B _4531_/C VGND VGND VPWR VPWR _4531_/X sky130_fd_sc_hd__and3_2
X_4462_ _4462_/A _4462_/B _4462_/C VGND VGND VPWR VPWR _4463_/B sky130_fd_sc_hd__nor3_2
XFILLER_7_74 VGND VGND VPWR VPWR sky130_fd_sc_hd__fill_1
XFILLER_7_393 VGND VGND VPWR VPWR sky130_fd_sc_hd__decap_3
XFILLER_7_382 VGND VGND VPWR VPWR sky130_fd_sc_hd__decap_3
X_3413_ _3415_/A VGND VGND VPWR VPWR _3424_/A sky130_fd_sc_hd__inv_2
X_4393_ _4393_/A _4393_/B _4393_/C _4393_/D VGND VGND VPWR VPWR _4458_/A sky130_fd_sc_hd__nand4_2
XFILLER_58_507 VGND VGND VPWR VPWR sky130_fd_sc_hd__fill_2
X_3344_ _5283_/Q _3366_/A _3344_/C VGND VGND VPWR VPWR _3344_/X sky130_fd_sc_hd__and3_2
XTAP_TAPCELL_ROW_90_1055 VGND VPWR sky130_fd_sc_hd__tapvpwrvgnd_1
X_3275_ _5264_/Q _3315_/B _3273_/Y _3274_/X VGND VGND VPWR VPWR _3276_/B sky130_fd_sc_hd__o2bb2a_2
X_5014_ clkload8/A _5014_/D VGND VGND VPWR VPWR _5014_/Q sky130_fd_sc_hd__dfxtp_2
XFILLER_38_253 VGND VGND VPWR VPWR sky130_fd_sc_hd__decap_3
XFILLER_38_275 VGND VGND VPWR VPWR sky130_fd_sc_hd__fill_2
XFILLER_41_407 VGND VGND VPWR VPWR sky130_fd_sc_hd__decap_3
XFILLER_53_278 VGND VGND VPWR VPWR sky130_fd_sc_hd__fill_2
XFILLER_34_492 VGND VGND VPWR VPWR sky130_fd_sc_hd__decap_3
XFILLER_42_27 VGND VGND VPWR VPWR sky130_fd_sc_hd__fill_1
XFILLER_21_175 VGND VGND VPWR VPWR sky130_fd_sc_hd__decap_3
XFILLER_21_186 VGND VGND VPWR VPWR sky130_fd_sc_hd__decap_3
XFILLER_5_308 VGND VGND VPWR VPWR sky130_fd_sc_hd__decap_3
X_4729_ _4734_/A _4728_/Y _4847_/B VGND VGND VPWR VPWR _4729_/Y sky130_fd_sc_hd__o21ai_2
XFILLER_1_503 VGND VGND VPWR VPWR sky130_fd_sc_hd__fill_1
XFILLER_1_514 VGND VGND VPWR VPWR sky130_fd_sc_hd__decap_3
XFILLER_1_547 VGND VGND VPWR VPWR sky130_fd_sc_hd__decap_3
XFILLER_88_120 VGND VGND VPWR VPWR sky130_fd_sc_hd__decap_3
XFILLER_67_35 VGND VGND VPWR VPWR sky130_fd_sc_hd__fill_1
XFILLER_67_57 VGND VGND VPWR VPWR sky130_fd_sc_hd__fill_1
XFILLER_88_164 VGND VGND VPWR VPWR sky130_fd_sc_hd__decap_3
XFILLER_76_315 VGND VGND VPWR VPWR sky130_fd_sc_hd__decap_3
XFILLER_67_68 VGND VGND VPWR VPWR sky130_fd_sc_hd__decap_3
XFILLER_88_197 VGND VGND VPWR VPWR sky130_fd_sc_hd__decap_3
XFILLER_72_510 VGND VGND VPWR VPWR sky130_fd_sc_hd__decap_3
XFILLER_83_34 VGND VGND VPWR VPWR sky130_fd_sc_hd__decap_3
XFILLER_83_12 VGND VGND VPWR VPWR sky130_fd_sc_hd__decap_3
XFILLER_44_245 VGND VGND VPWR VPWR sky130_fd_sc_hd__decap_3
XFILLER_44_256 VGND VGND VPWR VPWR sky130_fd_sc_hd__decap_3
XFILLER_72_554 VGND VGND VPWR VPWR sky130_fd_sc_hd__decap_3
XFILLER_83_67 VGND VGND VPWR VPWR sky130_fd_sc_hd__decap_3
XFILLER_32_407 VGND VGND VPWR VPWR sky130_fd_sc_hd__decap_3
XTAP_TAPCELL_ROW_27_454 VGND VPWR sky130_fd_sc_hd__tapvpwrvgnd_1
XFILLER_83_89 VGND VGND VPWR VPWR sky130_fd_sc_hd__decap_3
XFILLER_16_94 VGND VGND VPWR VPWR sky130_fd_sc_hd__fill_1
XFILLER_12_153 VGND VGND VPWR VPWR sky130_fd_sc_hd__decap_3
XFILLER_40_462 VGND VGND VPWR VPWR sky130_fd_sc_hd__decap_3
XFILLER_12_175 VGND VGND VPWR VPWR sky130_fd_sc_hd__decap_3
XFILLER_40_495 VGND VGND VPWR VPWR sky130_fd_sc_hd__decap_3
XFILLER_32_71 VGND VGND VPWR VPWR sky130_fd_sc_hd__decap_3
XFILLER_4_341 VGND VGND VPWR VPWR sky130_fd_sc_hd__fill_1
XFILLER_67_315 VGND VGND VPWR VPWR sky130_fd_sc_hd__decap_3
X_3060_ _2937_/X _3048_/B _3048_/Y _4978_/Q VGND VGND VPWR VPWR _4978_/D sky130_fd_sc_hd__a22o_2
XFILLER_48_551 VGND VGND VPWR VPWR sky130_fd_sc_hd__decap_3
XFILLER_67_359 VGND VGND VPWR VPWR sky130_fd_sc_hd__decap_3
XFILLER_82_318 VGND VGND VPWR VPWR sky130_fd_sc_hd__decap_3
XFILLER_75_381 VGND VGND VPWR VPWR sky130_fd_sc_hd__fill_2
XFILLER_63_543 VGND VGND VPWR VPWR sky130_fd_sc_hd__fill_1
XFILLER_23_418 VGND VGND VPWR VPWR sky130_fd_sc_hd__decap_3
XFILLER_35_267 VGND VGND VPWR VPWR sky130_fd_sc_hd__fill_1
XFILLER_35_289 VGND VGND VPWR VPWR sky130_fd_sc_hd__decap_3
XFILLER_50_215 VGND VGND VPWR VPWR sky130_fd_sc_hd__decap_3
XFILLER_90_362 VGND VGND VPWR VPWR sky130_fd_sc_hd__fill_2
X_3962_ _4071_/A _3961_/X _3960_/Y VGND VGND VPWR VPWR _4175_/B sky130_fd_sc_hd__o21a_2
XFILLER_31_440 VGND VGND VPWR VPWR sky130_fd_sc_hd__decap_3
X_3893_ _5182_/Q _3894_/B VGND VGND VPWR VPWR _4015_/B sky130_fd_sc_hd__nor2_2
X_2913_ _5277_/Q _5246_/Q _5198_/Q _5275_/Q VGND VGND VPWR VPWR _2913_/X sky130_fd_sc_hd__a22o_2
XTAP_TAPCELL_ROW_61_777 VGND VPWR sky130_fd_sc_hd__tapvpwrvgnd_1
X_2844_ _2855_/S _2844_/B VGND VGND VPWR VPWR _2844_/X sky130_fd_sc_hd__or2_2
X_4514_ _4449_/X _4451_/X _4515_/B VGND VGND VPWR VPWR _4514_/X sky130_fd_sc_hd__mux2_1
X_2775_ _5138_/Q _2770_/X _2772_/X _2774_/X VGND VGND VPWR VPWR _4769_/B sky130_fd_sc_hd__a22o_2
XFILLER_7_190 VGND VGND VPWR VPWR sky130_fd_sc_hd__decap_3
X_4445_ _4486_/S _4445_/B VGND VGND VPWR VPWR _4445_/X sky130_fd_sc_hd__or2_2
X_4376_ _4376_/A _4376_/B VGND VGND VPWR VPWR _4382_/A sky130_fd_sc_hd__or2_2
X_3327_ _5161_/Q _4868_/A2 _4870_/B1 _3326_/X VGND VGND VPWR VPWR _5161_/D sky130_fd_sc_hd__o22a_2
XFILLER_85_101 VGND VGND VPWR VPWR sky130_fd_sc_hd__decap_3
XFILLER_39_540 VGND VGND VPWR VPWR sky130_fd_sc_hd__decap_3
X_3258_ _5139_/Q _3311_/S VGND VGND VPWR VPWR _3258_/Y sky130_fd_sc_hd__nand2_2
XTAP_TAPCELL_ROW_69_855 VGND VPWR sky130_fd_sc_hd__tapvpwrvgnd_1
XFILLER_85_145 VGND VGND VPWR VPWR sky130_fd_sc_hd__decap_3
XFILLER_26_212 VGND VGND VPWR VPWR sky130_fd_sc_hd__decap_3
XFILLER_54_521 VGND VGND VPWR VPWR sky130_fd_sc_hd__decap_3
XFILLER_73_318 VGND VGND VPWR VPWR sky130_fd_sc_hd__decap_3
X_3189_ _2944_/X _3175_/B _3175_/Y _5092_/Q VGND VGND VPWR VPWR _5092_/D sky130_fd_sc_hd__a22o_2
XFILLER_81_340 VGND VGND VPWR VPWR sky130_fd_sc_hd__decap_3
XFILLER_26_256 VGND VGND VPWR VPWR sky130_fd_sc_hd__decap_3
XTAP_TAPCELL_ROW_52_700 VGND VPWR sky130_fd_sc_hd__tapvpwrvgnd_1
XFILLER_41_248 VGND VGND VPWR VPWR sky130_fd_sc_hd__fill_1
XFILLER_22_462 VGND VGND VPWR VPWR sky130_fd_sc_hd__decap_3
XFILLER_78_12 VGND VGND VPWR VPWR sky130_fd_sc_hd__decap_3
XFILLER_1_311 VGND VGND VPWR VPWR sky130_fd_sc_hd__fill_2
XFILLER_1_333 VGND VGND VPWR VPWR sky130_fd_sc_hd__decap_3
XFILLER_78_67 VGND VGND VPWR VPWR sky130_fd_sc_hd__decap_3
XFILLER_78_56 VGND VGND VPWR VPWR sky130_fd_sc_hd__decap_3
XFILLER_1_388 VGND VGND VPWR VPWR sky130_fd_sc_hd__decap_3
XFILLER_49_337 VGND VGND VPWR VPWR sky130_fd_sc_hd__decap_3
XFILLER_76_112 VGND VGND VPWR VPWR sky130_fd_sc_hd__decap_3
XFILLER_64_307 VGND VGND VPWR VPWR sky130_fd_sc_hd__fill_1
XFILLER_76_156 VGND VGND VPWR VPWR sky130_fd_sc_hd__decap_3
XFILLER_64_318 VGND VGND VPWR VPWR sky130_fd_sc_hd__decap_3
XFILLER_45_543 VGND VGND VPWR VPWR sky130_fd_sc_hd__decap_3
XFILLER_17_256 VGND VGND VPWR VPWR sky130_fd_sc_hd__decap_3
XFILLER_60_502 VGND VGND VPWR VPWR sky130_fd_sc_hd__decap_3
XFILLER_72_351 VGND VGND VPWR VPWR sky130_fd_sc_hd__decap_3
XFILLER_32_215 VGND VGND VPWR VPWR sky130_fd_sc_hd__decap_3
XFILLER_32_248 VGND VGND VPWR VPWR sky130_fd_sc_hd__decap_3
XFILLER_43_81 VGND VGND VPWR VPWR sky130_fd_sc_hd__decap_3
XFILLER_9_433 VGND VGND VPWR VPWR sky130_fd_sc_hd__decap_3
XFILLER_9_488 VGND VGND VPWR VPWR sky130_fd_sc_hd__decap_3
X_2560_ _4955_/Q _4939_/Q _4923_/Q _4907_/Q _5127_/Q _5128_/Q VGND VGND VPWR VPWR
+ _2560_/X sky130_fd_sc_hd__mux4_2
X_2491_ _4365_/A VGND VGND VPWR VPWR _4378_/B sky130_fd_sc_hd__inv_2
X_4230_ _4236_/A _2892_/B _2892_/C _4229_/Y VGND VGND VPWR VPWR _4230_/X sky130_fd_sc_hd__a31o_2
XFILLER_4_53 VGND VGND VPWR VPWR sky130_fd_sc_hd__decap_3
X_4161_ _4161_/A _4161_/B _4152_/Y VGND VGND VPWR VPWR _4161_/X sky130_fd_sc_hd__or3b_2
XFILLER_55_307 VGND VGND VPWR VPWR sky130_fd_sc_hd__decap_3
XFILLER_67_167 VGND VGND VPWR VPWR sky130_fd_sc_hd__fill_1
X_4092_ _4067_/Y _4091_/X _4692_/A VGND VGND VPWR VPWR _5217_/D sky130_fd_sc_hd__a21oi_2
X_3112_ _2927_/X _3119_/A2 _3103_/Y _5023_/Q VGND VGND VPWR VPWR _5023_/D sky130_fd_sc_hd__a22o_2
X_3043_ _2944_/X _3029_/B _3029_/Y _4964_/Q VGND VGND VPWR VPWR _4964_/D sky130_fd_sc_hd__a22o_2
XTAP_TAPCELL_ROW_66_825 VGND VPWR sky130_fd_sc_hd__tapvpwrvgnd_1
XFILLER_82_126 VGND VGND VPWR VPWR sky130_fd_sc_hd__decap_3
XFILLER_82_104 VGND VGND VPWR VPWR sky130_fd_sc_hd__decap_3
XFILLER_48_381 VGND VGND VPWR VPWR sky130_fd_sc_hd__decap_3
XFILLER_23_204 VGND VGND VPWR VPWR sky130_fd_sc_hd__decap_3
XFILLER_63_362 VGND VGND VPWR VPWR sky130_fd_sc_hd__decap_3
X_4994_ _4994_/CLK _4994_/D VGND VGND VPWR VPWR _4994_/Q sky130_fd_sc_hd__dfxtp_2
X_3945_ _5171_/Q _4378_/A _3778_/D _4434_/A _3604_/B VGND VGND VPWR VPWR _3945_/X
+ sky130_fd_sc_hd__o32a_2
XTAP_TAPCELL_ROW_21_405 VGND VPWR sky130_fd_sc_hd__tapvpwrvgnd_1
X_3876_ _3876_/A VGND VGND VPWR VPWR _3876_/Y sky130_fd_sc_hd__inv_2
X_2827_ _4963_/Q _4947_/Q _4931_/Q _4915_/Q _2854_/S0 _2854_/S1 VGND VGND VPWR VPWR
+ _2827_/X sky130_fd_sc_hd__mux4_2
X_2758_ _2857_/A _4755_/B VGND VGND VPWR VPWR _2758_/X sky130_fd_sc_hd__and2_2
X_4428_ _4320_/Y _4321_/Y _4323_/Y VGND VGND VPWR VPWR _4428_/X sky130_fd_sc_hd__o21a_2
X_2689_ _2888_/B _2888_/C _4192_/A VGND VGND VPWR VPWR _4191_/B sky130_fd_sc_hd__a21oi_2
X_4359_ _4359_/A _4359_/B VGND VGND VPWR VPWR _4360_/B sky130_fd_sc_hd__xnor2_2
XFILLER_86_410 VGND VGND VPWR VPWR sky130_fd_sc_hd__decap_3
XFILLER_86_443 VGND VGND VPWR VPWR sky130_fd_sc_hd__decap_3
XFILLER_46_318 VGND VGND VPWR VPWR sky130_fd_sc_hd__decap_3
XFILLER_86_487 VGND VGND VPWR VPWR sky130_fd_sc_hd__decap_3
XFILLER_27_532 VGND VGND VPWR VPWR sky130_fd_sc_hd__decap_3
XFILLER_39_381 VGND VGND VPWR VPWR sky130_fd_sc_hd__fill_1
XFILLER_64_25 VGND VGND VPWR VPWR sky130_fd_sc_hd__decap_3
XFILLER_73_159 VGND VGND VPWR VPWR sky130_fd_sc_hd__decap_3
XFILLER_54_351 VGND VGND VPWR VPWR sky130_fd_sc_hd__fill_1
XFILLER_64_69 VGND VGND VPWR VPWR sky130_fd_sc_hd__decap_3
XFILLER_14_226 VGND VGND VPWR VPWR sky130_fd_sc_hd__decap_3
XFILLER_14_237 VGND VGND VPWR VPWR sky130_fd_sc_hd__decap_3
XFILLER_42_524 VGND VGND VPWR VPWR sky130_fd_sc_hd__decap_3
XFILLER_54_395 VGND VGND VPWR VPWR sky130_fd_sc_hd__decap_3
XFILLER_42_557 VGND VGND VPWR VPWR sky130_fd_sc_hd__fill_1
XFILLER_10_432 VGND VGND VPWR VPWR sky130_fd_sc_hd__fill_1
XFILLER_6_414 VGND VGND VPWR VPWR sky130_fd_sc_hd__decap_3
XFILLER_6_436 VGND VGND VPWR VPWR sky130_fd_sc_hd__decap_3
XFILLER_13_95 VGND VGND VPWR VPWR sky130_fd_sc_hd__decap_3
XFILLER_89_33 VGND VGND VPWR VPWR sky130_fd_sc_hd__decap_3
XFILLER_89_55 VGND VGND VPWR VPWR sky130_fd_sc_hd__fill_1
XFILLER_1_130 VGND VGND VPWR VPWR sky130_fd_sc_hd__fill_1
XTAP_TAPCELL_ROW_9_285 VGND VPWR sky130_fd_sc_hd__tapvpwrvgnd_1
XFILLER_49_101 VGND VGND VPWR VPWR sky130_fd_sc_hd__decap_3
XFILLER_89_292 VGND VGND VPWR VPWR sky130_fd_sc_hd__decap_3
XFILLER_77_410 VGND VGND VPWR VPWR sky130_fd_sc_hd__decap_3
XFILLER_49_145 VGND VGND VPWR VPWR sky130_fd_sc_hd__decap_3
XFILLER_49_178 VGND VGND VPWR VPWR sky130_fd_sc_hd__fill_1
XFILLER_92_424 VGND VGND VPWR VPWR sky130_fd_sc_hd__decap_3
XFILLER_77_476 VGND VGND VPWR VPWR sky130_fd_sc_hd__fill_1
XFILLER_92_446 VGND VGND VPWR VPWR sky130_fd_sc_hd__decap_3
XFILLER_33_546 VGND VGND VPWR VPWR sky130_fd_sc_hd__decap_3
XFILLER_45_373 VGND VGND VPWR VPWR sky130_fd_sc_hd__fill_1
XFILLER_60_321 VGND VGND VPWR VPWR sky130_fd_sc_hd__decap_3
XFILLER_60_365 VGND VGND VPWR VPWR sky130_fd_sc_hd__decap_3
XFILLER_20_218 VGND VGND VPWR VPWR sky130_fd_sc_hd__decap_3
XFILLER_60_398 VGND VGND VPWR VPWR sky130_fd_sc_hd__decap_3
X_3730_ _3733_/S _3727_/X _5134_/Q VGND VGND VPWR VPWR _3730_/X sky130_fd_sc_hd__o21a_2
XTAP_TAPCELL_ROW_71_872 VGND VPWR sky130_fd_sc_hd__tapvpwrvgnd_1
X_3661_ _3659_/X _3660_/X _3693_/A VGND VGND VPWR VPWR _3661_/X sky130_fd_sc_hd__mux2_1
Xclkload33 _5254_/CLK VGND VGND VPWR VPWR clkload33/Y sky130_fd_sc_hd__bufinv_16
Xclkload22 _5114_/CLK VGND VGND VPWR VPWR clkload22/Y sky130_fd_sc_hd__clkinv_2
Xclkload11 _5010_/CLK VGND VGND VPWR VPWR clkload11/X sky130_fd_sc_hd__clkbuf_4
X_3592_ _5133_/Q _3592_/B VGND VGND VPWR VPWR _3592_/X sky130_fd_sc_hd__or2_2
X_2612_ _5156_/Q _4320_/B VGND VGND VPWR VPWR _2862_/B sky130_fd_sc_hd__nand2_2
X_2543_ _2630_/B _2629_/A _2531_/Y VGND VGND VPWR VPWR _2543_/Y sky130_fd_sc_hd__o21ai_2
XFILLER_5_480 VGND VGND VPWR VPWR sky130_fd_sc_hd__decap_3
X_5262_ _5263_/CLK _5262_/D VGND VGND VPWR VPWR _5262_/Q sky130_fd_sc_hd__dfxtp_2
X_2474_ _5126_/Q _5014_/Q _4998_/Q _4982_/Q _2676_/S0 _2676_/S1 VGND VGND VPWR VPWR
+ _2475_/B sky130_fd_sc_hd__mux4_2
XFILLER_87_207 VGND VGND VPWR VPWR sky130_fd_sc_hd__decap_3
XFILLER_68_410 VGND VGND VPWR VPWR sky130_fd_sc_hd__decap_3
XFILLER_68_421 VGND VGND VPWR VPWR sky130_fd_sc_hd__decap_3
X_4213_ _4213_/A _4213_/B VGND VGND VPWR VPWR _4213_/Y sky130_fd_sc_hd__nor2_2
X_5193_ _5216_/CLK _5193_/D VGND VGND VPWR VPWR _5193_/Q sky130_fd_sc_hd__dfxtp_2
X_4144_ _4144_/A _4144_/B VGND VGND VPWR VPWR _4145_/B sky130_fd_sc_hd__nand2_2
XTAP_TAPCELL_ROW_79_950 VGND VPWR sky130_fd_sc_hd__tapvpwrvgnd_1
XFILLER_83_413 VGND VGND VPWR VPWR sky130_fd_sc_hd__decap_3
XFILLER_55_137 VGND VGND VPWR VPWR sky130_fd_sc_hd__decap_3
X_4075_ _4070_/X _4072_/X _4074_/X _4168_/A VGND VGND VPWR VPWR _4075_/X sky130_fd_sc_hd__a211o_2
XTAP_TAPCELL_ROW_87_1027 VGND VPWR sky130_fd_sc_hd__tapvpwrvgnd_1
XFILLER_83_446 VGND VGND VPWR VPWR sky130_fd_sc_hd__fill_2
XFILLER_70_107 VGND VGND VPWR VPWR sky130_fd_sc_hd__decap_3
X_3026_ _2947_/X _3011_/B _3011_/Y _4949_/Q VGND VGND VPWR VPWR _4949_/D sky130_fd_sc_hd__a22o_2
XFILLER_83_468 VGND VGND VPWR VPWR sky130_fd_sc_hd__decap_3
XFILLER_24_524 VGND VGND VPWR VPWR sky130_fd_sc_hd__decap_3
XFILLER_36_373 VGND VGND VPWR VPWR sky130_fd_sc_hd__decap_3
XFILLER_24_557 VGND VGND VPWR VPWR sky130_fd_sc_hd__fill_1
XFILLER_51_343 VGND VGND VPWR VPWR sky130_fd_sc_hd__decap_3
XFILLER_11_207 VGND VGND VPWR VPWR sky130_fd_sc_hd__decap_3
XFILLER_51_376 VGND VGND VPWR VPWR sky130_fd_sc_hd__decap_3
X_4977_ clkload5/A _4977_/D VGND VGND VPWR VPWR _4977_/Q sky130_fd_sc_hd__dfxtp_2
Xclkload5 clkload5/A VGND VGND VPWR VPWR clkload5/X sky130_fd_sc_hd__clkbuf_4
X_3928_ _3571_/A _3581_/X _3956_/S VGND VGND VPWR VPWR _3929_/B sky130_fd_sc_hd__mux2_1
XFILLER_50_38 VGND VGND VPWR VPWR sky130_fd_sc_hd__decap_3
X_3859_ _3854_/X _4031_/B _4078_/B VGND VGND VPWR VPWR _3859_/X sky130_fd_sc_hd__mux2_1
XFILLER_3_406 VGND VGND VPWR VPWR sky130_fd_sc_hd__decap_3
XFILLER_59_69 VGND VGND VPWR VPWR sky130_fd_sc_hd__decap_3
XFILLER_59_432 VGND VGND VPWR VPWR sky130_fd_sc_hd__decap_3
XFILLER_59_465 VGND VGND VPWR VPWR sky130_fd_sc_hd__decap_3
XTAP_TAPCELL_ROW_6_255 VGND VPWR sky130_fd_sc_hd__tapvpwrvgnd_1
XFILLER_15_535 VGND VGND VPWR VPWR sky130_fd_sc_hd__fill_2
XFILLER_15_557 VGND VGND VPWR VPWR sky130_fd_sc_hd__fill_1
XFILLER_42_343 VGND VGND VPWR VPWR sky130_fd_sc_hd__decap_3
XFILLER_54_192 VGND VGND VPWR VPWR sky130_fd_sc_hd__decap_3
XFILLER_30_505 VGND VGND VPWR VPWR sky130_fd_sc_hd__decap_3
XFILLER_42_387 VGND VGND VPWR VPWR sky130_fd_sc_hd__decap_3
XFILLER_91_89 VGND VGND VPWR VPWR sky130_fd_sc_hd__decap_3
XFILLER_24_83 VGND VGND VPWR VPWR sky130_fd_sc_hd__fill_1
XFILLER_10_251 VGND VGND VPWR VPWR sky130_fd_sc_hd__fill_1
XTAP_TAPCELL_ROW_40_577 VGND VPWR sky130_fd_sc_hd__tapvpwrvgnd_1
XFILLER_6_222 VGND VGND VPWR VPWR sky130_fd_sc_hd__decap_3
XFILLER_69_218 VGND VGND VPWR VPWR sky130_fd_sc_hd__decap_3
XFILLER_27_6 VGND VGND VPWR VPWR sky130_fd_sc_hd__fill_1
XFILLER_2_494 VGND VGND VPWR VPWR sky130_fd_sc_hd__decap_3
XFILLER_49_91 VGND VGND VPWR VPWR sky130_fd_sc_hd__fill_2
XFILLER_65_402 VGND VGND VPWR VPWR sky130_fd_sc_hd__decap_3
XTAP_TAPCELL_ROW_76_920 VGND VPWR sky130_fd_sc_hd__tapvpwrvgnd_1
XFILLER_77_273 VGND VGND VPWR VPWR sky130_fd_sc_hd__decap_3
XFILLER_77_251 VGND VGND VPWR VPWR sky130_fd_sc_hd__decap_3
XFILLER_1_65 VGND VGND VPWR VPWR sky130_fd_sc_hd__decap_3
XFILLER_37_137 VGND VGND VPWR VPWR sky130_fd_sc_hd__decap_3
XFILLER_65_435 VGND VGND VPWR VPWR sky130_fd_sc_hd__decap_3
XFILLER_92_221 VGND VGND VPWR VPWR sky130_fd_sc_hd__decap_3
XFILLER_65_479 VGND VGND VPWR VPWR sky130_fd_sc_hd__decap_3
XTAP_TAPCELL_ROW_48_655 VGND VPWR sky130_fd_sc_hd__tapvpwrvgnd_1
X_4900_ _5109_/CLK _4900_/D VGND VGND VPWR VPWR _4900_/Q sky130_fd_sc_hd__dfxtp_2
XFILLER_92_298 VGND VGND VPWR VPWR sky130_fd_sc_hd__decap_3
XFILLER_80_438 VGND VGND VPWR VPWR sky130_fd_sc_hd__decap_3
XFILLER_33_354 VGND VGND VPWR VPWR sky130_fd_sc_hd__decap_3
X_4831_ _4821_/A _4822_/X _4829_/Y _4854_/B VGND VGND VPWR VPWR _4831_/X sky130_fd_sc_hd__a31o_2
XFILLER_21_516 VGND VGND VPWR VPWR sky130_fd_sc_hd__decap_3
XFILLER_21_538 VGND VGND VPWR VPWR sky130_fd_sc_hd__decap_3
XFILLER_33_365 VGND VGND VPWR VPWR sky130_fd_sc_hd__decap_3
XFILLER_60_151 VGND VGND VPWR VPWR sky130_fd_sc_hd__decap_3
XTAP_TAPCELL_ROW_31_500 VGND VPWR sky130_fd_sc_hd__tapvpwrvgnd_1
XFILLER_21_549 VGND VGND VPWR VPWR sky130_fd_sc_hd__decap_3
X_4762_ _5161_/Q _4763_/B VGND VGND VPWR VPWR _4764_/A sky130_fd_sc_hd__nand2_2
X_4693_ _5282_/Q _5274_/Q VGND VGND VPWR VPWR _4725_/B sky130_fd_sc_hd__and2_2
X_3713_ _4397_/B _3713_/B VGND VGND VPWR VPWR _4155_/B sky130_fd_sc_hd__and2_2
X_3644_ _4902_/Q _4886_/Q _5110_/Q _5094_/Q _3706_/S0 _3706_/S1 VGND VGND VPWR VPWR
+ _3645_/B sky130_fd_sc_hd__mux4_2
X_3575_ _4071_/A _3574_/X _3569_/X _3566_/X VGND VGND VPWR VPWR _3777_/D sky130_fd_sc_hd__a211o_2
X_2526_ _5118_/Q _5006_/Q _4990_/Q _4974_/Q _5127_/Q _5128_/Q VGND VGND VPWR VPWR
+ _2526_/X sky130_fd_sc_hd__mux4_2
X_5245_ _5253_/CLK _5245_/D VGND VGND VPWR VPWR _5245_/Q sky130_fd_sc_hd__dfxtp_2
X_2457_ _5175_/Q _5174_/Q _5173_/Q _5172_/Q VGND VGND VPWR VPWR _3363_/C sky130_fd_sc_hd__or4_2
XTAP_TAPCELL_ROW_93_1097 VGND VPWR sky130_fd_sc_hd__tapvpwrvgnd_1
XTAP_TAPCELL_ROW_93_1086 VGND VPWR sky130_fd_sc_hd__tapvpwrvgnd_1
XFILLER_68_262 VGND VGND VPWR VPWR sky130_fd_sc_hd__decap_3
X_5176_ _5176_/CLK _5176_/D VGND VGND VPWR VPWR _5176_/Q sky130_fd_sc_hd__dfxtp_2
XFILLER_56_446 VGND VGND VPWR VPWR sky130_fd_sc_hd__decap_3
X_4127_ _4397_/B _4449_/S VGND VGND VPWR VPWR _4127_/Y sky130_fd_sc_hd__nand2b_2
XFILLER_71_405 VGND VGND VPWR VPWR sky130_fd_sc_hd__decap_3
X_4058_ _2629_/Y _4056_/X _4057_/Y VGND VGND VPWR VPWR _4058_/X sky130_fd_sc_hd__a21o_2
XFILLER_83_276 VGND VGND VPWR VPWR sky130_fd_sc_hd__decap_3
XFILLER_83_243 VGND VGND VPWR VPWR sky130_fd_sc_hd__fill_1
XFILLER_45_49 VGND VGND VPWR VPWR sky130_fd_sc_hd__decap_3
XFILLER_71_427 VGND VGND VPWR VPWR sky130_fd_sc_hd__decap_3
XFILLER_71_449 VGND VGND VPWR VPWR sky130_fd_sc_hd__decap_3
X_3009_ _2950_/X _2992_/Y _2993_/Y _4934_/Q VGND VGND VPWR VPWR _4934_/D sky130_fd_sc_hd__a22o_2
XFILLER_83_287 VGND VGND VPWR VPWR sky130_fd_sc_hd__decap_3
XFILLER_36_181 VGND VGND VPWR VPWR sky130_fd_sc_hd__fill_1
XTAP_TAPCELL_ROW_82_978 VGND VPWR sky130_fd_sc_hd__tapvpwrvgnd_1
XFILLER_24_365 VGND VGND VPWR VPWR sky130_fd_sc_hd__decap_3
XFILLER_51_140 VGND VGND VPWR VPWR sky130_fd_sc_hd__decap_3
XFILLER_12_549 VGND VGND VPWR VPWR sky130_fd_sc_hd__decap_3
XFILLER_61_48 VGND VGND VPWR VPWR sky130_fd_sc_hd__decap_3
XFILLER_79_505 VGND VGND VPWR VPWR sky130_fd_sc_hd__decap_3
XFILLER_86_12 VGND VGND VPWR VPWR sky130_fd_sc_hd__decap_3
XFILLER_47_413 VGND VGND VPWR VPWR sky130_fd_sc_hd__decap_3
XFILLER_19_126 VGND VGND VPWR VPWR sky130_fd_sc_hd__fill_2
XFILLER_19_50 VGND VGND VPWR VPWR sky130_fd_sc_hd__decap_3
XFILLER_19_83 VGND VGND VPWR VPWR sky130_fd_sc_hd__fill_1
XFILLER_47_446 VGND VGND VPWR VPWR sky130_fd_sc_hd__fill_2
XFILLER_74_221 VGND VGND VPWR VPWR sky130_fd_sc_hd__decap_3
XFILLER_47_479 VGND VGND VPWR VPWR sky130_fd_sc_hd__decap_3
XFILLER_62_405 VGND VGND VPWR VPWR sky130_fd_sc_hd__decap_3
XFILLER_34_118 VGND VGND VPWR VPWR sky130_fd_sc_hd__decap_3
XFILLER_62_449 VGND VGND VPWR VPWR sky130_fd_sc_hd__decap_3
XTAP_TAPCELL_ROW_45_625 VGND VPWR sky130_fd_sc_hd__tapvpwrvgnd_1
XFILLER_35_60 VGND VGND VPWR VPWR sky130_fd_sc_hd__fill_1
XFILLER_30_346 VGND VGND VPWR VPWR sky130_fd_sc_hd__decap_3
X_3360_ _5177_/Q _3357_/X _4854_/B VGND VGND VPWR VPWR _3360_/X sky130_fd_sc_hd__a21o_2
X_5030_ _5107_/CLK _5030_/D VGND VGND VPWR VPWR _5030_/Q sky130_fd_sc_hd__dfxtp_2
X_3291_ _5147_/Q _5146_/Q _3297_/B _5148_/Q VGND VGND VPWR VPWR _3291_/X sky130_fd_sc_hd__a31o_2
XFILLER_25_3 VGND VGND VPWR VPWR sky130_fd_sc_hd__decap_3
XFILLER_38_424 VGND VGND VPWR VPWR sky130_fd_sc_hd__decap_3
XFILLER_38_468 VGND VGND VPWR VPWR sky130_fd_sc_hd__decap_3
XTAP_TAPCELL_ROW_0_206 VGND VPWR sky130_fd_sc_hd__tapvpwrvgnd_1
XFILLER_53_438 VGND VGND VPWR VPWR sky130_fd_sc_hd__decap_3
XFILLER_53_449 VGND VGND VPWR VPWR sky130_fd_sc_hd__decap_3
XFILLER_80_279 VGND VGND VPWR VPWR sky130_fd_sc_hd__decap_3
XFILLER_21_346 VGND VGND VPWR VPWR sky130_fd_sc_hd__decap_3
XFILLER_61_482 VGND VGND VPWR VPWR sky130_fd_sc_hd__fill_2
X_4814_ _4814_/A _4814_/B VGND VGND VPWR VPWR _4815_/B sky130_fd_sc_hd__nand2_2
X_4745_ _5159_/Q _4746_/B VGND VGND VPWR VPWR _4747_/A sky130_fd_sc_hd__nand2_2
XFILLER_31_29 VGND VGND VPWR VPWR sky130_fd_sc_hd__decap_3
X_4676_ _4572_/S _4312_/Y _4564_/A _4671_/X _4675_/X VGND VGND VPWR VPWR _4676_/X
+ sky130_fd_sc_hd__o311a_2
X_3627_ _3625_/X _3626_/X _3693_/A VGND VGND VPWR VPWR _3627_/X sky130_fd_sc_hd__mux2_1
X_3558_ _4732_/A _4286_/A _3567_/S VGND VGND VPWR VPWR _3956_/S sky130_fd_sc_hd__mux2_1
XFILLER_0_206 VGND VGND VPWR VPWR sky130_fd_sc_hd__decap_3
XFILLER_0_228 VGND VGND VPWR VPWR sky130_fd_sc_hd__decap_3
X_2509_ _5075_/Q _5059_/Q _5043_/Q _5027_/Q _2672_/S0 _2672_/S1 VGND VGND VPWR VPWR
+ _2510_/B sky130_fd_sc_hd__mux4_2
X_3489_ _3494_/A _3489_/B VGND VGND VPWR VPWR _5208_/D sky130_fd_sc_hd__nor2_2
XFILLER_88_368 VGND VGND VPWR VPWR sky130_fd_sc_hd__decap_3
XFILLER_88_335 VGND VGND VPWR VPWR sky130_fd_sc_hd__decap_3
X_5228_ _5241_/CLK _5228_/D VGND VGND VPWR VPWR _5228_/Q sky130_fd_sc_hd__dfxtp_2
XFILLER_29_435 VGND VGND VPWR VPWR sky130_fd_sc_hd__decap_3
X_5159_ _5176_/CLK _5159_/D VGND VGND VPWR VPWR _5159_/Q sky130_fd_sc_hd__dfxtp_2
XFILLER_56_232 VGND VGND VPWR VPWR sky130_fd_sc_hd__decap_3
XFILLER_84_552 VGND VGND VPWR VPWR sky130_fd_sc_hd__decap_3
XFILLER_56_298 VGND VGND VPWR VPWR sky130_fd_sc_hd__fill_2
XFILLER_71_279 VGND VGND VPWR VPWR sky130_fd_sc_hd__fill_1
XFILLER_24_195 VGND VGND VPWR VPWR sky130_fd_sc_hd__fill_1
XFILLER_12_357 VGND VGND VPWR VPWR sky130_fd_sc_hd__decap_3
XFILLER_8_306 VGND VGND VPWR VPWR sky130_fd_sc_hd__fill_2
XTAP_TAPCELL_ROW_50_672 VGND VPWR sky130_fd_sc_hd__tapvpwrvgnd_1
XFILLER_20_390 VGND VGND VPWR VPWR sky130_fd_sc_hd__decap_3
XFILLER_4_512 VGND VGND VPWR VPWR sky130_fd_sc_hd__decap_3
XFILLER_4_545 VGND VGND VPWR VPWR sky130_fd_sc_hd__decap_3
XFILLER_79_324 VGND VGND VPWR VPWR sky130_fd_sc_hd__decap_3
XFILLER_79_346 VGND VGND VPWR VPWR sky130_fd_sc_hd__decap_3
XFILLER_79_335 VGND VGND VPWR VPWR sky130_fd_sc_hd__fill_1
XFILLER_67_508 VGND VGND VPWR VPWR sky130_fd_sc_hd__decap_3
XFILLER_79_379 VGND VGND VPWR VPWR sky130_fd_sc_hd__decap_3
XFILLER_35_405 VGND VGND VPWR VPWR sky130_fd_sc_hd__decap_3
XFILLER_47_243 VGND VGND VPWR VPWR sky130_fd_sc_hd__fill_2
XTAP_TAPCELL_ROW_58_750 VGND VPWR sky130_fd_sc_hd__tapvpwrvgnd_1
XFILLER_75_541 VGND VGND VPWR VPWR sky130_fd_sc_hd__decap_3
XFILLER_35_438 VGND VGND VPWR VPWR sky130_fd_sc_hd__decap_3
XFILLER_47_298 VGND VGND VPWR VPWR sky130_fd_sc_hd__decap_3
XFILLER_62_224 VGND VGND VPWR VPWR sky130_fd_sc_hd__decap_3
XFILLER_35_449 VGND VGND VPWR VPWR sky130_fd_sc_hd__decap_3
XFILLER_15_140 VGND VGND VPWR VPWR sky130_fd_sc_hd__decap_3
XFILLER_50_419 VGND VGND VPWR VPWR sky130_fd_sc_hd__fill_1
XFILLER_15_184 VGND VGND VPWR VPWR sky130_fd_sc_hd__decap_3
XFILLER_43_482 VGND VGND VPWR VPWR sky130_fd_sc_hd__decap_3
XFILLER_70_290 VGND VGND VPWR VPWR sky130_fd_sc_hd__decap_3
X_2860_ _2860_/A _2860_/B VGND VGND VPWR VPWR _2861_/B sky130_fd_sc_hd__or2_2
XFILLER_62_80 VGND VGND VPWR VPWR sky130_fd_sc_hd__decap_3
X_2791_ _4959_/Q _4943_/Q _4927_/Q _4911_/Q _2818_/S0 _5136_/Q VGND VGND VPWR VPWR
+ _2791_/X sky130_fd_sc_hd__mux4_2
X_4530_ _4011_/A _4021_/B _3894_/X _3986_/A _4529_/X VGND VGND VPWR VPWR _4531_/C
+ sky130_fd_sc_hd__o221a_2
XFILLER_7_53 VGND VGND VPWR VPWR sky130_fd_sc_hd__decap_3
XFILLER_7_350 VGND VGND VPWR VPWR sky130_fd_sc_hd__decap_3
XFILLER_7_31 VGND VGND VPWR VPWR sky130_fd_sc_hd__fill_1
X_4461_ _4462_/A _4462_/B _4462_/C VGND VGND VPWR VPWR _4463_/A sky130_fd_sc_hd__o21a_2
X_3412_ _5161_/Q _5142_/Q VGND VGND VPWR VPWR _3415_/A sky130_fd_sc_hd__nor2_2
X_4392_ _4356_/B _4391_/Y _4460_/A VGND VGND VPWR VPWR _4404_/A sky130_fd_sc_hd__o21ai_2
X_3343_ _5181_/Q _3230_/B _3230_/Y _3342_/X VGND VGND VPWR VPWR _5181_/D sky130_fd_sc_hd__o22a_2
XTAP_TAPCELL_ROW_90_1056 VGND VPWR sky130_fd_sc_hd__tapvpwrvgnd_1
X_3274_ _5143_/Q _5142_/Q _3270_/B _3315_/B VGND VGND VPWR VPWR _3274_/X sky130_fd_sc_hd__a31o_2
X_5013_ _5177_/CLK _5013_/D VGND VGND VPWR VPWR _5013_/Q sky130_fd_sc_hd__dfxtp_2
XFILLER_26_29 VGND VGND VPWR VPWR sky130_fd_sc_hd__decap_3
XFILLER_26_405 VGND VGND VPWR VPWR sky130_fd_sc_hd__decap_3
XFILLER_53_202 VGND VGND VPWR VPWR sky130_fd_sc_hd__fill_2
XFILLER_26_449 VGND VGND VPWR VPWR sky130_fd_sc_hd__fill_1
XPHY_EDGE_ROW_5_Right_5 VGND VGND VPWR VPWR sky130_fd_sc_hd__decap_3
XFILLER_93_393 VGND VGND VPWR VPWR sky130_fd_sc_hd__fill_2
XFILLER_81_544 VGND VGND VPWR VPWR sky130_fd_sc_hd__decap_3
XFILLER_34_460 VGND VGND VPWR VPWR sky130_fd_sc_hd__decap_3
X_2989_ _2947_/X _2974_/B _2974_/Y _4917_/Q VGND VGND VPWR VPWR _4917_/D sky130_fd_sc_hd__a22o_2
X_4728_ _5156_/Q _4728_/B VGND VGND VPWR VPWR _4728_/Y sky130_fd_sc_hd__nor2_2
X_4659_ _4191_/A _3567_/S _4659_/S VGND VGND VPWR VPWR _4661_/C sky130_fd_sc_hd__mux2_1
XFILLER_1_526 VGND VGND VPWR VPWR sky130_fd_sc_hd__decap_3
XFILLER_49_508 VGND VGND VPWR VPWR sky130_fd_sc_hd__decap_3
XFILLER_88_176 VGND VGND VPWR VPWR sky130_fd_sc_hd__decap_3
XFILLER_29_254 VGND VGND VPWR VPWR sky130_fd_sc_hd__decap_3
XFILLER_17_427 VGND VGND VPWR VPWR sky130_fd_sc_hd__decap_3
XFILLER_44_213 VGND VGND VPWR VPWR sky130_fd_sc_hd__decap_3
XFILLER_72_522 VGND VGND VPWR VPWR sky130_fd_sc_hd__decap_3
XFILLER_29_298 VGND VGND VPWR VPWR sky130_fd_sc_hd__decap_3
XFILLER_72_533 VGND VGND VPWR VPWR sky130_fd_sc_hd__decap_3
XTAP_TAPCELL_ROW_55_720 VGND VPWR sky130_fd_sc_hd__tapvpwrvgnd_1
XFILLER_83_57 VGND VGND VPWR VPWR sky130_fd_sc_hd__decap_3
XFILLER_83_46 VGND VGND VPWR VPWR sky130_fd_sc_hd__decap_3
XFILLER_32_419 VGND VGND VPWR VPWR sky130_fd_sc_hd__fill_1
XTAP_TAPCELL_ROW_27_455 VGND VPWR sky130_fd_sc_hd__tapvpwrvgnd_1
XFILLER_40_441 VGND VGND VPWR VPWR sky130_fd_sc_hd__decap_3
XFILLER_52_290 VGND VGND VPWR VPWR sky130_fd_sc_hd__decap_3
XFILLER_8_103 VGND VGND VPWR VPWR sky130_fd_sc_hd__decap_3
XFILLER_12_165 VGND VGND VPWR VPWR sky130_fd_sc_hd__fill_2
XTAP_TAPCELL_ROW_10_300 VGND VPWR sky130_fd_sc_hd__tapvpwrvgnd_1
XFILLER_32_83 VGND VGND VPWR VPWR sky130_fd_sc_hd__fill_1
XFILLER_4_386 VGND VGND VPWR VPWR sky130_fd_sc_hd__fill_1
XFILLER_67_305 VGND VGND VPWR VPWR sky130_fd_sc_hd__decap_3
XFILLER_48_530 VGND VGND VPWR VPWR sky130_fd_sc_hd__fill_2
XFILLER_57_80 VGND VGND VPWR VPWR sky130_fd_sc_hd__decap_3
XFILLER_63_511 VGND VGND VPWR VPWR sky130_fd_sc_hd__fill_1
X_3961_ _3872_/X _3874_/X _3961_/S VGND VGND VPWR VPWR _3961_/X sky130_fd_sc_hd__mux2_1
XFILLER_50_238 VGND VGND VPWR VPWR sky130_fd_sc_hd__decap_3
X_2912_ _4874_/Q _2942_/A2 _2911_/X _2951_/B2 VGND VGND VPWR VPWR _4874_/D sky130_fd_sc_hd__a22o_2
X_3892_ _3892_/A _3892_/B VGND VGND VPWR VPWR _3892_/Y sky130_fd_sc_hd__xnor2_2
XTAP_TAPCELL_ROW_61_778 VGND VPWR sky130_fd_sc_hd__tapvpwrvgnd_1
XFILLER_92_3 VGND VGND VPWR VPWR sky130_fd_sc_hd__decap_3
XFILLER_31_474 VGND VGND VPWR VPWR sky130_fd_sc_hd__decap_3
XFILLER_31_496 VGND VGND VPWR VPWR sky130_fd_sc_hd__decap_3
X_2843_ _5125_/Q _5013_/Q _4997_/Q _4981_/Q _2854_/S0 _5136_/Q VGND VGND VPWR VPWR
+ _2844_/B sky130_fd_sc_hd__mux4_2
X_2774_ _2832_/A _2773_/X _2435_/Y VGND VGND VPWR VPWR _2774_/X sky130_fd_sc_hd__o21a_2
X_4513_ _4512_/X _4511_/X _4572_/S VGND VGND VPWR VPWR _4513_/X sky130_fd_sc_hd__mux2_1
X_4444_ _4515_/B _4444_/B VGND VGND VPWR VPWR _4444_/Y sky130_fd_sc_hd__nand2_2
X_4375_ _4397_/A _4374_/X _4350_/B VGND VGND VPWR VPWR _4375_/X sky130_fd_sc_hd__o21a_2
X_3326_ _5283_/Q _3338_/B _3326_/C VGND VGND VPWR VPWR _3326_/X sky130_fd_sc_hd__and3_2
XFILLER_58_338 VGND VGND VPWR VPWR sky130_fd_sc_hd__decap_3
XFILLER_39_552 VGND VGND VPWR VPWR sky130_fd_sc_hd__decap_3
X_3257_ _5189_/Q _3311_/S VGND VGND VPWR VPWR _3305_/B sky130_fd_sc_hd__nand2_2
XTAP_TAPCELL_ROW_69_856 VGND VPWR sky130_fd_sc_hd__tapvpwrvgnd_1
XFILLER_85_157 VGND VGND VPWR VPWR sky130_fd_sc_hd__fill_2
X_3188_ _2941_/X _3191_/A2 _3191_/B1 _5091_/Q VGND VGND VPWR VPWR _5091_/D sky130_fd_sc_hd__a22o_2
XFILLER_26_224 VGND VGND VPWR VPWR sky130_fd_sc_hd__decap_3
XFILLER_54_533 VGND VGND VPWR VPWR sky130_fd_sc_hd__decap_3
XFILLER_54_555 VGND VGND VPWR VPWR sky130_fd_sc_hd__decap_3
XFILLER_66_382 VGND VGND VPWR VPWR sky130_fd_sc_hd__decap_3
XFILLER_81_330 VGND VGND VPWR VPWR sky130_fd_sc_hd__decap_3
XFILLER_14_419 VGND VGND VPWR VPWR sky130_fd_sc_hd__fill_1
XFILLER_26_268 VGND VGND VPWR VPWR sky130_fd_sc_hd__decap_3
XFILLER_81_352 VGND VGND VPWR VPWR sky130_fd_sc_hd__decap_3
XFILLER_53_38 VGND VGND VPWR VPWR sky130_fd_sc_hd__decap_3
XTAP_TAPCELL_ROW_24_425 VGND VPWR sky130_fd_sc_hd__tapvpwrvgnd_1
XFILLER_81_396 VGND VGND VPWR VPWR sky130_fd_sc_hd__decap_3
XFILLER_81_385 VGND VGND VPWR VPWR sky130_fd_sc_hd__decap_3
XFILLER_22_430 VGND VGND VPWR VPWR sky130_fd_sc_hd__decap_3
XFILLER_1_356 VGND VGND VPWR VPWR sky130_fd_sc_hd__decap_3
XFILLER_89_474 VGND VGND VPWR VPWR sky130_fd_sc_hd__decap_3
XFILLER_89_452 VGND VGND VPWR VPWR sky130_fd_sc_hd__decap_3
XFILLER_78_79 VGND VGND VPWR VPWR sky130_fd_sc_hd__decap_3
XFILLER_49_327 VGND VGND VPWR VPWR sky130_fd_sc_hd__decap_3
XFILLER_76_124 VGND VGND VPWR VPWR sky130_fd_sc_hd__decap_3
XFILLER_49_349 VGND VGND VPWR VPWR sky130_fd_sc_hd__decap_3
XFILLER_57_371 VGND VGND VPWR VPWR sky130_fd_sc_hd__decap_3
XFILLER_76_168 VGND VGND VPWR VPWR sky130_fd_sc_hd__fill_1
XFILLER_27_50 VGND VGND VPWR VPWR sky130_fd_sc_hd__decap_3
XFILLER_45_522 VGND VGND VPWR VPWR sky130_fd_sc_hd__decap_3
XFILLER_45_555 VGND VGND VPWR VPWR sky130_fd_sc_hd__decap_3
XFILLER_57_393 VGND VGND VPWR VPWR sky130_fd_sc_hd__decap_3
XFILLER_17_268 VGND VGND VPWR VPWR sky130_fd_sc_hd__decap_3
XFILLER_27_94 VGND VGND VPWR VPWR sky130_fd_sc_hd__decap_3
XFILLER_72_363 VGND VGND VPWR VPWR sky130_fd_sc_hd__fill_1
XFILLER_32_227 VGND VGND VPWR VPWR sky130_fd_sc_hd__decap_3
XFILLER_60_536 VGND VGND VPWR VPWR sky130_fd_sc_hd__fill_2
XFILLER_13_452 VGND VGND VPWR VPWR sky130_fd_sc_hd__decap_3
XFILLER_25_290 VGND VGND VPWR VPWR sky130_fd_sc_hd__fill_1
XFILLER_43_93 VGND VGND VPWR VPWR sky130_fd_sc_hd__decap_3
XFILLER_40_293 VGND VGND VPWR VPWR sky130_fd_sc_hd__decap_3
X_2490_ _2485_/X _2486_/X _2489_/X _2433_/Y VGND VGND VPWR VPWR _4365_/A sky130_fd_sc_hd__a22o_2
XFILLER_4_32 VGND VGND VPWR VPWR sky130_fd_sc_hd__decap_3
XFILLER_4_65 VGND VGND VPWR VPWR sky130_fd_sc_hd__fill_2
X_4160_ _3838_/A _4278_/B _4154_/Y _4159_/X VGND VGND VPWR VPWR _4161_/B sky130_fd_sc_hd__a211o_2
XFILLER_67_113 VGND VGND VPWR VPWR sky130_fd_sc_hd__decap_3
X_3111_ _2924_/X _3119_/A2 _3103_/Y _5022_/Q VGND VGND VPWR VPWR _5022_/D sky130_fd_sc_hd__a22o_2
X_4091_ _4168_/A _4090_/Y _4088_/X _4854_/B VGND VGND VPWR VPWR _4091_/X sky130_fd_sc_hd__a211o_2
XFILLER_48_371 VGND VGND VPWR VPWR sky130_fd_sc_hd__fill_2
XFILLER_55_319 VGND VGND VPWR VPWR sky130_fd_sc_hd__fill_1
X_3042_ _2941_/X _3028_/Y _3029_/Y _4963_/Q VGND VGND VPWR VPWR _4963_/D sky130_fd_sc_hd__a22o_2
XTAP_TAPCELL_ROW_66_826 VGND VPWR sky130_fd_sc_hd__tapvpwrvgnd_1
XFILLER_36_522 VGND VGND VPWR VPWR sky130_fd_sc_hd__decap_3
XFILLER_36_544 VGND VGND VPWR VPWR sky130_fd_sc_hd__decap_3
XFILLER_48_393 VGND VGND VPWR VPWR sky130_fd_sc_hd__decap_3
XFILLER_51_514 VGND VGND VPWR VPWR sky130_fd_sc_hd__decap_3
XFILLER_51_525 VGND VGND VPWR VPWR sky130_fd_sc_hd__fill_2
X_4993_ clkload5/A _4993_/D VGND VGND VPWR VPWR _4993_/Q sky130_fd_sc_hd__dfxtp_2
X_3944_ _3820_/A _4278_/B _3885_/Y _3934_/A VGND VGND VPWR VPWR _3944_/X sky130_fd_sc_hd__a22o_2
X_3875_ _3701_/A _4397_/D _3905_/B VGND VGND VPWR VPWR _3876_/A sky130_fd_sc_hd__mux2_1
X_2826_ _2855_/S _2826_/B VGND VGND VPWR VPWR _2826_/X sky130_fd_sc_hd__or2_2
X_2757_ _5138_/Q _2752_/X _2754_/X _2756_/X VGND VGND VPWR VPWR _4755_/B sky130_fd_sc_hd__a22o_2
X_2688_ _4633_/S _2688_/B VGND VGND VPWR VPWR _2888_/C sky130_fd_sc_hd__nand2_2
X_4427_ _4427_/A VGND VGND VPWR VPWR _4427_/Y sky130_fd_sc_hd__inv_2
X_4358_ _4322_/B _4390_/C VGND VGND VPWR VPWR _4359_/B sky130_fd_sc_hd__and2b_2
XFILLER_58_135 VGND VGND VPWR VPWR sky130_fd_sc_hd__decap_3
X_4289_ _4288_/X _4287_/Y _4309_/S VGND VGND VPWR VPWR _4486_/S sky130_fd_sc_hd__mux2_1
X_3309_ _5152_/Q _3309_/B VGND VGND VPWR VPWR _3309_/X sky130_fd_sc_hd__xor2_2
XFILLER_27_511 VGND VGND VPWR VPWR sky130_fd_sc_hd__fill_1
XFILLER_73_116 VGND VGND VPWR VPWR sky130_fd_sc_hd__decap_3
XFILLER_86_499 VGND VGND VPWR VPWR sky130_fd_sc_hd__fill_1
XFILLER_27_555 VGND VGND VPWR VPWR sky130_fd_sc_hd__decap_3
XTAP_TAPCELL_ROW_37_550 VGND VPWR sky130_fd_sc_hd__tapvpwrvgnd_1
XFILLER_14_205 VGND VGND VPWR VPWR sky130_fd_sc_hd__decap_3
XFILLER_54_374 VGND VGND VPWR VPWR sky130_fd_sc_hd__decap_3
XFILLER_14_249 VGND VGND VPWR VPWR sky130_fd_sc_hd__decap_3
XFILLER_10_444 VGND VGND VPWR VPWR sky130_fd_sc_hd__decap_3
XFILLER_80_58 VGND VGND VPWR VPWR sky130_fd_sc_hd__fill_1
XFILLER_13_52 VGND VGND VPWR VPWR sky130_fd_sc_hd__decap_3
XFILLER_13_63 VGND VGND VPWR VPWR sky130_fd_sc_hd__decap_3
XFILLER_6_448 VGND VGND VPWR VPWR sky130_fd_sc_hd__decap_3
XTAP_TAPCELL_ROW_9_286 VGND VPWR sky130_fd_sc_hd__tapvpwrvgnd_1
XFILLER_77_422 VGND VGND VPWR VPWR sky130_fd_sc_hd__decap_3
XFILLER_49_157 VGND VGND VPWR VPWR sky130_fd_sc_hd__decap_3
XFILLER_18_522 VGND VGND VPWR VPWR sky130_fd_sc_hd__decap_3
XFILLER_18_533 VGND VGND VPWR VPWR sky130_fd_sc_hd__decap_3
XFILLER_38_82 VGND VGND VPWR VPWR sky130_fd_sc_hd__fill_2
XFILLER_92_458 VGND VGND VPWR VPWR sky130_fd_sc_hd__decap_3
XFILLER_18_555 VGND VGND VPWR VPWR sky130_fd_sc_hd__decap_3
XFILLER_33_503 VGND VGND VPWR VPWR sky130_fd_sc_hd__fill_1
XFILLER_33_514 VGND VGND VPWR VPWR sky130_fd_sc_hd__fill_1
XFILLER_60_355 VGND VGND VPWR VPWR sky130_fd_sc_hd__decap_3
XFILLER_60_377 VGND VGND VPWR VPWR sky130_fd_sc_hd__decap_3
XTAP_TAPCELL_ROW_71_873 VGND VPWR sky130_fd_sc_hd__tapvpwrvgnd_1
X_3660_ _5125_/Q _5013_/Q _4997_/Q _4981_/Q _5131_/Q _5132_/Q VGND VGND VPWR VPWR
+ _3660_/X sky130_fd_sc_hd__mux4_2
XFILLER_70_91 VGND VGND VPWR VPWR sky130_fd_sc_hd__decap_3
Xclkload23 _5177_/CLK VGND VGND VPWR VPWR clkload23/X sky130_fd_sc_hd__clkbuf_4
Xclkload12 _5215_/CLK VGND VGND VPWR VPWR clkload12/Y sky130_fd_sc_hd__clkinv_4
X_3591_ _4893_/Q _4877_/Q _5101_/Q _5085_/Q _5131_/Q _5132_/Q VGND VGND VPWR VPWR
+ _3592_/B sky130_fd_sc_hd__mux4_2
X_2611_ _2604_/X _2606_/X _2609_/X _2433_/Y VGND VGND VPWR VPWR _4320_/B sky130_fd_sc_hd__a22o_2
X_2542_ _5162_/Q _3600_/A VGND VGND VPWR VPWR _2629_/A sky130_fd_sc_hd__nand2_2
XFILLER_5_492 VGND VGND VPWR VPWR sky130_fd_sc_hd__decap_3
X_5261_ _5263_/CLK _5261_/D VGND VGND VPWR VPWR _5261_/Q sky130_fd_sc_hd__dfxtp_2
X_4212_ _4212_/A _4212_/B VGND VGND VPWR VPWR _4213_/B sky130_fd_sc_hd__xnor2_2
X_2473_ _2677_/S _2470_/X _2472_/X VGND VGND VPWR VPWR _2473_/Y sky130_fd_sc_hd__o21ai_2
X_5192_ _5216_/CLK _5192_/D VGND VGND VPWR VPWR _5192_/Q sky130_fd_sc_hd__dfxtp_2
XFILLER_68_433 VGND VGND VPWR VPWR sky130_fd_sc_hd__decap_3
XFILLER_68_455 VGND VGND VPWR VPWR sky130_fd_sc_hd__decap_3
X_4143_ _4619_/S _4166_/B _4142_/B _4169_/D _4189_/A VGND VGND VPWR VPWR _4143_/X
+ sky130_fd_sc_hd__o311a_2
XTAP_TAPCELL_ROW_79_951 VGND VPWR sky130_fd_sc_hd__tapvpwrvgnd_1
XFILLER_18_19 VGND VGND VPWR VPWR sky130_fd_sc_hd__fill_1
XFILLER_55_116 VGND VGND VPWR VPWR sky130_fd_sc_hd__decap_3
XFILLER_68_477 VGND VGND VPWR VPWR sky130_fd_sc_hd__decap_3
X_4074_ _4086_/A _4278_/B _3885_/Y _4090_/A _4073_/X VGND VGND VPWR VPWR _4074_/X
+ sky130_fd_sc_hd__a221o_2
XFILLER_83_425 VGND VGND VPWR VPWR sky130_fd_sc_hd__decap_3
XFILLER_55_149 VGND VGND VPWR VPWR sky130_fd_sc_hd__decap_3
X_3025_ _2944_/X _3011_/B _3011_/Y _4948_/Q VGND VGND VPWR VPWR _4948_/D sky130_fd_sc_hd__a22o_2
XTAP_TAPCELL_ROW_87_1028 VGND VPWR sky130_fd_sc_hd__tapvpwrvgnd_1
XFILLER_36_341 VGND VGND VPWR VPWR sky130_fd_sc_hd__decap_3
XFILLER_48_190 VGND VGND VPWR VPWR sky130_fd_sc_hd__decap_3
XFILLER_36_385 VGND VGND VPWR VPWR sky130_fd_sc_hd__fill_2
XFILLER_51_300 VGND VGND VPWR VPWR sky130_fd_sc_hd__decap_3
XFILLER_70_119 VGND VGND VPWR VPWR sky130_fd_sc_hd__decap_3
XFILLER_34_29 VGND VGND VPWR VPWR sky130_fd_sc_hd__decap_3
XFILLER_51_333 VGND VGND VPWR VPWR sky130_fd_sc_hd__decap_3
XTAP_TAPCELL_ROW_34_520 VGND VPWR sky130_fd_sc_hd__tapvpwrvgnd_1
XFILLER_11_219 VGND VGND VPWR VPWR sky130_fd_sc_hd__decap_3
XFILLER_51_388 VGND VGND VPWR VPWR sky130_fd_sc_hd__decap_3
X_4976_ clkload4/A _4976_/D VGND VGND VPWR VPWR _4976_/Q sky130_fd_sc_hd__dfxtp_2
X_3927_ _3925_/X _3926_/X _4044_/S VGND VGND VPWR VPWR _3927_/X sky130_fd_sc_hd__mux2_1
Xclkload6 clkload6/A VGND VGND VPWR VPWR clkload6/X sky130_fd_sc_hd__clkbuf_4
X_3858_ _3856_/Y _3966_/B _3969_/S VGND VGND VPWR VPWR _4031_/B sky130_fd_sc_hd__mux2_1
X_3789_ _3840_/B _3676_/B _3715_/A _3787_/Y VGND VGND VPWR VPWR _3789_/X sky130_fd_sc_hd__o22a_2
X_2809_ _4961_/Q _4945_/Q _4929_/Q _4913_/Q _5135_/Q _5136_/Q VGND VGND VPWR VPWR
+ _2809_/X sky130_fd_sc_hd__mux4_2
XFILLER_59_411 VGND VGND VPWR VPWR sky130_fd_sc_hd__fill_1
XFILLER_78_219 VGND VGND VPWR VPWR sky130_fd_sc_hd__decap_3
XFILLER_59_455 VGND VGND VPWR VPWR sky130_fd_sc_hd__fill_1
XTAP_TAPCELL_ROW_6_256 VGND VPWR sky130_fd_sc_hd__tapvpwrvgnd_1
XFILLER_19_308 VGND VGND VPWR VPWR sky130_fd_sc_hd__fill_2
XFILLER_59_477 VGND VGND VPWR VPWR sky130_fd_sc_hd__decap_3
XFILLER_75_47 VGND VGND VPWR VPWR sky130_fd_sc_hd__decap_3
XFILLER_15_503 VGND VGND VPWR VPWR sky130_fd_sc_hd__fill_1
XFILLER_15_514 VGND VGND VPWR VPWR sky130_fd_sc_hd__decap_3
XFILLER_27_396 VGND VGND VPWR VPWR sky130_fd_sc_hd__decap_3
XFILLER_61_119 VGND VGND VPWR VPWR sky130_fd_sc_hd__decap_3
XFILLER_82_480 VGND VGND VPWR VPWR sky130_fd_sc_hd__decap_3
XFILLER_42_322 VGND VGND VPWR VPWR sky130_fd_sc_hd__decap_3
XFILLER_91_57 VGND VGND VPWR VPWR sky130_fd_sc_hd__fill_1
XFILLER_30_517 VGND VGND VPWR VPWR sky130_fd_sc_hd__decap_3
XFILLER_42_377 VGND VGND VPWR VPWR sky130_fd_sc_hd__decap_3
XFILLER_42_399 VGND VGND VPWR VPWR sky130_fd_sc_hd__decap_3
XTAP_TAPCELL_ROW_40_578 VGND VPWR sky130_fd_sc_hd__tapvpwrvgnd_1
XFILLER_41_9 VGND VGND VPWR VPWR sky130_fd_sc_hd__decap_3
XFILLER_65_414 VGND VGND VPWR VPWR sky130_fd_sc_hd__decap_3
XFILLER_1_33 VGND VGND VPWR VPWR sky130_fd_sc_hd__decap_3
XTAP_TAPCELL_ROW_76_921 VGND VPWR sky130_fd_sc_hd__tapvpwrvgnd_1
XFILLER_92_233 VGND VGND VPWR VPWR sky130_fd_sc_hd__fill_2
XFILLER_18_330 VGND VGND VPWR VPWR sky130_fd_sc_hd__decap_3
XFILLER_1_99 VGND VGND VPWR VPWR sky130_fd_sc_hd__decap_3
XFILLER_37_149 VGND VGND VPWR VPWR sky130_fd_sc_hd__decap_3
XTAP_TAPCELL_ROW_48_656 VGND VPWR sky130_fd_sc_hd__tapvpwrvgnd_1
XFILLER_73_491 VGND VGND VPWR VPWR sky130_fd_sc_hd__decap_3
X_4830_ _4821_/A _4822_/X _4829_/Y VGND VGND VPWR VPWR _4830_/Y sky130_fd_sc_hd__a21oi_2
XFILLER_33_377 VGND VGND VPWR VPWR sky130_fd_sc_hd__decap_3
XFILLER_60_185 VGND VGND VPWR VPWR sky130_fd_sc_hd__decap_3
X_4761_ _4758_/A _4758_/B _4756_/A VGND VGND VPWR VPWR _4761_/X sky130_fd_sc_hd__a21o_2
X_4692_ _4692_/A _4692_/B VGND VGND VPWR VPWR _5241_/D sky130_fd_sc_hd__nor2_2
X_3712_ _4397_/B _3713_/B VGND VGND VPWR VPWR _3714_/A sky130_fd_sc_hd__nor2_2
X_3643_ _4644_/S _4233_/B VGND VGND VPWR VPWR _4207_/A sky130_fd_sc_hd__nor2_2
X_3574_ _3571_/Y _3573_/X _3961_/S VGND VGND VPWR VPWR _3574_/X sky130_fd_sc_hd__mux2_1
X_2525_ _2677_/S _2522_/X _5130_/Q VGND VGND VPWR VPWR _2525_/X sky130_fd_sc_hd__o21a_2
XFILLER_88_506 VGND VGND VPWR VPWR sky130_fd_sc_hd__decap_3
X_5244_ _5253_/CLK _5244_/D VGND VGND VPWR VPWR _5244_/Q sky130_fd_sc_hd__dfxtp_2
X_2456_ _5187_/Q _5186_/Q _5185_/Q _5184_/Q VGND VGND VPWR VPWR _4847_/A sky130_fd_sc_hd__or4_2
XTAP_TAPCELL_ROW_93_1098 VGND VPWR sky130_fd_sc_hd__tapvpwrvgnd_1
XTAP_TAPCELL_ROW_93_1087 VGND VPWR sky130_fd_sc_hd__tapvpwrvgnd_1
X_5175_ _5263_/CLK _5175_/D VGND VGND VPWR VPWR _5175_/Q sky130_fd_sc_hd__dfxtp_2
XFILLER_68_274 VGND VGND VPWR VPWR sky130_fd_sc_hd__decap_3
X_4126_ _4126_/A _4174_/C _4126_/C _4144_/B VGND VGND VPWR VPWR _4138_/A sky130_fd_sc_hd__nand4_2
XTAP_TAPCELL_ROW_3_226 VGND VPWR sky130_fd_sc_hd__tapvpwrvgnd_1
XFILLER_28_127 VGND VGND VPWR VPWR sky130_fd_sc_hd__decap_3
XFILLER_28_149 VGND VGND VPWR VPWR sky130_fd_sc_hd__decap_3
X_4057_ _2629_/Y _4056_/X _4015_/B VGND VGND VPWR VPWR _4057_/Y sky130_fd_sc_hd__o21ai_2
XFILLER_83_255 VGND VGND VPWR VPWR sky130_fd_sc_hd__fill_1
XFILLER_43_119 VGND VGND VPWR VPWR sky130_fd_sc_hd__fill_1
XFILLER_71_439 VGND VGND VPWR VPWR sky130_fd_sc_hd__decap_3
X_3008_ _2947_/X _2993_/B _2993_/Y _4933_/Q VGND VGND VPWR VPWR _4933_/D sky130_fd_sc_hd__a22o_2
XFILLER_83_299 VGND VGND VPWR VPWR sky130_fd_sc_hd__decap_3
XTAP_TAPCELL_ROW_82_979 VGND VPWR sky130_fd_sc_hd__tapvpwrvgnd_1
XTAP_TAPCELL_ROW_19_380 VGND VPWR sky130_fd_sc_hd__tapvpwrvgnd_1
XFILLER_51_196 VGND VGND VPWR VPWR sky130_fd_sc_hd__decap_3
X_4959_ _5008_/CLK _4959_/D VGND VGND VPWR VPWR _4959_/Q sky130_fd_sc_hd__dfxtp_2
XFILLER_20_550 VGND VGND VPWR VPWR sky130_fd_sc_hd__decap_3
XFILLER_3_215 VGND VGND VPWR VPWR sky130_fd_sc_hd__fill_1
XFILLER_79_517 VGND VGND VPWR VPWR sky130_fd_sc_hd__decap_3
XFILLER_86_46 VGND VGND VPWR VPWR sky130_fd_sc_hd__decap_3
XFILLER_87_550 VGND VGND VPWR VPWR sky130_fd_sc_hd__decap_3
XFILLER_47_425 VGND VGND VPWR VPWR sky130_fd_sc_hd__decap_3
XFILLER_47_458 VGND VGND VPWR VPWR sky130_fd_sc_hd__decap_3
XFILLER_74_299 VGND VGND VPWR VPWR sky130_fd_sc_hd__fill_2
XTAP_TAPCELL_ROW_45_626 VGND VPWR sky130_fd_sc_hd__tapvpwrvgnd_1
XFILLER_55_491 VGND VGND VPWR VPWR sky130_fd_sc_hd__fill_1
XFILLER_70_472 VGND VGND VPWR VPWR sky130_fd_sc_hd__decap_3
XFILLER_7_532 VGND VGND VPWR VPWR sky130_fd_sc_hd__decap_3
X_3290_ _5268_/Q _3305_/B _3289_/Y _3338_/B VGND VGND VPWR VPWR _5147_/D sky130_fd_sc_hd__o211a_2
XPHY_EDGE_ROW_29_Left_123 VGND VGND VPWR VPWR sky130_fd_sc_hd__decap_3
XFILLER_18_3 VGND VGND VPWR VPWR sky130_fd_sc_hd__decap_3
XFILLER_38_436 VGND VGND VPWR VPWR sky130_fd_sc_hd__decap_3
XFILLER_93_520 VGND VGND VPWR VPWR sky130_fd_sc_hd__decap_3
XFILLER_53_406 VGND VGND VPWR VPWR sky130_fd_sc_hd__decap_3
XFILLER_93_542 VGND VGND VPWR VPWR sky130_fd_sc_hd__decap_3
XFILLER_80_214 VGND VGND VPWR VPWR sky130_fd_sc_hd__decap_3
XFILLER_33_141 VGND VGND VPWR VPWR sky130_fd_sc_hd__decap_3
XTAP_TAPCELL_ROW_16_350 VGND VPWR sky130_fd_sc_hd__tapvpwrvgnd_1
XPHY_EDGE_ROW_38_Left_132 VGND VGND VPWR VPWR sky130_fd_sc_hd__decap_3
X_4813_ _4854_/B _4811_/X _4812_/X _3338_/B VGND VGND VPWR VPWR _5269_/D sky130_fd_sc_hd__o211a_2
XFILLER_21_358 VGND VGND VPWR VPWR sky130_fd_sc_hd__decap_3
X_4744_ _5260_/Q _4847_/B _4743_/X _3338_/B VGND VGND VPWR VPWR _5260_/D sky130_fd_sc_hd__o211a_2
X_4675_ _4682_/S _4614_/X _4674_/Y _4437_/X VGND VGND VPWR VPWR _4675_/X sky130_fd_sc_hd__a211o_2
Xclkbuf_leaf_34_CLK clkbuf_leaf_5_CLK/A VGND VGND VPWR VPWR clkload7/A sky130_fd_sc_hd__clkbuf_8
X_3626_ _5124_/Q _5012_/Q _4996_/Q _4980_/Q _5131_/Q _5132_/Q VGND VGND VPWR VPWR
+ _3626_/X sky130_fd_sc_hd__mux4_2
X_3557_ _5156_/Q _4286_/B _3567_/S VGND VGND VPWR VPWR _3874_/S sky130_fd_sc_hd__mux2_1
XPHY_EDGE_ROW_47_Left_141 VGND VGND VPWR VPWR sky130_fd_sc_hd__decap_3
X_2508_ _4899_/Q _4883_/Q _5107_/Q _5091_/Q _2672_/S0 _2672_/S1 VGND VGND VPWR VPWR
+ _2508_/X sky130_fd_sc_hd__mux4_2
XFILLER_88_314 VGND VGND VPWR VPWR sky130_fd_sc_hd__decap_3
X_5227_ _5233_/CLK _5227_/D VGND VGND VPWR VPWR _5227_/Q sky130_fd_sc_hd__dfxtp_2
X_3488_ _5208_/Q _4854_/B _3458_/A _3487_/Y VGND VGND VPWR VPWR _3489_/B sky130_fd_sc_hd__o2bb2a_2
XFILLER_88_347 VGND VGND VPWR VPWR sky130_fd_sc_hd__decap_3
X_2439_ _5182_/Q _5181_/Q _3891_/A VGND VGND VPWR VPWR _4069_/A sky130_fd_sc_hd__or3_2
XFILLER_56_200 VGND VGND VPWR VPWR sky130_fd_sc_hd__decap_3
X_5158_ _5176_/CLK _5158_/D VGND VGND VPWR VPWR _5158_/Q sky130_fd_sc_hd__dfxtp_2
XFILLER_29_447 VGND VGND VPWR VPWR sky130_fd_sc_hd__fill_1
XFILLER_29_458 VGND VGND VPWR VPWR sky130_fd_sc_hd__fill_1
XFILLER_56_244 VGND VGND VPWR VPWR sky130_fd_sc_hd__decap_3
XFILLER_56_49 VGND VGND VPWR VPWR sky130_fd_sc_hd__decap_3
X_4109_ _3827_/X _3832_/X _3776_/B VGND VGND VPWR VPWR _4125_/B sky130_fd_sc_hd__a21oi_2
X_5089_ _5105_/CLK _5089_/D VGND VGND VPWR VPWR _5089_/Q sky130_fd_sc_hd__dfxtp_2
XFILLER_84_542 VGND VGND VPWR VPWR sky130_fd_sc_hd__fill_1
XFILLER_16_119 VGND VGND VPWR VPWR sky130_fd_sc_hd__decap_3
XFILLER_56_277 VGND VGND VPWR VPWR sky130_fd_sc_hd__decap_3
XFILLER_71_203 VGND VGND VPWR VPWR sky130_fd_sc_hd__decap_3
XFILLER_71_214 VGND VGND VPWR VPWR sky130_fd_sc_hd__decap_3
XFILLER_37_491 VGND VGND VPWR VPWR sky130_fd_sc_hd__decap_3
XFILLER_71_225 VGND VGND VPWR VPWR sky130_fd_sc_hd__decap_3
XFILLER_71_247 VGND VGND VPWR VPWR sky130_fd_sc_hd__decap_3
XPHY_EDGE_ROW_56_Left_150 VGND VGND VPWR VPWR sky130_fd_sc_hd__decap_3
XFILLER_12_303 VGND VGND VPWR VPWR sky130_fd_sc_hd__decap_3
XFILLER_52_450 VGND VGND VPWR VPWR sky130_fd_sc_hd__fill_2
XFILLER_52_494 VGND VGND VPWR VPWR sky130_fd_sc_hd__decap_3
XTAP_TAPCELL_ROW_50_673 VGND VPWR sky130_fd_sc_hd__tapvpwrvgnd_1
XFILLER_4_524 VGND VGND VPWR VPWR sky130_fd_sc_hd__decap_3
Xclkbuf_leaf_25_CLK clkload0/A VGND VGND VPWR VPWR _5083_/CLK sky130_fd_sc_hd__clkbuf_8
XFILLER_4_557 VGND VGND VPWR VPWR sky130_fd_sc_hd__fill_1
XFILLER_79_358 VGND VGND VPWR VPWR sky130_fd_sc_hd__decap_3
XTAP_TAPCELL_ROW_58_751 VGND VPWR sky130_fd_sc_hd__tapvpwrvgnd_1
XFILLER_75_553 VGND VGND VPWR VPWR sky130_fd_sc_hd__decap_3
XFILLER_62_203 VGND VGND VPWR VPWR sky130_fd_sc_hd__decap_3
XFILLER_62_236 VGND VGND VPWR VPWR sky130_fd_sc_hd__decap_3
XFILLER_62_269 VGND VGND VPWR VPWR sky130_fd_sc_hd__decap_3
XFILLER_30_100 VGND VGND VPWR VPWR sky130_fd_sc_hd__decap_3
XFILLER_43_494 VGND VGND VPWR VPWR sky130_fd_sc_hd__decap_3
XFILLER_30_144 VGND VGND VPWR VPWR sky130_fd_sc_hd__decap_3
XFILLER_87_6 VGND VGND VPWR VPWR sky130_fd_sc_hd__decap_3
X_2790_ _5137_/Q _2790_/B VGND VGND VPWR VPWR _2790_/X sky130_fd_sc_hd__or2_2
X_4460_ _4460_/A _4460_/B VGND VGND VPWR VPWR _4462_/C sky130_fd_sc_hd__xnor2_2
Xclkbuf_leaf_16_CLK clkload2/A VGND VGND VPWR VPWR _5253_/CLK sky130_fd_sc_hd__clkbuf_8
XFILLER_7_65 VGND VGND VPWR VPWR sky130_fd_sc_hd__decap_3
XFILLER_7_373 VGND VGND VPWR VPWR sky130_fd_sc_hd__decap_3
X_4391_ _4356_/A _4322_/B _4390_/C VGND VGND VPWR VPWR _4391_/Y sky130_fd_sc_hd__o21ai_2
X_3411_ _3408_/A _3408_/B _3406_/A VGND VGND VPWR VPWR _3416_/A sky130_fd_sc_hd__a21o_2
XFILLER_7_98 VGND VGND VPWR VPWR sky130_fd_sc_hd__decap_3
X_3342_ _5283_/Q _3366_/A _3342_/C VGND VGND VPWR VPWR _3342_/X sky130_fd_sc_hd__and3_2
XTAP_TAPCELL_ROW_90_1057 VGND VPWR sky130_fd_sc_hd__tapvpwrvgnd_1
X_3273_ _5142_/Q _3270_/B _5143_/Q VGND VGND VPWR VPWR _3273_/Y sky130_fd_sc_hd__a21oi_2
XFILLER_38_200 VGND VGND VPWR VPWR sky130_fd_sc_hd__fill_2
XFILLER_66_520 VGND VGND VPWR VPWR sky130_fd_sc_hd__decap_3
X_5012_ _5177_/CLK _5012_/D VGND VGND VPWR VPWR _5012_/Q sky130_fd_sc_hd__dfxtp_2
XFILLER_78_380 VGND VGND VPWR VPWR sky130_fd_sc_hd__fill_2
XFILLER_66_542 VGND VGND VPWR VPWR sky130_fd_sc_hd__fill_2
XFILLER_66_553 VGND VGND VPWR VPWR sky130_fd_sc_hd__decap_3
XFILLER_93_361 VGND VGND VPWR VPWR sky130_fd_sc_hd__decap_3
XFILLER_81_523 VGND VGND VPWR VPWR sky130_fd_sc_hd__decap_3
XFILLER_81_501 VGND VGND VPWR VPWR sky130_fd_sc_hd__decap_3
XFILLER_81_556 VGND VGND VPWR VPWR sky130_fd_sc_hd__fill_2
XFILLER_21_100 VGND VGND VPWR VPWR sky130_fd_sc_hd__decap_3
XFILLER_34_472 VGND VGND VPWR VPWR sky130_fd_sc_hd__decap_3
XFILLER_21_133 VGND VGND VPWR VPWR sky130_fd_sc_hd__decap_3
XFILLER_42_29 VGND VGND VPWR VPWR sky130_fd_sc_hd__decap_3
XFILLER_21_155 VGND VGND VPWR VPWR sky130_fd_sc_hd__decap_3
X_2988_ _2944_/X _2974_/B _2974_/Y _4916_/Q VGND VGND VPWR VPWR _4916_/D sky130_fd_sc_hd__a22o_2
X_4727_ _5156_/Q _4728_/B VGND VGND VPWR VPWR _4734_/A sky130_fd_sc_hd__and2_2
X_4658_ _4168_/A _3631_/A _3778_/D _2693_/B VGND VGND VPWR VPWR _4661_/B sky130_fd_sc_hd__o2bb2a_2
X_3609_ _5115_/Q _5003_/Q _4987_/Q _4971_/Q _3732_/S0 _3732_/S1 VGND VGND VPWR VPWR
+ _3609_/X sky130_fd_sc_hd__mux4_2
XFILLER_1_505 VGND VGND VPWR VPWR sky130_fd_sc_hd__decap_3
X_4589_ _4588_/X _4534_/X _4682_/S VGND VGND VPWR VPWR _4589_/X sky130_fd_sc_hd__mux2_1
XFILLER_1_538 VGND VGND VPWR VPWR sky130_fd_sc_hd__decap_3
XFILLER_88_111 VGND VGND VPWR VPWR sky130_fd_sc_hd__decap_3
XFILLER_69_380 VGND VGND VPWR VPWR sky130_fd_sc_hd__decap_3
XFILLER_57_553 VGND VGND VPWR VPWR sky130_fd_sc_hd__decap_3
XFILLER_72_501 VGND VGND VPWR VPWR sky130_fd_sc_hd__decap_3
XFILLER_83_25 VGND VGND VPWR VPWR sky130_fd_sc_hd__decap_3
XFILLER_17_439 VGND VGND VPWR VPWR sky130_fd_sc_hd__decap_3
XFILLER_44_225 VGND VGND VPWR VPWR sky130_fd_sc_hd__decap_3
XFILLER_72_545 VGND VGND VPWR VPWR sky130_fd_sc_hd__decap_3
XTAP_TAPCELL_ROW_55_721 VGND VPWR sky130_fd_sc_hd__tapvpwrvgnd_1
XFILLER_25_461 VGND VGND VPWR VPWR sky130_fd_sc_hd__decap_3
XTAP_TAPCELL_ROW_27_456 VGND VPWR sky130_fd_sc_hd__tapvpwrvgnd_1
XFILLER_12_100 VGND VGND VPWR VPWR sky130_fd_sc_hd__decap_3
XFILLER_16_85 VGND VGND VPWR VPWR sky130_fd_sc_hd__fill_1
XPHY_EDGE_ROW_11_Right_11 VGND VGND VPWR VPWR sky130_fd_sc_hd__decap_3
XFILLER_12_144 VGND VGND VPWR VPWR sky130_fd_sc_hd__decap_3
XFILLER_40_453 VGND VGND VPWR VPWR sky130_fd_sc_hd__decap_3
XFILLER_40_486 VGND VGND VPWR VPWR sky130_fd_sc_hd__decap_3
XFILLER_8_115 VGND VGND VPWR VPWR sky130_fd_sc_hd__decap_3
XFILLER_32_62 VGND VGND VPWR VPWR sky130_fd_sc_hd__decap_3
XTAP_TAPCELL_ROW_10_301 VGND VPWR sky130_fd_sc_hd__tapvpwrvgnd_1
XPHY_EDGE_ROW_20_Right_20 VGND VGND VPWR VPWR sky130_fd_sc_hd__decap_3
XFILLER_79_111 VGND VGND VPWR VPWR sky130_fd_sc_hd__fill_1
XFILLER_79_199 VGND VGND VPWR VPWR sky130_fd_sc_hd__decap_3
XFILLER_79_177 VGND VGND VPWR VPWR sky130_fd_sc_hd__decap_3
XFILLER_48_542 VGND VGND VPWR VPWR sky130_fd_sc_hd__decap_3
XFILLER_57_92 VGND VGND VPWR VPWR sky130_fd_sc_hd__fill_2
XFILLER_63_501 VGND VGND VPWR VPWR sky130_fd_sc_hd__decap_3
XFILLER_63_534 VGND VGND VPWR VPWR sky130_fd_sc_hd__decap_3
XFILLER_63_556 VGND VGND VPWR VPWR sky130_fd_sc_hd__fill_2
Xclkbuf_leaf_5_CLK clkbuf_leaf_5_CLK/A VGND VGND VPWR VPWR clkload6/A sky130_fd_sc_hd__clkbuf_8
XFILLER_90_320 VGND VGND VPWR VPWR sky130_fd_sc_hd__decap_3
XFILLER_35_258 VGND VGND VPWR VPWR sky130_fd_sc_hd__decap_3
XFILLER_50_206 VGND VGND VPWR VPWR sky130_fd_sc_hd__decap_3
X_3960_ _4378_/A _4071_/A VGND VGND VPWR VPWR _3960_/Y sky130_fd_sc_hd__nand2_2
XFILLER_90_353 VGND VGND VPWR VPWR sky130_fd_sc_hd__decap_3
XFILLER_16_461 VGND VGND VPWR VPWR sky130_fd_sc_hd__fill_1
XFILLER_16_483 VGND VGND VPWR VPWR sky130_fd_sc_hd__fill_1
X_2911_ _5277_/Q _5245_/Q _5229_/Q _4854_/A _2910_/X VGND VGND VPWR VPWR _2911_/X
+ sky130_fd_sc_hd__a221o_2
XFILLER_43_291 VGND VGND VPWR VPWR sky130_fd_sc_hd__decap_3
X_3891_ _3891_/A _3891_/B VGND VGND VPWR VPWR _4021_/B sky130_fd_sc_hd__or2_2
XTAP_TAPCELL_ROW_61_779 VGND VPWR sky130_fd_sc_hd__tapvpwrvgnd_1
X_2842_ _2840_/X _2841_/X _2855_/S VGND VGND VPWR VPWR _2842_/X sky130_fd_sc_hd__mux2_1
XFILLER_85_3 VGND VGND VPWR VPWR sky130_fd_sc_hd__decap_3
X_2773_ _4957_/Q _4941_/Q _4925_/Q _4909_/Q _2818_/S0 _5136_/Q VGND VGND VPWR VPWR
+ _2773_/X sky130_fd_sc_hd__mux4_2
X_4512_ _4444_/B _4439_/Y _4515_/B VGND VGND VPWR VPWR _4512_/X sky130_fd_sc_hd__mux2_1
XFILLER_7_181 VGND VGND VPWR VPWR sky130_fd_sc_hd__decap_3
X_4443_ _3867_/A _4449_/S _3879_/Y VGND VGND VPWR VPWR _4445_/B sky130_fd_sc_hd__a21oi_2
X_4374_ _4393_/A _4373_/X _4397_/B VGND VGND VPWR VPWR _4374_/X sky130_fd_sc_hd__o21ba_2
X_3325_ _5160_/Q _4868_/A2 _4870_/B1 _3324_/X VGND VGND VPWR VPWR _5160_/D sky130_fd_sc_hd__o22a_2
XFILLER_58_317 VGND VGND VPWR VPWR sky130_fd_sc_hd__decap_3
X_3256_ _5189_/Q _3311_/S VGND VGND VPWR VPWR _3315_/B sky130_fd_sc_hd__and2_2
XTAP_TAPCELL_ROW_69_857 VGND VPWR sky130_fd_sc_hd__tapvpwrvgnd_1
XFILLER_26_203 VGND VGND VPWR VPWR sky130_fd_sc_hd__decap_3
XFILLER_54_512 VGND VGND VPWR VPWR sky130_fd_sc_hd__decap_3
XFILLER_66_350 VGND VGND VPWR VPWR sky130_fd_sc_hd__decap_3
XFILLER_73_309 VGND VGND VPWR VPWR sky130_fd_sc_hd__fill_1
X_3187_ _2937_/X _3191_/A2 _3175_/Y _5090_/Q VGND VGND VPWR VPWR _5090_/D sky130_fd_sc_hd__a22o_2
XFILLER_66_394 VGND VGND VPWR VPWR sky130_fd_sc_hd__decap_3
XFILLER_81_364 VGND VGND VPWR VPWR sky130_fd_sc_hd__decap_3
XTAP_TAPCELL_ROW_24_426 VGND VPWR sky130_fd_sc_hd__tapvpwrvgnd_1
XFILLER_34_291 VGND VGND VPWR VPWR sky130_fd_sc_hd__decap_3
XFILLER_22_475 VGND VGND VPWR VPWR sky130_fd_sc_hd__fill_1
XFILLER_22_486 VGND VGND VPWR VPWR sky130_fd_sc_hd__decap_3
XFILLER_78_47 VGND VGND VPWR VPWR sky130_fd_sc_hd__decap_3
XFILLER_89_497 VGND VGND VPWR VPWR sky130_fd_sc_hd__decap_3
XFILLER_76_103 VGND VGND VPWR VPWR sky130_fd_sc_hd__decap_3
XFILLER_64_309 VGND VGND VPWR VPWR sky130_fd_sc_hd__decap_3
XFILLER_17_225 VGND VGND VPWR VPWR sky130_fd_sc_hd__decap_3
XFILLER_45_534 VGND VGND VPWR VPWR sky130_fd_sc_hd__decap_3
XFILLER_72_342 VGND VGND VPWR VPWR sky130_fd_sc_hd__decap_3
XFILLER_32_239 VGND VGND VPWR VPWR sky130_fd_sc_hd__fill_1
XFILLER_60_526 VGND VGND VPWR VPWR sky130_fd_sc_hd__decap_3
XFILLER_13_431 VGND VGND VPWR VPWR sky130_fd_sc_hd__decap_3
XFILLER_13_486 VGND VGND VPWR VPWR sky130_fd_sc_hd__decap_3
XFILLER_9_413 VGND VGND VPWR VPWR sky130_fd_sc_hd__decap_3
XFILLER_9_446 VGND VGND VPWR VPWR sky130_fd_sc_hd__fill_2
XFILLER_4_22 VGND VGND VPWR VPWR sky130_fd_sc_hd__decap_3
XFILLER_4_88 VGND VGND VPWR VPWR sky130_fd_sc_hd__decap_3
X_3110_ _2921_/X _3119_/A2 _3103_/Y _5021_/Q VGND VGND VPWR VPWR _5021_/D sky130_fd_sc_hd__a22o_2
XFILLER_67_125 VGND VGND VPWR VPWR sky130_fd_sc_hd__decap_3
XFILLER_67_158 VGND VGND VPWR VPWR sky130_fd_sc_hd__decap_3
XFILLER_68_91 VGND VGND VPWR VPWR sky130_fd_sc_hd__fill_1
X_4090_ _4090_/A _4090_/B VGND VGND VPWR VPWR _4090_/Y sky130_fd_sc_hd__xnor2_2
XFILLER_36_501 VGND VGND VPWR VPWR sky130_fd_sc_hd__fill_2
XFILLER_48_361 VGND VGND VPWR VPWR sky130_fd_sc_hd__decap_3
XFILLER_67_169 VGND VGND VPWR VPWR sky130_fd_sc_hd__fill_1
X_3041_ _2937_/X _3029_/B _3029_/Y _4962_/Q VGND VGND VPWR VPWR _4962_/D sky130_fd_sc_hd__a22o_2
XTAP_TAPCELL_ROW_66_827 VGND VPWR sky130_fd_sc_hd__tapvpwrvgnd_1
XFILLER_82_139 VGND VGND VPWR VPWR sky130_fd_sc_hd__fill_1
XFILLER_63_353 VGND VGND VPWR VPWR sky130_fd_sc_hd__decap_3
X_4992_ clkload4/A _4992_/D VGND VGND VPWR VPWR _4992_/Q sky130_fd_sc_hd__dfxtp_2
X_3943_ _3943_/A _3943_/B VGND VGND VPWR VPWR _3947_/D sky130_fd_sc_hd__nand2_2
XFILLER_90_194 VGND VGND VPWR VPWR sky130_fd_sc_hd__fill_2
X_3874_ _4397_/C _4376_/B _3874_/S VGND VGND VPWR VPWR _3874_/X sky130_fd_sc_hd__mux2_1
X_2825_ _5123_/Q _5011_/Q _4995_/Q _4979_/Q _2854_/S0 _2854_/S1 VGND VGND VPWR VPWR
+ _2826_/B sky130_fd_sc_hd__mux4_2
X_2756_ _2832_/A _2755_/X _2435_/Y VGND VGND VPWR VPWR _2756_/X sky130_fd_sc_hd__o21a_2
X_2687_ _4145_/A _2686_/A _2670_/A _2683_/A VGND VGND VPWR VPWR _2688_/B sky130_fd_sc_hd__o211ai_2
X_4426_ _4426_/A _4595_/B VGND VGND VPWR VPWR _4427_/A sky130_fd_sc_hd__nor2_2
X_4357_ _4357_/A _4357_/B VGND VGND VPWR VPWR _4390_/C sky130_fd_sc_hd__nand2_2
XFILLER_86_401 VGND VGND VPWR VPWR sky130_fd_sc_hd__decap_3
XFILLER_58_125 VGND VGND VPWR VPWR sky130_fd_sc_hd__decap_3
X_4288_ _4732_/A _5156_/Q VGND VGND VPWR VPWR _4288_/X sky130_fd_sc_hd__xor2_2
X_3308_ _5145_/Q _3308_/B _3308_/C VGND VGND VPWR VPWR _3309_/B sky130_fd_sc_hd__and3_2
XFILLER_39_361 VGND VGND VPWR VPWR sky130_fd_sc_hd__decap_3
XFILLER_46_309 VGND VGND VPWR VPWR sky130_fd_sc_hd__decap_3
X_3239_ _5283_/Q _3338_/B input4/X VGND VGND VPWR VPWR _3239_/X sky130_fd_sc_hd__and3_2
XFILLER_27_523 VGND VGND VPWR VPWR sky130_fd_sc_hd__decap_3
XFILLER_54_320 VGND VGND VPWR VPWR sky130_fd_sc_hd__decap_3
XFILLER_54_342 VGND VGND VPWR VPWR sky130_fd_sc_hd__decap_3
XTAP_TAPCELL_ROW_37_551 VGND VPWR sky130_fd_sc_hd__tapvpwrvgnd_1
XFILLER_14_217 VGND VGND VPWR VPWR sky130_fd_sc_hd__decap_3
XFILLER_42_515 VGND VGND VPWR VPWR sky130_fd_sc_hd__decap_3
XFILLER_54_386 VGND VGND VPWR VPWR sky130_fd_sc_hd__decap_3
XFILLER_81_150 VGND VGND VPWR VPWR sky130_fd_sc_hd__decap_3
XFILLER_10_489 VGND VGND VPWR VPWR sky130_fd_sc_hd__decap_3
XFILLER_89_57 VGND VGND VPWR VPWR sky130_fd_sc_hd__decap_3
XFILLER_89_46 VGND VGND VPWR VPWR sky130_fd_sc_hd__decap_3
XFILLER_1_165 VGND VGND VPWR VPWR sky130_fd_sc_hd__decap_3
XTAP_TAPCELL_ROW_9_287 VGND VPWR sky130_fd_sc_hd__tapvpwrvgnd_1
XFILLER_77_401 VGND VGND VPWR VPWR sky130_fd_sc_hd__decap_3
XFILLER_49_136 VGND VGND VPWR VPWR sky130_fd_sc_hd__decap_3
XFILLER_77_434 VGND VGND VPWR VPWR sky130_fd_sc_hd__decap_3
XFILLER_38_61 VGND VGND VPWR VPWR sky130_fd_sc_hd__decap_3
XFILLER_49_169 VGND VGND VPWR VPWR sky130_fd_sc_hd__decap_3
XFILLER_64_106 VGND VGND VPWR VPWR sky130_fd_sc_hd__decap_3
XFILLER_92_404 VGND VGND VPWR VPWR sky130_fd_sc_hd__decap_3
XFILLER_92_437 VGND VGND VPWR VPWR sky130_fd_sc_hd__decap_3
XFILLER_72_161 VGND VGND VPWR VPWR sky130_fd_sc_hd__fill_1
XFILLER_54_93 VGND VGND VPWR VPWR sky130_fd_sc_hd__fill_2
XFILLER_20_209 VGND VGND VPWR VPWR sky130_fd_sc_hd__decap_3
XTAP_TAPCELL_ROW_71_874 VGND VPWR sky130_fd_sc_hd__tapvpwrvgnd_1
XFILLER_70_81 VGND VGND VPWR VPWR sky130_fd_sc_hd__decap_3
Xclkload24 _5176_/CLK VGND VGND VPWR VPWR clkload24/X sky130_fd_sc_hd__clkbuf_4
Xclkload13 _5105_/CLK VGND VGND VPWR VPWR clkload13/Y sky130_fd_sc_hd__clkinv_2
X_3590_ _3884_/D _3590_/B VGND VGND VPWR VPWR _3747_/A sky130_fd_sc_hd__or2_2
X_2610_ _2604_/X _2606_/X _2609_/X _2433_/Y VGND VGND VPWR VPWR _4390_/B sky130_fd_sc_hd__a22oi_2
X_2541_ _3600_/A VGND VGND VPWR VPWR _4079_/A sky130_fd_sc_hd__inv_2
X_5260_ _5260_/CLK _5260_/D VGND VGND VPWR VPWR _5260_/Q sky130_fd_sc_hd__dfxtp_2
X_2472_ _2660_/A _2471_/X _5130_/Q VGND VGND VPWR VPWR _2472_/X sky130_fd_sc_hd__o21a_2
XPHY_EDGE_ROW_10_Left_104 VGND VGND VPWR VPWR sky130_fd_sc_hd__decap_3
X_4211_ _4207_/A _4207_/B _4233_/B VGND VGND VPWR VPWR _4212_/B sky130_fd_sc_hd__a21oi_2
XFILLER_68_401 VGND VGND VPWR VPWR sky130_fd_sc_hd__decap_3
X_5191_ _5216_/CLK _5191_/D VGND VGND VPWR VPWR _5191_/Q sky130_fd_sc_hd__dfxtp_2
X_4142_ _4200_/B _4142_/B VGND VGND VPWR VPWR _4169_/D sky130_fd_sc_hd__nand2_2
XTAP_TAPCELL_ROW_79_952 VGND VPWR sky130_fd_sc_hd__tapvpwrvgnd_1
XFILLER_68_467 VGND VGND VPWR VPWR sky130_fd_sc_hd__decap_3
XFILLER_68_489 VGND VGND VPWR VPWR sky130_fd_sc_hd__decap_3
X_4073_ _4434_/A _3726_/A _2531_/Y _3764_/X VGND VGND VPWR VPWR _4073_/X sky130_fd_sc_hd__a2bb2o_2
XFILLER_55_128 VGND VGND VPWR VPWR sky130_fd_sc_hd__decap_3
X_3024_ _2941_/X _3011_/B _3011_/Y _4947_/Q VGND VGND VPWR VPWR _4947_/D sky130_fd_sc_hd__a22o_2
XTAP_TAPCELL_ROW_87_1029 VGND VPWR sky130_fd_sc_hd__tapvpwrvgnd_1
XFILLER_36_331 VGND VGND VPWR VPWR sky130_fd_sc_hd__fill_2
XFILLER_83_459 VGND VGND VPWR VPWR sky130_fd_sc_hd__decap_3
XFILLER_51_312 VGND VGND VPWR VPWR sky130_fd_sc_hd__decap_3
XFILLER_63_161 VGND VGND VPWR VPWR sky130_fd_sc_hd__fill_2
XFILLER_36_397 VGND VGND VPWR VPWR sky130_fd_sc_hd__decap_3
X_4975_ clkload4/A _4975_/D VGND VGND VPWR VPWR _4975_/Q sky130_fd_sc_hd__dfxtp_2
XTAP_TAPCELL_ROW_34_521 VGND VPWR sky130_fd_sc_hd__tapvpwrvgnd_1
XFILLER_91_492 VGND VGND VPWR VPWR sky130_fd_sc_hd__decap_3
XFILLER_51_367 VGND VGND VPWR VPWR sky130_fd_sc_hd__decap_3
X_3926_ _3578_/X _3580_/X _3961_/S VGND VGND VPWR VPWR _3926_/X sky130_fd_sc_hd__mux2_1
XFILLER_50_29 VGND VGND VPWR VPWR sky130_fd_sc_hd__decap_3
Xclkload7 clkload7/A VGND VGND VPWR VPWR clkload7/X sky130_fd_sc_hd__clkbuf_4
X_3857_ _4378_/A _3866_/B VGND VGND VPWR VPWR _3966_/B sky130_fd_sc_hd__or2_2
X_3788_ _4397_/D _3788_/B VGND VGND VPWR VPWR _4169_/B sky130_fd_sc_hd__nand2_2
X_2808_ _5137_/Q _2808_/B VGND VGND VPWR VPWR _2808_/X sky130_fd_sc_hd__or2_2
X_2739_ _5138_/Q _2734_/X _2736_/X _2738_/X VGND VGND VPWR VPWR _4738_/B sky130_fd_sc_hd__a22o_2
XFILLER_1_9 VGND VGND VPWR VPWR sky130_fd_sc_hd__decap_3
XFILLER_59_49 VGND VGND VPWR VPWR sky130_fd_sc_hd__decap_3
X_4409_ _4410_/A _4410_/B VGND VGND VPWR VPWR _4468_/A sky130_fd_sc_hd__and2_2
XTAP_TAPCELL_ROW_6_257 VGND VPWR sky130_fd_sc_hd__tapvpwrvgnd_1
XFILLER_59_489 VGND VGND VPWR VPWR sky130_fd_sc_hd__decap_3
XFILLER_74_404 VGND VGND VPWR VPWR sky130_fd_sc_hd__decap_3
XFILLER_86_275 VGND VGND VPWR VPWR sky130_fd_sc_hd__fill_1
XFILLER_86_264 VGND VGND VPWR VPWR sky130_fd_sc_hd__decap_3
XFILLER_86_253 VGND VGND VPWR VPWR sky130_fd_sc_hd__decap_3
XFILLER_74_448 VGND VGND VPWR VPWR sky130_fd_sc_hd__decap_3
XFILLER_27_331 VGND VGND VPWR VPWR sky130_fd_sc_hd__decap_3
XFILLER_15_526 VGND VGND VPWR VPWR sky130_fd_sc_hd__decap_3
XFILLER_54_161 VGND VGND VPWR VPWR sky130_fd_sc_hd__decap_3
XFILLER_82_470 VGND VGND VPWR VPWR sky130_fd_sc_hd__decap_3
XFILLER_15_548 VGND VGND VPWR VPWR sky130_fd_sc_hd__decap_3
XFILLER_54_183 VGND VGND VPWR VPWR sky130_fd_sc_hd__decap_3
XFILLER_82_492 VGND VGND VPWR VPWR sky130_fd_sc_hd__decap_3
XFILLER_42_356 VGND VGND VPWR VPWR sky130_fd_sc_hd__decap_3
XFILLER_24_85 VGND VGND VPWR VPWR sky130_fd_sc_hd__decap_3
XFILLER_10_253 VGND VGND VPWR VPWR sky130_fd_sc_hd__decap_3
XFILLER_24_96 VGND VGND VPWR VPWR sky130_fd_sc_hd__decap_3
XFILLER_6_213 VGND VGND VPWR VPWR sky130_fd_sc_hd__decap_3
XTAP_TAPCELL_ROW_40_579 VGND VPWR sky130_fd_sc_hd__tapvpwrvgnd_1
XFILLER_34_9 VGND VGND VPWR VPWR sky130_fd_sc_hd__fill_2
XFILLER_49_71 VGND VGND VPWR VPWR sky130_fd_sc_hd__decap_3
XFILLER_77_231 VGND VGND VPWR VPWR sky130_fd_sc_hd__decap_3
XFILLER_77_220 VGND VGND VPWR VPWR sky130_fd_sc_hd__decap_3
XFILLER_1_12 VGND VGND VPWR VPWR sky130_fd_sc_hd__decap_3
XFILLER_37_128 VGND VGND VPWR VPWR sky130_fd_sc_hd__decap_3
XTAP_TAPCELL_ROW_76_922 VGND VPWR sky130_fd_sc_hd__tapvpwrvgnd_1
XFILLER_77_297 VGND VGND VPWR VPWR sky130_fd_sc_hd__fill_2
XFILLER_18_342 VGND VGND VPWR VPWR sky130_fd_sc_hd__decap_3
XTAP_TAPCELL_ROW_48_657 VGND VPWR sky130_fd_sc_hd__tapvpwrvgnd_1
XFILLER_80_407 VGND VGND VPWR VPWR sky130_fd_sc_hd__fill_2
XFILLER_52_109 VGND VGND VPWR VPWR sky130_fd_sc_hd__decap_3
XFILLER_73_481 VGND VGND VPWR VPWR sky130_fd_sc_hd__fill_1
XFILLER_92_289 VGND VGND VPWR VPWR sky130_fd_sc_hd__decap_3
XFILLER_80_429 VGND VGND VPWR VPWR sky130_fd_sc_hd__decap_3
XFILLER_80_418 VGND VGND VPWR VPWR sky130_fd_sc_hd__fill_2
X_4760_ _4854_/B _4758_/X _4759_/X _3338_/B VGND VGND VPWR VPWR _5262_/D sky130_fd_sc_hd__o211a_2
X_4691_ _5241_/Q _4854_/B _4541_/X _4690_/X VGND VGND VPWR VPWR _4692_/B sky130_fd_sc_hd__o2bb2a_2
X_3711_ _3705_/X _3707_/X _3710_/X _2430_/Y VGND VGND VPWR VPWR _3713_/B sky130_fd_sc_hd__a22o_2
XFILLER_81_91 VGND VGND VPWR VPWR sky130_fd_sc_hd__decap_3
X_3642_ _3642_/A _3809_/B VGND VGND VPWR VPWR _4233_/B sky130_fd_sc_hd__and2_2
X_3573_ _4346_/B _3905_/B _3572_/Y VGND VGND VPWR VPWR _3573_/X sky130_fd_sc_hd__o21a_2
XPHY_EDGE_ROW_49_Right_49 VGND VGND VPWR VPWR sky130_fd_sc_hd__decap_3
X_2524_ _5129_/Q _2524_/B VGND VGND VPWR VPWR _2524_/X sky130_fd_sc_hd__or2_2
X_5243_ _5254_/CLK _5243_/D VGND VGND VPWR VPWR _5243_/Q sky130_fd_sc_hd__dfxtp_2
X_2455_ _5184_/Q _3357_/B VGND VGND VPWR VPWR _2455_/X sky130_fd_sc_hd__and2b_2
XTAP_TAPCELL_ROW_93_1099 VGND VPWR sky130_fd_sc_hd__tapvpwrvgnd_1
XTAP_TAPCELL_ROW_93_1088 VGND VPWR sky130_fd_sc_hd__tapvpwrvgnd_1
X_5174_ _5263_/CLK _5174_/D VGND VGND VPWR VPWR _5174_/Q sky130_fd_sc_hd__dfxtp_2
XFILLER_56_404 VGND VGND VPWR VPWR sky130_fd_sc_hd__decap_3
XFILLER_68_253 VGND VGND VPWR VPWR sky130_fd_sc_hd__decap_3
X_4125_ _4125_/A _4125_/B VGND VGND VPWR VPWR _4144_/B sky130_fd_sc_hd__nand2_2
XFILLER_28_106 VGND VGND VPWR VPWR sky130_fd_sc_hd__decap_3
XFILLER_56_437 VGND VGND VPWR VPWR sky130_fd_sc_hd__decap_3
XFILLER_68_286 VGND VGND VPWR VPWR sky130_fd_sc_hd__fill_1
XTAP_TAPCELL_ROW_3_227 VGND VPWR sky130_fd_sc_hd__tapvpwrvgnd_1
XFILLER_83_223 VGND VGND VPWR VPWR sky130_fd_sc_hd__fill_1
XFILLER_83_201 VGND VGND VPWR VPWR sky130_fd_sc_hd__decap_3
XFILLER_45_29 VGND VGND VPWR VPWR sky130_fd_sc_hd__fill_2
X_4056_ _4015_/A _3986_/Y _3830_/X VGND VGND VPWR VPWR _4056_/X sky130_fd_sc_hd__a21o_2
XPHY_EDGE_ROW_58_Right_58 VGND VGND VPWR VPWR sky130_fd_sc_hd__decap_3
XFILLER_83_234 VGND VGND VPWR VPWR sky130_fd_sc_hd__decap_3
XFILLER_24_301 VGND VGND VPWR VPWR sky130_fd_sc_hd__decap_3
XFILLER_64_470 VGND VGND VPWR VPWR sky130_fd_sc_hd__decap_3
X_3007_ _2944_/X _2993_/B _2993_/Y _4932_/Q VGND VGND VPWR VPWR _4932_/D sky130_fd_sc_hd__a22o_2
XTAP_TAPCELL_ROW_19_381 VGND VPWR sky130_fd_sc_hd__tapvpwrvgnd_1
XFILLER_61_39 VGND VGND VPWR VPWR sky130_fd_sc_hd__decap_3
X_4958_ _5118_/CLK _4958_/D VGND VGND VPWR VPWR _4958_/Q sky130_fd_sc_hd__dfxtp_2
X_4889_ _5083_/CLK _4889_/D VGND VGND VPWR VPWR _4889_/Q sky130_fd_sc_hd__dfxtp_2
X_3909_ _4021_/B _3892_/Y _3898_/X _3908_/X VGND VGND VPWR VPWR _3909_/X sky130_fd_sc_hd__o211a_2
XPHY_EDGE_ROW_67_Right_67 VGND VGND VPWR VPWR sky130_fd_sc_hd__decap_3
XFILLER_19_74 VGND VGND VPWR VPWR sky130_fd_sc_hd__decap_3
XFILLER_47_437 VGND VGND VPWR VPWR sky130_fd_sc_hd__decap_3
XFILLER_59_297 VGND VGND VPWR VPWR sky130_fd_sc_hd__decap_3
XPHY_EDGE_ROW_76_Right_76 VGND VGND VPWR VPWR sky130_fd_sc_hd__decap_3
XFILLER_27_150 VGND VGND VPWR VPWR sky130_fd_sc_hd__decap_3
XFILLER_62_418 VGND VGND VPWR VPWR sky130_fd_sc_hd__fill_2
XTAP_TAPCELL_ROW_45_627 VGND VPWR sky130_fd_sc_hd__tapvpwrvgnd_1
XFILLER_27_194 VGND VGND VPWR VPWR sky130_fd_sc_hd__decap_3
XFILLER_55_481 VGND VGND VPWR VPWR sky130_fd_sc_hd__fill_2
XFILLER_30_304 VGND VGND VPWR VPWR sky130_fd_sc_hd__decap_3
XFILLER_42_131 VGND VGND VPWR VPWR sky130_fd_sc_hd__decap_3
XFILLER_15_389 VGND VGND VPWR VPWR sky130_fd_sc_hd__decap_3
XFILLER_30_326 VGND VGND VPWR VPWR sky130_fd_sc_hd__decap_3
XFILLER_70_484 VGND VGND VPWR VPWR sky130_fd_sc_hd__decap_3
XPHY_EDGE_ROW_85_Right_85 VGND VGND VPWR VPWR sky130_fd_sc_hd__decap_3
XFILLER_51_83 VGND VGND VPWR VPWR sky130_fd_sc_hd__decap_3
XFILLER_32_6 VGND VGND VPWR VPWR sky130_fd_sc_hd__decap_3
XFILLER_38_404 VGND VGND VPWR VPWR sky130_fd_sc_hd__decap_3
XFILLER_78_551 VGND VGND VPWR VPWR sky130_fd_sc_hd__decap_3
XFILLER_65_223 VGND VGND VPWR VPWR sky130_fd_sc_hd__fill_1
XFILLER_38_459 VGND VGND VPWR VPWR sky130_fd_sc_hd__decap_3
XFILLER_93_554 VGND VGND VPWR VPWR sky130_fd_sc_hd__decap_3
XFILLER_76_91 VGND VGND VPWR VPWR sky130_fd_sc_hd__decap_3
XFILLER_18_150 VGND VGND VPWR VPWR sky130_fd_sc_hd__decap_3
XFILLER_65_278 VGND VGND VPWR VPWR sky130_fd_sc_hd__fill_2
XFILLER_46_492 VGND VGND VPWR VPWR sky130_fd_sc_hd__fill_1
XFILLER_61_440 VGND VGND VPWR VPWR sky130_fd_sc_hd__fill_2
XFILLER_21_337 VGND VGND VPWR VPWR sky130_fd_sc_hd__decap_3
XFILLER_33_164 VGND VGND VPWR VPWR sky130_fd_sc_hd__decap_3
XFILLER_33_197 VGND VGND VPWR VPWR sky130_fd_sc_hd__decap_3
XFILLER_61_473 VGND VGND VPWR VPWR sky130_fd_sc_hd__decap_3
X_4812_ _5269_/Q _4847_/B VGND VGND VPWR VPWR _4812_/X sky130_fd_sc_hd__or2_2
XTAP_TAPCELL_ROW_16_351 VGND VPWR sky130_fd_sc_hd__tapvpwrvgnd_1
X_4743_ _4741_/Y _4742_/X _4854_/B VGND VGND VPWR VPWR _4743_/X sky130_fd_sc_hd__a21o_2
X_4674_ _4682_/S _4674_/B VGND VGND VPWR VPWR _4674_/Y sky130_fd_sc_hd__nor2_2
X_3625_ _4964_/Q _4948_/Q _4932_/Q _4916_/Q _5131_/Q _5132_/Q VGND VGND VPWR VPWR
+ _3625_/X sky130_fd_sc_hd__mux4_2
X_3556_ _4078_/A _4104_/A _4225_/A _3555_/X VGND VGND VPWR VPWR _3782_/A sky130_fd_sc_hd__o22a_2
X_2507_ _5169_/Q _4376_/A VGND VGND VPWR VPWR _2693_/B sky130_fd_sc_hd__nand2_2
XFILLER_88_304 VGND VGND VPWR VPWR sky130_fd_sc_hd__decap_3
X_5226_ _5233_/CLK _5226_/D VGND VGND VPWR VPWR _5226_/Q sky130_fd_sc_hd__dfxtp_2
X_3487_ _3487_/A _3487_/B VGND VGND VPWR VPWR _3487_/Y sky130_fd_sc_hd__xnor2_2
XFILLER_88_326 VGND VGND VPWR VPWR sky130_fd_sc_hd__decap_3
X_2438_ _5182_/Q _5181_/Q _3891_/A VGND VGND VPWR VPWR _3576_/A sky130_fd_sc_hd__nor3_2
XFILLER_29_426 VGND VGND VPWR VPWR sky130_fd_sc_hd__decap_3
X_5157_ _5263_/CLK _5157_/D VGND VGND VPWR VPWR _5157_/Q sky130_fd_sc_hd__dfxtp_2
XFILLER_84_521 VGND VGND VPWR VPWR sky130_fd_sc_hd__fill_2
X_4108_ _4108_/A _4108_/B VGND VGND VPWR VPWR _4108_/Y sky130_fd_sc_hd__nor2_2
X_5088_ _5109_/CLK _5088_/D VGND VGND VPWR VPWR _5088_/Q sky130_fd_sc_hd__dfxtp_2
XFILLER_44_418 VGND VGND VPWR VPWR sky130_fd_sc_hd__fill_2
XFILLER_56_267 VGND VGND VPWR VPWR sky130_fd_sc_hd__fill_1
XFILLER_56_289 VGND VGND VPWR VPWR sky130_fd_sc_hd__decap_3
X_4039_ _4033_/Y _4034_/X _4854_/B VGND VGND VPWR VPWR _4039_/Y sky130_fd_sc_hd__a21oi_2
XFILLER_72_38 VGND VGND VPWR VPWR sky130_fd_sc_hd__fill_2
XFILLER_12_315 VGND VGND VPWR VPWR sky130_fd_sc_hd__decap_3
XFILLER_12_348 VGND VGND VPWR VPWR sky130_fd_sc_hd__decap_3
XFILLER_24_197 VGND VGND VPWR VPWR sky130_fd_sc_hd__decap_3
XTAP_TAPCELL_ROW_50_674 VGND VPWR sky130_fd_sc_hd__tapvpwrvgnd_1
XFILLER_4_503 VGND VGND VPWR VPWR sky130_fd_sc_hd__decap_3
XFILLER_21_86 VGND VGND VPWR VPWR sky130_fd_sc_hd__decap_3
XFILLER_4_536 VGND VGND VPWR VPWR sky130_fd_sc_hd__decap_3
XFILLER_79_337 VGND VGND VPWR VPWR sky130_fd_sc_hd__decap_3
XFILLER_75_521 VGND VGND VPWR VPWR sky130_fd_sc_hd__decap_3
XTAP_TAPCELL_ROW_58_752 VGND VPWR sky130_fd_sc_hd__tapvpwrvgnd_1
XFILLER_35_429 VGND VGND VPWR VPWR sky130_fd_sc_hd__decap_3
XFILLER_47_289 VGND VGND VPWR VPWR sky130_fd_sc_hd__decap_3
XFILLER_62_215 VGND VGND VPWR VPWR sky130_fd_sc_hd__decap_3
XFILLER_90_557 VGND VGND VPWR VPWR sky130_fd_sc_hd__fill_1
XFILLER_15_131 VGND VGND VPWR VPWR sky130_fd_sc_hd__decap_3
XFILLER_15_164 VGND VGND VPWR VPWR sky130_fd_sc_hd__decap_3
XFILLER_15_175 VGND VGND VPWR VPWR sky130_fd_sc_hd__decap_3
XFILLER_70_281 VGND VGND VPWR VPWR sky130_fd_sc_hd__decap_3
XTAP_TAPCELL_ROW_13_321 VGND VPWR sky130_fd_sc_hd__tapvpwrvgnd_1
X_4390_ _4390_/A _4390_/B _4390_/C VGND VGND VPWR VPWR _4460_/A sky130_fd_sc_hd__or3_2
X_3410_ _3494_/A _3410_/B VGND VGND VPWR VPWR _5198_/D sky130_fd_sc_hd__nor2_2
XFILLER_7_385 VGND VGND VPWR VPWR sky130_fd_sc_hd__fill_1
X_3341_ _5180_/Q _3230_/B _3230_/Y _3340_/X VGND VGND VPWR VPWR _5180_/D sky130_fd_sc_hd__o22a_2
XFILLER_30_3 VGND VGND VPWR VPWR sky130_fd_sc_hd__decap_3
X_3272_ _5142_/Q _3315_/B _3270_/B _3271_/X _3338_/B VGND VGND VPWR VPWR _5142_/D
+ sky130_fd_sc_hd__o311a_2
XTAP_TAPCELL_ROW_90_1058 VGND VPWR sky130_fd_sc_hd__tapvpwrvgnd_1
X_5011_ clkload6/A _5011_/D VGND VGND VPWR VPWR _5011_/Q sky130_fd_sc_hd__dfxtp_2
XFILLER_38_256 VGND VGND VPWR VPWR sky130_fd_sc_hd__fill_2
XFILLER_19_492 VGND VGND VPWR VPWR sky130_fd_sc_hd__decap_3
XFILLER_81_535 VGND VGND VPWR VPWR sky130_fd_sc_hd__decap_3
XFILLER_34_451 VGND VGND VPWR VPWR sky130_fd_sc_hd__decap_3
XFILLER_34_495 VGND VGND VPWR VPWR sky130_fd_sc_hd__decap_3
XFILLER_61_281 VGND VGND VPWR VPWR sky130_fd_sc_hd__decap_3
X_2987_ _2941_/X _2974_/B _2974_/Y _4915_/Q VGND VGND VPWR VPWR _4915_/D sky130_fd_sc_hd__a22o_2
XFILLER_21_189 VGND VGND VPWR VPWR sky130_fd_sc_hd__decap_3
X_4726_ input39/X _4694_/Y _4725_/X _3366_/A VGND VGND VPWR VPWR _5257_/D sky130_fd_sc_hd__o211a_2
X_4657_ _4684_/B1 _3631_/B _3631_/A _3363_/A VGND VGND VPWR VPWR _4657_/X sky130_fd_sc_hd__o2bb2a_2
X_3608_ _3733_/S _3607_/X _5134_/Q VGND VGND VPWR VPWR _3608_/X sky130_fd_sc_hd__o21a_2
XFILLER_1_517 VGND VGND VPWR VPWR sky130_fd_sc_hd__decap_3
X_4588_ _4587_/Y _4556_/Y _4681_/S VGND VGND VPWR VPWR _4588_/X sky130_fd_sc_hd__mux2_1
X_3539_ _3642_/A _3866_/B _3538_/Y VGND VGND VPWR VPWR _3539_/Y sky130_fd_sc_hd__o21ai_2
XFILLER_88_123 VGND VGND VPWR VPWR sky130_fd_sc_hd__decap_3
XFILLER_88_167 VGND VGND VPWR VPWR sky130_fd_sc_hd__decap_3
X_5209_ _5286_/CLK _5209_/D VGND VGND VPWR VPWR _5209_/Q sky130_fd_sc_hd__dfxtp_2
XFILLER_76_318 VGND VGND VPWR VPWR sky130_fd_sc_hd__decap_3
XFILLER_72_513 VGND VGND VPWR VPWR sky130_fd_sc_hd__decap_3
XFILLER_84_351 VGND VGND VPWR VPWR sky130_fd_sc_hd__decap_3
XFILLER_83_15 VGND VGND VPWR VPWR sky130_fd_sc_hd__fill_2
XFILLER_29_289 VGND VGND VPWR VPWR sky130_fd_sc_hd__decap_3
XTAP_TAPCELL_ROW_55_722 VGND VPWR sky130_fd_sc_hd__tapvpwrvgnd_1
XFILLER_83_37 VGND VGND VPWR VPWR sky130_fd_sc_hd__decap_3
XFILLER_25_440 VGND VGND VPWR VPWR sky130_fd_sc_hd__fill_1
XFILLER_44_248 VGND VGND VPWR VPWR sky130_fd_sc_hd__decap_3
XFILLER_44_259 VGND VGND VPWR VPWR sky130_fd_sc_hd__decap_3
XFILLER_72_557 VGND VGND VPWR VPWR sky130_fd_sc_hd__fill_1
XTAP_TAPCELL_ROW_27_457 VGND VPWR sky130_fd_sc_hd__tapvpwrvgnd_1
XFILLER_12_134 VGND VGND VPWR VPWR sky130_fd_sc_hd__decap_3
XFILLER_40_421 VGND VGND VPWR VPWR sky130_fd_sc_hd__decap_3
XFILLER_40_432 VGND VGND VPWR VPWR sky130_fd_sc_hd__decap_3
XFILLER_12_156 VGND VGND VPWR VPWR sky130_fd_sc_hd__decap_3
XFILLER_40_465 VGND VGND VPWR VPWR sky130_fd_sc_hd__fill_2
XFILLER_32_41 VGND VGND VPWR VPWR sky130_fd_sc_hd__fill_1
XFILLER_32_74 VGND VGND VPWR VPWR sky130_fd_sc_hd__decap_3
XFILLER_40_498 VGND VGND VPWR VPWR sky130_fd_sc_hd__decap_3
XFILLER_32_85 VGND VGND VPWR VPWR sky130_fd_sc_hd__decap_3
XFILLER_79_156 VGND VGND VPWR VPWR sky130_fd_sc_hd__decap_3
XFILLER_48_510 VGND VGND VPWR VPWR sky130_fd_sc_hd__decap_3
XFILLER_67_318 VGND VGND VPWR VPWR sky130_fd_sc_hd__decap_3
XFILLER_79_167 VGND VGND VPWR VPWR sky130_fd_sc_hd__fill_1
XFILLER_48_554 VGND VGND VPWR VPWR sky130_fd_sc_hd__decap_3
XFILLER_57_60 VGND VGND VPWR VPWR sky130_fd_sc_hd__fill_1
X_2910_ _5276_/Q _5213_/Q _5197_/Q _5275_/Q VGND VGND VPWR VPWR _2910_/X sky130_fd_sc_hd__a22o_2
XFILLER_31_443 VGND VGND VPWR VPWR sky130_fd_sc_hd__decap_3
X_3890_ _3891_/A _3891_/B VGND VGND VPWR VPWR _4022_/B sky130_fd_sc_hd__nor2_2
X_2841_ _5077_/Q _5061_/Q _5045_/Q _5029_/Q _2854_/S0 _5136_/Q VGND VGND VPWR VPWR
+ _2841_/X sky130_fd_sc_hd__mux4_2
XPHY_EDGE_ROW_75_Left_169 VGND VGND VPWR VPWR sky130_fd_sc_hd__decap_3
X_2772_ _5137_/Q _2772_/B VGND VGND VPWR VPWR _2772_/X sky130_fd_sc_hd__or2_2
XFILLER_78_3 VGND VGND VPWR VPWR sky130_fd_sc_hd__decap_3
X_4511_ _4440_/Y _4448_/X _4515_/B VGND VGND VPWR VPWR _4511_/X sky130_fd_sc_hd__mux2_1
X_4442_ _4318_/A _4449_/S _4027_/Y VGND VGND VPWR VPWR _4444_/B sky130_fd_sc_hd__o21ai_2
XFILLER_7_193 VGND VGND VPWR VPWR sky130_fd_sc_hd__decap_3
X_4373_ _4393_/C _4372_/Y _4079_/A VGND VGND VPWR VPWR _4373_/X sky130_fd_sc_hd__o21a_2
X_3324_ _5283_/Q _3338_/B _3324_/C VGND VGND VPWR VPWR _3324_/X sky130_fd_sc_hd__and3_2
X_3255_ _5279_/Q _5155_/Q VGND VGND VPWR VPWR _3311_/S sky130_fd_sc_hd__nor2_2
XPHY_EDGE_ROW_84_Left_178 VGND VGND VPWR VPWR sky130_fd_sc_hd__decap_3
XFILLER_39_521 VGND VGND VPWR VPWR sky130_fd_sc_hd__fill_2
XTAP_TAPCELL_ROW_69_858 VGND VPWR sky130_fd_sc_hd__tapvpwrvgnd_1
XFILLER_85_148 VGND VGND VPWR VPWR sky130_fd_sc_hd__fill_1
XFILLER_66_362 VGND VGND VPWR VPWR sky130_fd_sc_hd__fill_2
X_3186_ _2934_/X _3191_/A2 _3191_/B1 _5089_/Q VGND VGND VPWR VPWR _5089_/D sky130_fd_sc_hd__a22o_2
XFILLER_26_215 VGND VGND VPWR VPWR sky130_fd_sc_hd__decap_3
XFILLER_54_524 VGND VGND VPWR VPWR sky130_fd_sc_hd__decap_3
XFILLER_66_373 VGND VGND VPWR VPWR sky130_fd_sc_hd__decap_3
XFILLER_26_259 VGND VGND VPWR VPWR sky130_fd_sc_hd__decap_3
XFILLER_81_343 VGND VGND VPWR VPWR sky130_fd_sc_hd__decap_3
XTAP_TAPCELL_ROW_24_427 VGND VPWR sky130_fd_sc_hd__tapvpwrvgnd_1
XFILLER_81_376 VGND VGND VPWR VPWR sky130_fd_sc_hd__decap_3
XFILLER_22_421 VGND VGND VPWR VPWR sky130_fd_sc_hd__decap_3
XPHY_EDGE_ROW_93_Left_187 VGND VGND VPWR VPWR sky130_fd_sc_hd__decap_3
X_4709_ _5249_/Q _4725_/B VGND VGND VPWR VPWR _4709_/X sky130_fd_sc_hd__or2_2
XFILLER_78_15 VGND VGND VPWR VPWR sky130_fd_sc_hd__decap_3
XFILLER_89_410 VGND VGND VPWR VPWR sky130_fd_sc_hd__decap_3
XFILLER_76_115 VGND VGND VPWR VPWR sky130_fd_sc_hd__decap_3
XFILLER_57_340 VGND VGND VPWR VPWR sky130_fd_sc_hd__decap_3
XFILLER_76_159 VGND VGND VPWR VPWR sky130_fd_sc_hd__decap_3
XFILLER_45_546 VGND VGND VPWR VPWR sky130_fd_sc_hd__decap_3
XFILLER_17_259 VGND VGND VPWR VPWR sky130_fd_sc_hd__decap_3
XFILLER_72_354 VGND VGND VPWR VPWR sky130_fd_sc_hd__decap_3
XFILLER_72_365 VGND VGND VPWR VPWR sky130_fd_sc_hd__decap_3
XFILLER_13_410 VGND VGND VPWR VPWR sky130_fd_sc_hd__decap_3
XFILLER_32_218 VGND VGND VPWR VPWR sky130_fd_sc_hd__decap_3
XFILLER_72_376 VGND VGND VPWR VPWR sky130_fd_sc_hd__decap_3
XFILLER_25_281 VGND VGND VPWR VPWR sky130_fd_sc_hd__decap_3
XFILLER_43_84 VGND VGND VPWR VPWR sky130_fd_sc_hd__decap_3
XFILLER_9_436 VGND VGND VPWR VPWR sky130_fd_sc_hd__decap_3
XFILLER_4_130 VGND VGND VPWR VPWR sky130_fd_sc_hd__fill_2
XFILLER_4_141 VGND VGND VPWR VPWR sky130_fd_sc_hd__fill_1
XFILLER_4_12 VGND VGND VPWR VPWR sky130_fd_sc_hd__fill_2
XFILLER_4_56 VGND VGND VPWR VPWR sky130_fd_sc_hd__decap_3
XFILLER_0_391 VGND VGND VPWR VPWR sky130_fd_sc_hd__fill_1
XFILLER_48_340 VGND VGND VPWR VPWR sky130_fd_sc_hd__decap_3
X_3040_ _2934_/X _3028_/Y _3029_/Y _4961_/Q VGND VGND VPWR VPWR _4961_/D sky130_fd_sc_hd__a22o_2
XTAP_TAPCELL_ROW_66_828 VGND VPWR sky130_fd_sc_hd__tapvpwrvgnd_1
XFILLER_82_107 VGND VGND VPWR VPWR sky130_fd_sc_hd__decap_3
XFILLER_48_384 VGND VGND VPWR VPWR sky130_fd_sc_hd__decap_3
XFILLER_82_129 VGND VGND VPWR VPWR sky130_fd_sc_hd__fill_2
XFILLER_51_505 VGND VGND VPWR VPWR sky130_fd_sc_hd__decap_3
XFILLER_84_80 VGND VGND VPWR VPWR sky130_fd_sc_hd__decap_3
XFILLER_63_365 VGND VGND VPWR VPWR sky130_fd_sc_hd__fill_2
XFILLER_63_376 VGND VGND VPWR VPWR sky130_fd_sc_hd__fill_1
X_4991_ clkload4/A _4991_/D VGND VGND VPWR VPWR _4991_/Q sky130_fd_sc_hd__dfxtp_2
X_3942_ _3934_/A _3797_/B _4021_/B VGND VGND VPWR VPWR _3943_/B sky130_fd_sc_hd__a21oi_2
XFILLER_31_251 VGND VGND VPWR VPWR sky130_fd_sc_hd__decap_3
X_3873_ _4362_/A _3872_/X _3961_/S VGND VGND VPWR VPWR _3873_/X sky130_fd_sc_hd__mux2_1
X_2824_ _2822_/X _2823_/X _2855_/S VGND VGND VPWR VPWR _2824_/X sky130_fd_sc_hd__mux2_1
X_2755_ _4955_/Q _4939_/Q _4923_/Q _4907_/Q _2818_/S0 _5136_/Q VGND VGND VPWR VPWR
+ _2755_/X sky130_fd_sc_hd__mux4_2
X_2686_ _2686_/A VGND VGND VPWR VPWR _2686_/Y sky130_fd_sc_hd__inv_2
X_4425_ _4682_/S _4666_/B VGND VGND VPWR VPWR _4595_/B sky130_fd_sc_hd__or2_2
X_4356_ _4356_/A _4356_/B VGND VGND VPWR VPWR _4359_/A sky130_fd_sc_hd__nor2_2
XFILLER_48_29 VGND VGND VPWR VPWR sky130_fd_sc_hd__decap_3
X_3307_ _5151_/Q _5150_/Q _5149_/Q _3307_/D VGND VGND VPWR VPWR _3308_/C sky130_fd_sc_hd__and4_2
XFILLER_86_413 VGND VGND VPWR VPWR sky130_fd_sc_hd__decap_3
X_4287_ _4287_/A _4287_/B VGND VGND VPWR VPWR _4287_/Y sky130_fd_sc_hd__nor2_2
XFILLER_86_446 VGND VGND VPWR VPWR sky130_fd_sc_hd__decap_3
XFILLER_27_502 VGND VGND VPWR VPWR sky130_fd_sc_hd__fill_2
XFILLER_39_340 VGND VGND VPWR VPWR sky130_fd_sc_hd__decap_3
XFILLER_58_159 VGND VGND VPWR VPWR sky130_fd_sc_hd__fill_2
X_3238_ _5175_/Q _4868_/A2 _4870_/B1 _3237_/X VGND VGND VPWR VPWR _5130_/D sky130_fd_sc_hd__o22a_2
XFILLER_27_535 VGND VGND VPWR VPWR sky130_fd_sc_hd__decap_3
X_3169_ _2937_/X _3173_/A2 _3157_/Y _5074_/Q VGND VGND VPWR VPWR _5074_/D sky130_fd_sc_hd__a22o_2
XFILLER_27_546 VGND VGND VPWR VPWR sky130_fd_sc_hd__decap_3
XFILLER_54_332 VGND VGND VPWR VPWR sky130_fd_sc_hd__fill_2
XFILLER_66_192 VGND VGND VPWR VPWR sky130_fd_sc_hd__decap_3
XFILLER_42_527 VGND VGND VPWR VPWR sky130_fd_sc_hd__decap_3
XFILLER_54_365 VGND VGND VPWR VPWR sky130_fd_sc_hd__decap_3
XTAP_TAPCELL_ROW_37_552 VGND VPWR sky130_fd_sc_hd__tapvpwrvgnd_1
XFILLER_81_162 VGND VGND VPWR VPWR sky130_fd_sc_hd__fill_1
XFILLER_54_398 VGND VGND VPWR VPWR sky130_fd_sc_hd__decap_3
XFILLER_10_402 VGND VGND VPWR VPWR sky130_fd_sc_hd__decap_3
XFILLER_22_251 VGND VGND VPWR VPWR sky130_fd_sc_hd__fill_1
XFILLER_80_27 VGND VGND VPWR VPWR sky130_fd_sc_hd__fill_1
XFILLER_22_262 VGND VGND VPWR VPWR sky130_fd_sc_hd__decap_3
XFILLER_80_49 VGND VGND VPWR VPWR sky130_fd_sc_hd__decap_3
XFILLER_6_417 VGND VGND VPWR VPWR sky130_fd_sc_hd__decap_3
XFILLER_13_98 VGND VGND VPWR VPWR sky130_fd_sc_hd__decap_3
XFILLER_6_439 VGND VGND VPWR VPWR sky130_fd_sc_hd__decap_3
XFILLER_89_36 VGND VGND VPWR VPWR sky130_fd_sc_hd__decap_3
XFILLER_8_3 VGND VGND VPWR VPWR sky130_fd_sc_hd__decap_3
XFILLER_49_104 VGND VGND VPWR VPWR sky130_fd_sc_hd__decap_3
XTAP_TAPCELL_ROW_9_288 VGND VPWR sky130_fd_sc_hd__tapvpwrvgnd_1
XFILLER_89_262 VGND VGND VPWR VPWR sky130_fd_sc_hd__fill_2
XFILLER_77_413 VGND VGND VPWR VPWR sky130_fd_sc_hd__decap_3
XFILLER_49_148 VGND VGND VPWR VPWR sky130_fd_sc_hd__decap_3
XFILLER_89_295 VGND VGND VPWR VPWR sky130_fd_sc_hd__fill_1
XFILLER_92_449 VGND VGND VPWR VPWR sky130_fd_sc_hd__decap_3
XFILLER_92_427 VGND VGND VPWR VPWR sky130_fd_sc_hd__decap_3
XFILLER_33_505 VGND VGND VPWR VPWR sky130_fd_sc_hd__decap_3
XFILLER_60_302 VGND VGND VPWR VPWR sky130_fd_sc_hd__decap_3
XFILLER_33_549 VGND VGND VPWR VPWR sky130_fd_sc_hd__fill_1
XFILLER_60_324 VGND VGND VPWR VPWR sky130_fd_sc_hd__fill_1
XFILLER_60_335 VGND VGND VPWR VPWR sky130_fd_sc_hd__fill_2
XFILLER_60_346 VGND VGND VPWR VPWR sky130_fd_sc_hd__decap_3
XFILLER_60_368 VGND VGND VPWR VPWR sky130_fd_sc_hd__decap_3
XTAP_TAPCELL_ROW_71_875 VGND VPWR sky130_fd_sc_hd__tapvpwrvgnd_1
XFILLER_9_277 VGND VGND VPWR VPWR sky130_fd_sc_hd__decap_3
Xclkload25 _5263_/CLK VGND VGND VPWR VPWR clkload25/X sky130_fd_sc_hd__clkbuf_8
Xclkload14 _5083_/CLK VGND VGND VPWR VPWR clkload14/Y sky130_fd_sc_hd__clkinv_2
X_2540_ _2535_/X _2536_/X _2539_/X _2433_/Y VGND VGND VPWR VPWR _4393_/B sky130_fd_sc_hd__a22o_2
XFILLER_5_461 VGND VGND VPWR VPWR sky130_fd_sc_hd__decap_3
XFILLER_5_483 VGND VGND VPWR VPWR sky130_fd_sc_hd__decap_3
X_2471_ _4902_/Q _4886_/Q _5110_/Q _5094_/Q _2672_/S0 _2672_/S1 VGND VGND VPWR VPWR
+ _2471_/X sky130_fd_sc_hd__mux4_2
X_4210_ _5222_/Q _4847_/B _4209_/Y _3366_/A VGND VGND VPWR VPWR _5222_/D sky130_fd_sc_hd__o211a_2
XFILLER_68_413 VGND VGND VPWR VPWR sky130_fd_sc_hd__fill_2
X_5190_ _5216_/CLK _5190_/D VGND VGND VPWR VPWR _5190_/Q sky130_fd_sc_hd__dfxtp_2
XFILLER_68_424 VGND VGND VPWR VPWR sky130_fd_sc_hd__decap_3
XFILLER_68_446 VGND VGND VPWR VPWR sky130_fd_sc_hd__decap_3
X_4141_ _4123_/A _4119_/B _3787_/Y VGND VGND VPWR VPWR _4142_/B sky130_fd_sc_hd__a21bo_2
XTAP_TAPCELL_ROW_79_953 VGND VPWR sky130_fd_sc_hd__tapvpwrvgnd_1
X_4072_ _4071_/A _3961_/X _4071_/Y _4175_/A VGND VGND VPWR VPWR _4072_/X sky130_fd_sc_hd__a211o_2
XFILLER_83_416 VGND VGND VPWR VPWR sky130_fd_sc_hd__fill_1
X_3023_ _2937_/X _3011_/B _3011_/Y _4946_/Q VGND VGND VPWR VPWR _4946_/D sky130_fd_sc_hd__a22o_2
XFILLER_24_527 VGND VGND VPWR VPWR sky130_fd_sc_hd__decap_3
XFILLER_36_376 VGND VGND VPWR VPWR sky130_fd_sc_hd__decap_3
XFILLER_51_346 VGND VGND VPWR VPWR sky130_fd_sc_hd__decap_3
X_4974_ _5118_/CLK _4974_/D VGND VGND VPWR VPWR _4974_/Q sky130_fd_sc_hd__dfxtp_2
XTAP_TAPCELL_ROW_34_522 VGND VPWR sky130_fd_sc_hd__tapvpwrvgnd_1
XFILLER_51_379 VGND VGND VPWR VPWR sky130_fd_sc_hd__decap_3
X_3925_ _4362_/A _3577_/X _3961_/S VGND VGND VPWR VPWR _3925_/X sky130_fd_sc_hd__mux2_1
Xclkload8 clkload8/A VGND VGND VPWR VPWR clkload8/X sky130_fd_sc_hd__clkbuf_4
X_3856_ _4376_/A _4638_/S _3855_/Y VGND VGND VPWR VPWR _3856_/Y sky130_fd_sc_hd__o21ai_2
X_3787_ _4123_/A _4119_/A _3785_/Y VGND VGND VPWR VPWR _3787_/Y sky130_fd_sc_hd__a21oi_2
X_2807_ _5121_/Q _5009_/Q _4993_/Q _4977_/Q _5135_/Q _5136_/Q VGND VGND VPWR VPWR
+ _2808_/B sky130_fd_sc_hd__mux4_2
XFILLER_3_409 VGND VGND VPWR VPWR sky130_fd_sc_hd__decap_3
X_2738_ _2832_/A _2737_/X _2435_/Y VGND VGND VPWR VPWR _2738_/X sky130_fd_sc_hd__o21a_2
X_4408_ _4408_/A _4408_/B VGND VGND VPWR VPWR _4410_/B sky130_fd_sc_hd__xor2_2
X_2669_ _2670_/A _4633_/S VGND VGND VPWR VPWR _4173_/A sky130_fd_sc_hd__and2_2
XFILLER_59_402 VGND VGND VPWR VPWR sky130_fd_sc_hd__decap_3
XFILLER_59_435 VGND VGND VPWR VPWR sky130_fd_sc_hd__decap_3
X_4339_ _4241_/A _3642_/A _4365_/A VGND VGND VPWR VPWR _4339_/Y sky130_fd_sc_hd__a21oi_2
XTAP_TAPCELL_ROW_6_258 VGND VPWR sky130_fd_sc_hd__tapvpwrvgnd_1
XFILLER_59_468 VGND VGND VPWR VPWR sky130_fd_sc_hd__decap_3
XFILLER_15_505 VGND VGND VPWR VPWR sky130_fd_sc_hd__fill_1
XFILLER_42_302 VGND VGND VPWR VPWR sky130_fd_sc_hd__decap_3
XFILLER_42_346 VGND VGND VPWR VPWR sky130_fd_sc_hd__decap_3
XFILLER_54_195 VGND VGND VPWR VPWR sky130_fd_sc_hd__fill_1
XFILLER_30_508 VGND VGND VPWR VPWR sky130_fd_sc_hd__decap_3
XFILLER_10_210 VGND VGND VPWR VPWR sky130_fd_sc_hd__decap_3
XFILLER_24_64 VGND VGND VPWR VPWR sky130_fd_sc_hd__decap_3
XFILLER_40_85 VGND VGND VPWR VPWR sky130_fd_sc_hd__decap_3
XFILLER_2_497 VGND VGND VPWR VPWR sky130_fd_sc_hd__decap_3
XFILLER_65_405 VGND VGND VPWR VPWR sky130_fd_sc_hd__decap_3
XFILLER_77_254 VGND VGND VPWR VPWR sky130_fd_sc_hd__fill_2
XFILLER_1_24 VGND VGND VPWR VPWR sky130_fd_sc_hd__decap_3
XFILLER_65_438 VGND VGND VPWR VPWR sky130_fd_sc_hd__fill_2
XTAP_TAPCELL_ROW_76_923 VGND VPWR sky130_fd_sc_hd__tapvpwrvgnd_1
XFILLER_92_224 VGND VGND VPWR VPWR sky130_fd_sc_hd__fill_1
XFILLER_77_276 VGND VGND VPWR VPWR sky130_fd_sc_hd__decap_3
XFILLER_1_68 VGND VGND VPWR VPWR sky130_fd_sc_hd__decap_3
XTAP_TAPCELL_ROW_48_658 VGND VPWR sky130_fd_sc_hd__tapvpwrvgnd_1
XFILLER_65_71 VGND VGND VPWR VPWR sky130_fd_sc_hd__decap_3
XFILLER_33_335 VGND VGND VPWR VPWR sky130_fd_sc_hd__fill_1
XFILLER_21_519 VGND VGND VPWR VPWR sky130_fd_sc_hd__decap_3
XFILLER_33_357 VGND VGND VPWR VPWR sky130_fd_sc_hd__fill_2
XFILLER_33_368 VGND VGND VPWR VPWR sky130_fd_sc_hd__decap_3
XFILLER_60_154 VGND VGND VPWR VPWR sky130_fd_sc_hd__decap_3
X_3710_ _3708_/X _3709_/X _3733_/S VGND VGND VPWR VPWR _3710_/X sky130_fd_sc_hd__mux2_1
X_4690_ _4437_/A _4683_/X _4689_/X _4268_/X VGND VGND VPWR VPWR _4690_/X sky130_fd_sc_hd__o211a_2
X_3641_ _3642_/A _3809_/B VGND VGND VPWR VPWR _4644_/S sky130_fd_sc_hd__nor2_2
X_3572_ _4393_/C _3905_/B VGND VGND VPWR VPWR _3572_/Y sky130_fd_sc_hd__nand2_2
X_2523_ _4894_/Q _4878_/Q _5102_/Q _5086_/Q _2676_/S0 _2676_/S1 VGND VGND VPWR VPWR
+ _2524_/B sky130_fd_sc_hd__mux4_2
X_5242_ _5254_/CLK _5242_/D VGND VGND VPWR VPWR _5242_/Q sky130_fd_sc_hd__dfxtp_2
X_2454_ _5185_/Q _2463_/A VGND VGND VPWR VPWR _3357_/B sky130_fd_sc_hd__and2b_2
XTAP_TAPCELL_ROW_93_1089 VGND VPWR sky130_fd_sc_hd__tapvpwrvgnd_1
X_5173_ _5263_/CLK _5173_/D VGND VGND VPWR VPWR _5173_/Q sky130_fd_sc_hd__dfxtp_2
XFILLER_68_265 VGND VGND VPWR VPWR sky130_fd_sc_hd__decap_3
X_4124_ _4125_/A _4124_/B _4125_/B VGND VGND VPWR VPWR _4126_/C sky130_fd_sc_hd__or3_2
XFILLER_28_118 VGND VGND VPWR VPWR sky130_fd_sc_hd__decap_3
Xinput1 INSTR_STREAM[0] VGND VGND VPWR VPWR input1/X sky130_fd_sc_hd__clkdlybuf4s25_1
XTAP_TAPCELL_ROW_3_228 VGND VPWR sky130_fd_sc_hd__tapvpwrvgnd_1
XFILLER_56_449 VGND VGND VPWR VPWR sky130_fd_sc_hd__decap_3
X_4055_ _4055_/A _4055_/B _4055_/C _4055_/D VGND VGND VPWR VPWR _4055_/X sky130_fd_sc_hd__and4_2
XFILLER_71_408 VGND VGND VPWR VPWR sky130_fd_sc_hd__decap_3
X_3006_ _2941_/X _2992_/Y _2993_/Y _4931_/Q VGND VGND VPWR VPWR _4931_/D sky130_fd_sc_hd__a22o_2
XFILLER_83_279 VGND VGND VPWR VPWR sky130_fd_sc_hd__fill_1
XTAP_TAPCELL_ROW_19_382 VGND VPWR sky130_fd_sc_hd__tapvpwrvgnd_1
XFILLER_24_368 VGND VGND VPWR VPWR sky130_fd_sc_hd__decap_3
X_4957_ _5117_/CLK _4957_/D VGND VGND VPWR VPWR _4957_/Q sky130_fd_sc_hd__dfxtp_2
X_4888_ _5083_/CLK _4888_/D VGND VGND VPWR VPWR _4888_/Q sky130_fd_sc_hd__dfxtp_2
X_3908_ _4071_/A _4016_/B _3902_/X _3569_/X VGND VGND VPWR VPWR _3908_/X sky130_fd_sc_hd__a211o_2
X_3839_ _3834_/Y _3838_/Y _4174_/B VGND VGND VPWR VPWR _4192_/C sky130_fd_sc_hd__o21a_2
XFILLER_3_206 VGND VGND VPWR VPWR sky130_fd_sc_hd__decap_3
XFILLER_10_22 VGND VGND VPWR VPWR sky130_fd_sc_hd__decap_3
XFILLER_79_508 VGND VGND VPWR VPWR sky130_fd_sc_hd__decap_3
XFILLER_86_26 VGND VGND VPWR VPWR sky130_fd_sc_hd__fill_2
XFILLER_86_15 VGND VGND VPWR VPWR sky130_fd_sc_hd__fill_1
XFILLER_19_53 VGND VGND VPWR VPWR sky130_fd_sc_hd__decap_3
XFILLER_47_416 VGND VGND VPWR VPWR sky130_fd_sc_hd__decap_3
XFILLER_47_449 VGND VGND VPWR VPWR sky130_fd_sc_hd__decap_3
XFILLER_74_224 VGND VGND VPWR VPWR sky130_fd_sc_hd__decap_3
XFILLER_74_235 VGND VGND VPWR VPWR sky130_fd_sc_hd__decap_3
XFILLER_62_408 VGND VGND VPWR VPWR sky130_fd_sc_hd__decap_3
XFILLER_35_52 VGND VGND VPWR VPWR sky130_fd_sc_hd__decap_3
XFILLER_42_121 VGND VGND VPWR VPWR sky130_fd_sc_hd__fill_2
XFILLER_70_430 VGND VGND VPWR VPWR sky130_fd_sc_hd__decap_3
XTAP_TAPCELL_ROW_45_628 VGND VPWR sky130_fd_sc_hd__tapvpwrvgnd_1
XFILLER_70_452 VGND VGND VPWR VPWR sky130_fd_sc_hd__fill_2
XTAP_TAPCELL_ROW_81_970 VGND VPWR sky130_fd_sc_hd__tapvpwrvgnd_1
XFILLER_30_349 VGND VGND VPWR VPWR sky130_fd_sc_hd__decap_3
XFILLER_51_40 VGND VGND VPWR VPWR sky130_fd_sc_hd__decap_3
XFILLER_2_250 VGND VGND VPWR VPWR sky130_fd_sc_hd__fill_2
XFILLER_25_6 VGND VGND VPWR VPWR sky130_fd_sc_hd__decap_3
XFILLER_38_427 VGND VGND VPWR VPWR sky130_fd_sc_hd__decap_3
XFILLER_65_202 VGND VGND VPWR VPWR sky130_fd_sc_hd__decap_3
XFILLER_93_511 VGND VGND VPWR VPWR sky130_fd_sc_hd__decap_3
XFILLER_65_235 VGND VGND VPWR VPWR sky130_fd_sc_hd__decap_3
XFILLER_93_533 VGND VGND VPWR VPWR sky130_fd_sc_hd__decap_3
XFILLER_61_452 VGND VGND VPWR VPWR sky130_fd_sc_hd__decap_3
XFILLER_73_290 VGND VGND VPWR VPWR sky130_fd_sc_hd__decap_3
X_4811_ _4814_/B _4811_/B VGND VGND VPWR VPWR _4811_/X sky130_fd_sc_hd__xor2_2
XTAP_TAPCELL_ROW_16_352 VGND VPWR sky130_fd_sc_hd__tapvpwrvgnd_1
XFILLER_92_91 VGND VGND VPWR VPWR sky130_fd_sc_hd__decap_3
XFILLER_14_390 VGND VGND VPWR VPWR sky130_fd_sc_hd__decap_3
XFILLER_21_349 VGND VGND VPWR VPWR sky130_fd_sc_hd__decap_3
X_4742_ _4742_/A _4742_/B VGND VGND VPWR VPWR _4742_/X sky130_fd_sc_hd__or2_2
X_4673_ _4672_/X _4639_/A _4681_/S VGND VGND VPWR VPWR _4674_/B sky130_fd_sc_hd__mux2_1
X_3624_ _3693_/A _3621_/X _5134_/Q VGND VGND VPWR VPWR _3624_/X sky130_fd_sc_hd__o21a_2
X_3555_ _3547_/X _3554_/Y _4078_/B VGND VGND VPWR VPWR _3555_/X sky130_fd_sc_hd__mux2_1
XFILLER_0_209 VGND VGND VPWR VPWR sky130_fd_sc_hd__decap_3
X_3486_ _3479_/A _3476_/Y _3478_/B VGND VGND VPWR VPWR _3487_/B sky130_fd_sc_hd__o21ai_2
X_2506_ _4659_/S VGND VGND VPWR VPWR _2506_/Y sky130_fd_sc_hd__inv_2
X_5225_ _5257_/CLK _5225_/D VGND VGND VPWR VPWR _5225_/Q sky130_fd_sc_hd__dfxtp_2
X_2437_ _3366_/A _5280_/Q VGND VGND VPWR VPWR _5283_/D sky130_fd_sc_hd__and2_2
XFILLER_88_338 VGND VGND VPWR VPWR sky130_fd_sc_hd__decap_3
XFILLER_69_552 VGND VGND VPWR VPWR sky130_fd_sc_hd__decap_3
XFILLER_56_213 VGND VGND VPWR VPWR sky130_fd_sc_hd__fill_2
X_5156_ _5176_/CLK _5156_/D VGND VGND VPWR VPWR _5156_/Q sky130_fd_sc_hd__dfxtp_2
XFILLER_29_438 VGND VGND VPWR VPWR sky130_fd_sc_hd__decap_3
XFILLER_29_449 VGND VGND VPWR VPWR sky130_fd_sc_hd__decap_3
XFILLER_56_224 VGND VGND VPWR VPWR sky130_fd_sc_hd__fill_1
XFILLER_56_235 VGND VGND VPWR VPWR sky130_fd_sc_hd__decap_3
X_4107_ _4107_/A _4107_/B _4107_/C _4096_/X VGND VGND VPWR VPWR _4108_/B sky130_fd_sc_hd__or4b_2
X_5087_ _5215_/CLK _5087_/D VGND VGND VPWR VPWR _5087_/Q sky130_fd_sc_hd__dfxtp_2
XFILLER_84_555 VGND VGND VPWR VPWR sky130_fd_sc_hd__decap_3
XFILLER_44_408 VGND VGND VPWR VPWR sky130_fd_sc_hd__fill_1
X_4038_ _4191_/A _2871_/B _4023_/X _4035_/X _4037_/X VGND VGND VPWR VPWR _4038_/X
+ sky130_fd_sc_hd__o2111a_2
XFILLER_37_471 VGND VGND VPWR VPWR sky130_fd_sc_hd__decap_3
XFILLER_37_482 VGND VGND VPWR VPWR sky130_fd_sc_hd__decap_3
XFILLER_24_121 VGND VGND VPWR VPWR sky130_fd_sc_hd__fill_1
XFILLER_52_441 VGND VGND VPWR VPWR sky130_fd_sc_hd__decap_3
XFILLER_52_474 VGND VGND VPWR VPWR sky130_fd_sc_hd__fill_2
XFILLER_8_309 VGND VGND VPWR VPWR sky130_fd_sc_hd__decap_3
XTAP_TAPCELL_ROW_50_675 VGND VPWR sky130_fd_sc_hd__tapvpwrvgnd_1
XFILLER_20_393 VGND VGND VPWR VPWR sky130_fd_sc_hd__decap_3
XFILLER_4_515 VGND VGND VPWR VPWR sky130_fd_sc_hd__decap_3
XFILLER_4_548 VGND VGND VPWR VPWR sky130_fd_sc_hd__decap_3
XFILLER_79_349 VGND VGND VPWR VPWR sky130_fd_sc_hd__decap_3
XFILLER_87_360 VGND VGND VPWR VPWR sky130_fd_sc_hd__decap_3
XFILLER_75_511 VGND VGND VPWR VPWR sky130_fd_sc_hd__fill_1
XFILLER_87_393 VGND VGND VPWR VPWR sky130_fd_sc_hd__decap_3
XFILLER_75_533 VGND VGND VPWR VPWR sky130_fd_sc_hd__fill_1
XFILLER_35_408 VGND VGND VPWR VPWR sky130_fd_sc_hd__fill_2
XTAP_TAPCELL_ROW_58_753 VGND VPWR sky130_fd_sc_hd__tapvpwrvgnd_1
XFILLER_62_227 VGND VGND VPWR VPWR sky130_fd_sc_hd__decap_3
XFILLER_15_143 VGND VGND VPWR VPWR sky130_fd_sc_hd__decap_3
XFILLER_43_452 VGND VGND VPWR VPWR sky130_fd_sc_hd__decap_3
XFILLER_15_187 VGND VGND VPWR VPWR sky130_fd_sc_hd__decap_3
XFILLER_43_485 VGND VGND VPWR VPWR sky130_fd_sc_hd__decap_3
XFILLER_15_198 VGND VGND VPWR VPWR sky130_fd_sc_hd__decap_3
XFILLER_70_293 VGND VGND VPWR VPWR sky130_fd_sc_hd__decap_3
XTAP_TAPCELL_ROW_13_322 VGND VPWR sky130_fd_sc_hd__tapvpwrvgnd_1
XFILLER_62_83 VGND VGND VPWR VPWR sky130_fd_sc_hd__fill_1
XFILLER_11_360 VGND VGND VPWR VPWR sky130_fd_sc_hd__decap_3
X_3340_ _5283_/Q _3366_/A _3340_/C VGND VGND VPWR VPWR _3340_/X sky130_fd_sc_hd__and3_2
X_5010_ _5010_/CLK _5010_/D VGND VGND VPWR VPWR _5010_/Q sky130_fd_sc_hd__dfxtp_2
X_3271_ _5263_/Q _5189_/Q _3305_/B _3270_/Y VGND VGND VPWR VPWR _3271_/X sky130_fd_sc_hd__a22o_2
XTAP_TAPCELL_ROW_90_1059 VGND VPWR sky130_fd_sc_hd__tapvpwrvgnd_1
XFILLER_23_3 VGND VGND VPWR VPWR sky130_fd_sc_hd__decap_3
XFILLER_66_511 VGND VGND VPWR VPWR sky130_fd_sc_hd__decap_3
XFILLER_87_80 VGND VGND VPWR VPWR sky130_fd_sc_hd__decap_3
XFILLER_78_371 VGND VGND VPWR VPWR sky130_fd_sc_hd__decap_3
XFILLER_66_533 VGND VGND VPWR VPWR sky130_fd_sc_hd__decap_3
XFILLER_26_408 VGND VGND VPWR VPWR sky130_fd_sc_hd__decap_3
XFILLER_81_514 VGND VGND VPWR VPWR sky130_fd_sc_hd__decap_3
XFILLER_34_430 VGND VGND VPWR VPWR sky130_fd_sc_hd__decap_3
XFILLER_46_290 VGND VGND VPWR VPWR sky130_fd_sc_hd__decap_3
XFILLER_34_463 VGND VGND VPWR VPWR sky130_fd_sc_hd__decap_3
XFILLER_61_271 VGND VGND VPWR VPWR sky130_fd_sc_hd__decap_3
X_2986_ _2937_/X _2974_/B _2974_/Y _4914_/Q VGND VGND VPWR VPWR _4914_/D sky130_fd_sc_hd__a22o_2
X_4725_ _5257_/Q _4725_/B VGND VGND VPWR VPWR _4725_/X sky130_fd_sc_hd__or2_2
X_4656_ _4666_/A _4545_/X _4655_/X _4437_/B VGND VGND VPWR VPWR _4656_/X sky130_fd_sc_hd__o22a_2
X_4587_ _4397_/B _3866_/B _3551_/Y VGND VGND VPWR VPWR _4587_/Y sky130_fd_sc_hd__o21ai_2
X_3607_ _5067_/Q _5051_/Q _5035_/Q _5019_/Q _5131_/Q _5132_/Q VGND VGND VPWR VPWR
+ _3607_/X sky130_fd_sc_hd__mux4_2
X_3538_ _4241_/A _3866_/B VGND VGND VPWR VPWR _3538_/Y sky130_fd_sc_hd__nand2_2
XFILLER_1_529 VGND VGND VPWR VPWR sky130_fd_sc_hd__decap_3
XFILLER_67_17 VGND VGND VPWR VPWR sky130_fd_sc_hd__fill_1
X_3469_ _3469_/A _3469_/B VGND VGND VPWR VPWR _3472_/B sky130_fd_sc_hd__nand2_2
X_5208_ _5208_/CLK _5208_/D VGND VGND VPWR VPWR _5208_/Q sky130_fd_sc_hd__dfxtp_2
XFILLER_88_179 VGND VGND VPWR VPWR sky130_fd_sc_hd__decap_3
XFILLER_69_393 VGND VGND VPWR VPWR sky130_fd_sc_hd__decap_3
X_5139_ _5260_/CLK _5139_/D VGND VGND VPWR VPWR _5139_/Q sky130_fd_sc_hd__dfxtp_2
XFILLER_29_257 VGND VGND VPWR VPWR sky130_fd_sc_hd__decap_3
XFILLER_44_216 VGND VGND VPWR VPWR sky130_fd_sc_hd__decap_3
XFILLER_72_525 VGND VGND VPWR VPWR sky130_fd_sc_hd__decap_3
XFILLER_72_536 VGND VGND VPWR VPWR sky130_fd_sc_hd__decap_3
XTAP_TAPCELL_ROW_55_723 VGND VPWR sky130_fd_sc_hd__tapvpwrvgnd_1
XFILLER_84_385 VGND VGND VPWR VPWR sky130_fd_sc_hd__decap_3
XFILLER_83_49 VGND VGND VPWR VPWR sky130_fd_sc_hd__decap_3
XFILLER_16_21 VGND VGND VPWR VPWR sky130_fd_sc_hd__decap_3
XTAP_TAPCELL_ROW_27_458 VGND VPWR sky130_fd_sc_hd__tapvpwrvgnd_1
XFILLER_16_65 VGND VGND VPWR VPWR sky130_fd_sc_hd__fill_2
XFILLER_40_444 VGND VGND VPWR VPWR sky130_fd_sc_hd__decap_3
XFILLER_52_293 VGND VGND VPWR VPWR sky130_fd_sc_hd__decap_3
XFILLER_40_477 VGND VGND VPWR VPWR sky130_fd_sc_hd__decap_3
XFILLER_8_106 VGND VGND VPWR VPWR sky130_fd_sc_hd__decap_3
XFILLER_4_312 VGND VGND VPWR VPWR sky130_fd_sc_hd__decap_3
XFILLER_79_113 VGND VGND VPWR VPWR sky130_fd_sc_hd__decap_3
XFILLER_0_551 VGND VGND VPWR VPWR sky130_fd_sc_hd__decap_3
XFILLER_57_50 VGND VGND VPWR VPWR sky130_fd_sc_hd__fill_1
XFILLER_57_83 VGND VGND VPWR VPWR sky130_fd_sc_hd__decap_3
XFILLER_90_344 VGND VGND VPWR VPWR sky130_fd_sc_hd__decap_3
XFILLER_73_71 VGND VGND VPWR VPWR sky130_fd_sc_hd__decap_3
XFILLER_90_388 VGND VGND VPWR VPWR sky130_fd_sc_hd__decap_3
X_2840_ _4901_/Q _4885_/Q _5109_/Q _5093_/Q _2854_/S0 _5136_/Q VGND VGND VPWR VPWR
+ _2840_/X sky130_fd_sc_hd__mux4_2
XFILLER_92_6 VGND VGND VPWR VPWR sky130_fd_sc_hd__decap_3
XFILLER_31_477 VGND VGND VPWR VPWR sky130_fd_sc_hd__decap_3
XFILLER_31_499 VGND VGND VPWR VPWR sky130_fd_sc_hd__decap_3
X_2771_ _5117_/Q _5005_/Q _4989_/Q _4973_/Q _2818_/S0 _5136_/Q VGND VGND VPWR VPWR
+ _2772_/B sky130_fd_sc_hd__mux4_2
X_4510_ _4558_/S _4437_/X _4501_/B _4509_/X VGND VGND VPWR VPWR _4518_/B sky130_fd_sc_hd__o31a_2
X_4441_ _4439_/Y _4440_/Y _4515_/B VGND VGND VPWR VPWR _4441_/X sky130_fd_sc_hd__mux2_1
XPHY_EDGE_ROW_9_Right_9 VGND VGND VPWR VPWR sky130_fd_sc_hd__decap_3
X_4372_ _4390_/A _4371_/Y _4393_/D VGND VGND VPWR VPWR _4372_/Y sky130_fd_sc_hd__a21oi_2
X_3323_ _5159_/Q _4868_/A2 _4870_/B1 _3322_/X VGND VGND VPWR VPWR _5159_/D sky130_fd_sc_hd__o22a_2
X_3254_ _5179_/Q _3229_/Y _4870_/B1 _3253_/X VGND VGND VPWR VPWR _5138_/D sky130_fd_sc_hd__o22a_2
XTAP_TAPCELL_ROW_69_859 VGND VPWR sky130_fd_sc_hd__tapvpwrvgnd_1
XFILLER_39_555 VGND VGND VPWR VPWR sky130_fd_sc_hd__decap_3
XFILLER_54_503 VGND VGND VPWR VPWR sky130_fd_sc_hd__decap_3
XFILLER_66_341 VGND VGND VPWR VPWR sky130_fd_sc_hd__decap_3
X_3185_ _2931_/X _3191_/A2 _3175_/Y _5088_/Q VGND VGND VPWR VPWR _5088_/D sky130_fd_sc_hd__a22o_2
XFILLER_26_227 VGND VGND VPWR VPWR sky130_fd_sc_hd__decap_3
XFILLER_54_536 VGND VGND VPWR VPWR sky130_fd_sc_hd__fill_1
XFILLER_66_385 VGND VGND VPWR VPWR sky130_fd_sc_hd__decap_3
XFILLER_81_322 VGND VGND VPWR VPWR sky130_fd_sc_hd__fill_1
XFILLER_81_355 VGND VGND VPWR VPWR sky130_fd_sc_hd__decap_3
XFILLER_81_333 VGND VGND VPWR VPWR sky130_fd_sc_hd__decap_3
XFILLER_53_19 VGND VGND VPWR VPWR sky130_fd_sc_hd__fill_2
XFILLER_81_399 VGND VGND VPWR VPWR sky130_fd_sc_hd__decap_3
XFILLER_81_388 VGND VGND VPWR VPWR sky130_fd_sc_hd__decap_3
XFILLER_22_433 VGND VGND VPWR VPWR sky130_fd_sc_hd__decap_3
XFILLER_34_282 VGND VGND VPWR VPWR sky130_fd_sc_hd__decap_3
XTAP_TAPCELL_ROW_24_428 VGND VPWR sky130_fd_sc_hd__tapvpwrvgnd_1
XFILLER_22_477 VGND VGND VPWR VPWR sky130_fd_sc_hd__decap_3
X_2969_ _2947_/X _2954_/B _2954_/Y _4901_/Q VGND VGND VPWR VPWR _4901_/D sky130_fd_sc_hd__a22o_2
XTAP_TAPCELL_ROW_60_770 VGND VPWR sky130_fd_sc_hd__tapvpwrvgnd_1
X_4708_ input45/X _4694_/Y _4707_/X _3366_/A VGND VGND VPWR VPWR _5248_/D sky130_fd_sc_hd__o211a_2
X_4639_ _4639_/A VGND VGND VPWR VPWR _4639_/Y sky130_fd_sc_hd__inv_2
XFILLER_1_337 VGND VGND VPWR VPWR sky130_fd_sc_hd__decap_3
XFILLER_1_359 VGND VGND VPWR VPWR sky130_fd_sc_hd__decap_3
XFILLER_89_455 VGND VGND VPWR VPWR sky130_fd_sc_hd__decap_3
XFILLER_89_477 VGND VGND VPWR VPWR sky130_fd_sc_hd__decap_3
XFILLER_76_127 VGND VGND VPWR VPWR sky130_fd_sc_hd__decap_3
XFILLER_45_503 VGND VGND VPWR VPWR sky130_fd_sc_hd__fill_1
XFILLER_57_330 VGND VGND VPWR VPWR sky130_fd_sc_hd__decap_3
XFILLER_27_53 VGND VGND VPWR VPWR sky130_fd_sc_hd__decap_3
XFILLER_57_374 VGND VGND VPWR VPWR sky130_fd_sc_hd__decap_3
XFILLER_57_396 VGND VGND VPWR VPWR sky130_fd_sc_hd__decap_3
XFILLER_27_75 VGND VGND VPWR VPWR sky130_fd_sc_hd__fill_2
XFILLER_25_260 VGND VGND VPWR VPWR sky130_fd_sc_hd__decap_3
XFILLER_27_97 VGND VGND VPWR VPWR sky130_fd_sc_hd__decap_3
XFILLER_60_517 VGND VGND VPWR VPWR sky130_fd_sc_hd__decap_3
XFILLER_13_422 VGND VGND VPWR VPWR sky130_fd_sc_hd__decap_3
XFILLER_13_455 VGND VGND VPWR VPWR sky130_fd_sc_hd__decap_3
XFILLER_43_52 VGND VGND VPWR VPWR sky130_fd_sc_hd__decap_3
XFILLER_43_96 VGND VGND VPWR VPWR sky130_fd_sc_hd__decap_3
XFILLER_4_197 VGND VGND VPWR VPWR sky130_fd_sc_hd__decap_3
XFILLER_68_71 VGND VGND VPWR VPWR sky130_fd_sc_hd__decap_3
XFILLER_67_116 VGND VGND VPWR VPWR sky130_fd_sc_hd__decap_3
XFILLER_48_330 VGND VGND VPWR VPWR sky130_fd_sc_hd__fill_1
XFILLER_36_525 VGND VGND VPWR VPWR sky130_fd_sc_hd__decap_3
XFILLER_48_396 VGND VGND VPWR VPWR sky130_fd_sc_hd__decap_3
XFILLER_63_322 VGND VGND VPWR VPWR sky130_fd_sc_hd__decap_3
XTAP_TAPCELL_ROW_89_1050 VGND VPWR sky130_fd_sc_hd__tapvpwrvgnd_1
XTAP_TAPCELL_ROW_66_829 VGND VPWR sky130_fd_sc_hd__tapvpwrvgnd_1
XFILLER_36_547 VGND VGND VPWR VPWR sky130_fd_sc_hd__decap_3
XFILLER_63_344 VGND VGND VPWR VPWR sky130_fd_sc_hd__decap_3
XFILLER_90_130 VGND VGND VPWR VPWR sky130_fd_sc_hd__decap_3
XFILLER_51_517 VGND VGND VPWR VPWR sky130_fd_sc_hd__fill_2
X_4990_ _5118_/CLK _4990_/D VGND VGND VPWR VPWR _4990_/Q sky130_fd_sc_hd__dfxtp_2
X_3941_ _4051_/A _4267_/S _3941_/C VGND VGND VPWR VPWR _3947_/C sky130_fd_sc_hd__or3_2
X_3872_ _4376_/A _4365_/A _3874_/S VGND VGND VPWR VPWR _3872_/X sky130_fd_sc_hd__mux2_1
XFILLER_90_3 VGND VGND VPWR VPWR sky130_fd_sc_hd__decap_3
X_2823_ _5075_/Q _5059_/Q _5043_/Q _5027_/Q _2854_/S0 _5136_/Q VGND VGND VPWR VPWR
+ _2823_/X sky130_fd_sc_hd__mux4_2
X_2754_ _5137_/Q _2754_/B VGND VGND VPWR VPWR _2754_/X sky130_fd_sc_hd__or2_2
XFILLER_8_470 VGND VGND VPWR VPWR sky130_fd_sc_hd__decap_3
X_2685_ _2642_/Y _2656_/A _4602_/S VGND VGND VPWR VPWR _2686_/A sky130_fd_sc_hd__a21o_2
X_4424_ _4437_/A _4424_/B VGND VGND VPWR VPWR _4666_/B sky130_fd_sc_hd__or2_2
X_4355_ _4390_/A _4390_/B VGND VGND VPWR VPWR _4356_/B sky130_fd_sc_hd__nor2_2
X_3306_ _3315_/B _3304_/X _3305_/X _3338_/B VGND VGND VPWR VPWR _5151_/D sky130_fd_sc_hd__o211a_2
XFILLER_58_138 VGND VGND VPWR VPWR sky130_fd_sc_hd__fill_2
X_4286_ _4286_/A _4286_/B VGND VGND VPWR VPWR _4287_/B sky130_fd_sc_hd__and2_2
XFILLER_39_352 VGND VGND VPWR VPWR sky130_fd_sc_hd__decap_3
XFILLER_73_108 VGND VGND VPWR VPWR sky130_fd_sc_hd__decap_3
X_3237_ _5283_/Q _3338_/B _3237_/C VGND VGND VPWR VPWR _3237_/X sky130_fd_sc_hd__and3_2
XFILLER_66_171 VGND VGND VPWR VPWR sky130_fd_sc_hd__decap_3
XFILLER_73_119 VGND VGND VPWR VPWR sky130_fd_sc_hd__decap_3
X_3168_ _2934_/X _3173_/A2 _3157_/Y _5073_/Q VGND VGND VPWR VPWR _5073_/D sky130_fd_sc_hd__a22o_2
XFILLER_66_182 VGND VGND VPWR VPWR sky130_fd_sc_hd__fill_1
XFILLER_81_130 VGND VGND VPWR VPWR sky130_fd_sc_hd__decap_3
XFILLER_14_208 VGND VGND VPWR VPWR sky130_fd_sc_hd__decap_3
XFILLER_54_377 VGND VGND VPWR VPWR sky130_fd_sc_hd__decap_3
X_3099_ _2947_/X _3084_/B _3084_/Y _5013_/Q VGND VGND VPWR VPWR _5013_/D sky130_fd_sc_hd__a22o_2
XTAP_TAPCELL_ROW_37_553 VGND VPWR sky130_fd_sc_hd__tapvpwrvgnd_1
XFILLER_81_185 VGND VGND VPWR VPWR sky130_fd_sc_hd__fill_2
XFILLER_22_230 VGND VGND VPWR VPWR sky130_fd_sc_hd__decap_3
XFILLER_10_447 VGND VGND VPWR VPWR sky130_fd_sc_hd__decap_3
XFILLER_13_55 VGND VGND VPWR VPWR sky130_fd_sc_hd__fill_1
XTAP_TAPCELL_ROW_9_289 VGND VPWR sky130_fd_sc_hd__tapvpwrvgnd_1
XFILLER_77_447 VGND VGND VPWR VPWR sky130_fd_sc_hd__fill_1
XFILLER_77_425 VGND VGND VPWR VPWR sky130_fd_sc_hd__decap_3
XFILLER_18_525 VGND VGND VPWR VPWR sky130_fd_sc_hd__decap_3
XFILLER_38_85 VGND VGND VPWR VPWR sky130_fd_sc_hd__decap_3
XFILLER_92_417 VGND VGND VPWR VPWR sky130_fd_sc_hd__decap_3
XFILLER_45_322 VGND VGND VPWR VPWR sky130_fd_sc_hd__decap_3
XFILLER_85_491 VGND VGND VPWR VPWR sky130_fd_sc_hd__decap_3
XFILLER_45_388 VGND VGND VPWR VPWR sky130_fd_sc_hd__decap_3
XFILLER_72_152 VGND VGND VPWR VPWR sky130_fd_sc_hd__decap_3
XFILLER_13_252 VGND VGND VPWR VPWR sky130_fd_sc_hd__decap_3
XFILLER_60_358 VGND VGND VPWR VPWR sky130_fd_sc_hd__decap_3
XTAP_TAPCELL_ROW_71_876 VGND VPWR sky130_fd_sc_hd__tapvpwrvgnd_1
XFILLER_9_223 VGND VGND VPWR VPWR sky130_fd_sc_hd__fill_1
XFILLER_70_50 VGND VGND VPWR VPWR sky130_fd_sc_hd__fill_1
XFILLER_9_245 VGND VGND VPWR VPWR sky130_fd_sc_hd__decap_3
XFILLER_70_72 VGND VGND VPWR VPWR sky130_fd_sc_hd__fill_1
XFILLER_70_94 VGND VGND VPWR VPWR sky130_fd_sc_hd__decap_3
Xclkload26 _5286_/CLK VGND VGND VPWR VPWR clkload26/Y sky130_fd_sc_hd__clkinv_2
Xclkload15 _5099_/CLK VGND VGND VPWR VPWR clkload15/Y sky130_fd_sc_hd__bufinv_16
XFILLER_9_289 VGND VGND VPWR VPWR sky130_fd_sc_hd__decap_3
X_2470_ _5078_/Q _5062_/Q _5046_/Q _5030_/Q _2672_/S0 _2672_/S1 VGND VGND VPWR VPWR
+ _2470_/X sky130_fd_sc_hd__mux4_2
XFILLER_5_495 VGND VGND VPWR VPWR sky130_fd_sc_hd__decap_3
X_4140_ _2421_/Y _4854_/B _4121_/X _4139_/X _4692_/A VGND VGND VPWR VPWR _5219_/D
+ sky130_fd_sc_hd__a221oi_2
XFILLER_68_436 VGND VGND VPWR VPWR sky130_fd_sc_hd__fill_2
XFILLER_68_458 VGND VGND VPWR VPWR sky130_fd_sc_hd__decap_3
X_4071_ _4071_/A _4071_/B VGND VGND VPWR VPWR _4071_/Y sky130_fd_sc_hd__nor2_2
XTAP_TAPCELL_ROW_79_954 VGND VPWR sky130_fd_sc_hd__tapvpwrvgnd_1
XFILLER_55_119 VGND VGND VPWR VPWR sky130_fd_sc_hd__decap_3
X_3022_ _2934_/X _3011_/B _3011_/Y _4945_/Q VGND VGND VPWR VPWR _4945_/D sky130_fd_sc_hd__a22o_2
XFILLER_83_428 VGND VGND VPWR VPWR sky130_fd_sc_hd__decap_3
XFILLER_76_480 VGND VGND VPWR VPWR sky130_fd_sc_hd__decap_3
XFILLER_36_322 VGND VGND VPWR VPWR sky130_fd_sc_hd__decap_3
XFILLER_36_344 VGND VGND VPWR VPWR sky130_fd_sc_hd__decap_3
XFILLER_48_193 VGND VGND VPWR VPWR sky130_fd_sc_hd__decap_3
XFILLER_51_303 VGND VGND VPWR VPWR sky130_fd_sc_hd__decap_3
XFILLER_63_152 VGND VGND VPWR VPWR sky130_fd_sc_hd__decap_3
X_4973_ _5117_/CLK _4973_/D VGND VGND VPWR VPWR _4973_/Q sky130_fd_sc_hd__dfxtp_2
XTAP_TAPCELL_ROW_34_523 VGND VPWR sky130_fd_sc_hd__tapvpwrvgnd_1
X_3924_ _4078_/A _3918_/X _3923_/X VGND VGND VPWR VPWR _3924_/X sky130_fd_sc_hd__o21a_2
Xclkload9 clkload9/A VGND VGND VPWR VPWR clkload9/X sky130_fd_sc_hd__clkbuf_4
X_3855_ _4378_/B _4638_/S VGND VGND VPWR VPWR _3855_/Y sky130_fd_sc_hd__nand2_2
X_3786_ _3713_/B _3786_/B VGND VGND VPWR VPWR _4119_/A sky130_fd_sc_hd__and2b_2
X_2806_ _2804_/X _2805_/X _2855_/S VGND VGND VPWR VPWR _2806_/X sky130_fd_sc_hd__mux2_1
X_2737_ _4953_/Q _4937_/Q _4921_/Q _4905_/Q _2818_/S0 _5136_/Q VGND VGND VPWR VPWR
+ _2737_/X sky130_fd_sc_hd__mux4_2
X_2668_ _5167_/Q _4397_/C VGND VGND VPWR VPWR _4633_/S sky130_fd_sc_hd__or2_2
X_4407_ _4407_/A _4407_/B VGND VGND VPWR VPWR _4408_/B sky130_fd_sc_hd__xnor2_2
X_2599_ _4732_/A _4320_/A VGND VGND VPWR VPWR _2599_/Y sky130_fd_sc_hd__nand2_2
XFILLER_59_447 VGND VGND VPWR VPWR sky130_fd_sc_hd__fill_1
X_4338_ _4334_/X _4337_/X _4434_/A VGND VGND VPWR VPWR _4338_/X sky130_fd_sc_hd__a21o_2
XTAP_TAPCELL_ROW_6_259 VGND VPWR sky130_fd_sc_hd__tapvpwrvgnd_1
XFILLER_86_200 VGND VGND VPWR VPWR sky130_fd_sc_hd__decap_3
XFILLER_75_17 VGND VGND VPWR VPWR sky130_fd_sc_hd__decap_3
X_4269_ _4434_/A _3654_/B _2482_/A _3764_/X VGND VGND VPWR VPWR _4271_/A sky130_fd_sc_hd__a2bb2o_2
XFILLER_54_130 VGND VGND VPWR VPWR sky130_fd_sc_hd__decap_3
XFILLER_67_480 VGND VGND VPWR VPWR sky130_fd_sc_hd__decap_3
XFILLER_15_517 VGND VGND VPWR VPWR sky130_fd_sc_hd__decap_3
XFILLER_27_377 VGND VGND VPWR VPWR sky130_fd_sc_hd__decap_3
XFILLER_54_141 VGND VGND VPWR VPWR sky130_fd_sc_hd__decap_3
XFILLER_54_152 VGND VGND VPWR VPWR sky130_fd_sc_hd__decap_3
XFILLER_82_461 VGND VGND VPWR VPWR sky130_fd_sc_hd__decap_3
XFILLER_27_399 VGND VGND VPWR VPWR sky130_fd_sc_hd__decap_3
XFILLER_42_325 VGND VGND VPWR VPWR sky130_fd_sc_hd__fill_1
XFILLER_82_483 VGND VGND VPWR VPWR sky130_fd_sc_hd__fill_2
XFILLER_10_222 VGND VGND VPWR VPWR sky130_fd_sc_hd__decap_3
XFILLER_10_277 VGND VGND VPWR VPWR sky130_fd_sc_hd__decap_3
XFILLER_6_204 VGND VGND VPWR VPWR sky130_fd_sc_hd__decap_3
XFILLER_6_248 VGND VGND VPWR VPWR sky130_fd_sc_hd__decap_3
XFILLER_2_410 VGND VGND VPWR VPWR sky130_fd_sc_hd__fill_2
XFILLER_2_421 VGND VGND VPWR VPWR sky130_fd_sc_hd__fill_2
XFILLER_18_300 VGND VGND VPWR VPWR sky130_fd_sc_hd__decap_3
XFILLER_1_36 VGND VGND VPWR VPWR sky130_fd_sc_hd__decap_3
XFILLER_65_417 VGND VGND VPWR VPWR sky130_fd_sc_hd__decap_3
XTAP_TAPCELL_ROW_76_924 VGND VPWR sky130_fd_sc_hd__tapvpwrvgnd_1
XFILLER_18_333 VGND VGND VPWR VPWR sky130_fd_sc_hd__decap_3
XFILLER_58_480 VGND VGND VPWR VPWR sky130_fd_sc_hd__decap_3
XTAP_TAPCELL_ROW_86_1020 VGND VPWR sky130_fd_sc_hd__tapvpwrvgnd_1
XTAP_TAPCELL_ROW_48_659 VGND VPWR sky130_fd_sc_hd__tapvpwrvgnd_1
XFILLER_73_461 VGND VGND VPWR VPWR sky130_fd_sc_hd__decap_3
XFILLER_60_100 VGND VGND VPWR VPWR sky130_fd_sc_hd__decap_3
XFILLER_73_494 VGND VGND VPWR VPWR sky130_fd_sc_hd__decap_3
XFILLER_60_188 VGND VGND VPWR VPWR sky130_fd_sc_hd__decap_3
XFILLER_81_82 VGND VGND VPWR VPWR sky130_fd_sc_hd__decap_3
X_3640_ _3634_/X _3636_/X _3639_/X _2430_/Y VGND VGND VPWR VPWR _3809_/B sky130_fd_sc_hd__a22o_2
X_3571_ _3571_/A VGND VGND VPWR VPWR _3571_/Y sky130_fd_sc_hd__inv_2
X_2522_ _5070_/Q _5054_/Q _5038_/Q _5022_/Q _2676_/S0 _2676_/S1 VGND VGND VPWR VPWR
+ _2522_/X sky130_fd_sc_hd__mux4_2
XFILLER_5_270 VGND VGND VPWR VPWR sky130_fd_sc_hd__decap_3
X_5241_ _5241_/CLK _5241_/D VGND VGND VPWR VPWR _5241_/Q sky130_fd_sc_hd__dfxtp_2
X_2453_ _4069_/A _4191_/A _2894_/A _4213_/A VGND VGND VPWR VPWR _2453_/X sky130_fd_sc_hd__and4_2
XFILLER_88_509 VGND VGND VPWR VPWR sky130_fd_sc_hd__decap_3
XFILLER_68_200 VGND VGND VPWR VPWR sky130_fd_sc_hd__decap_3
X_5172_ _5263_/CLK _5172_/D VGND VGND VPWR VPWR _5172_/Q sky130_fd_sc_hd__dfxtp_2
X_4123_ _4123_/A _4123_/B VGND VGND VPWR VPWR _4123_/Y sky130_fd_sc_hd__xnor2_2
XFILLER_56_428 VGND VGND VPWR VPWR sky130_fd_sc_hd__fill_1
XFILLER_68_277 VGND VGND VPWR VPWR sky130_fd_sc_hd__decap_3
X_4054_ _4168_/A _4054_/B VGND VGND VPWR VPWR _4055_/D sky130_fd_sc_hd__nor2_2
Xinput2 INSTR_STREAM[10] VGND VGND VPWR VPWR input2/X sky130_fd_sc_hd__clkdlybuf4s25_1
XTAP_TAPCELL_ROW_3_229 VGND VPWR sky130_fd_sc_hd__tapvpwrvgnd_1
XFILLER_83_214 VGND VGND VPWR VPWR sky130_fd_sc_hd__decap_3
XFILLER_49_480 VGND VGND VPWR VPWR sky130_fd_sc_hd__decap_3
X_3005_ _2937_/X _2993_/B _2993_/Y _4930_/Q VGND VGND VPWR VPWR _4930_/D sky130_fd_sc_hd__a22o_2
XFILLER_83_225 VGND VGND VPWR VPWR sky130_fd_sc_hd__fill_1
XFILLER_36_141 VGND VGND VPWR VPWR sky130_fd_sc_hd__decap_3
XFILLER_51_111 VGND VGND VPWR VPWR sky130_fd_sc_hd__fill_1
XTAP_TAPCELL_ROW_19_383 VGND VPWR sky130_fd_sc_hd__tapvpwrvgnd_1
XFILLER_24_358 VGND VGND VPWR VPWR sky130_fd_sc_hd__decap_3
X_4956_ clkload9/A _4956_/D VGND VGND VPWR VPWR _4956_/Q sky130_fd_sc_hd__dfxtp_2
XFILLER_32_380 VGND VGND VPWR VPWR sky130_fd_sc_hd__decap_3
XFILLER_51_199 VGND VGND VPWR VPWR sky130_fd_sc_hd__decap_3
X_4887_ _5083_/CLK _4887_/D VGND VGND VPWR VPWR _4887_/Q sky130_fd_sc_hd__dfxtp_2
X_3907_ _3904_/Y _3906_/X _3961_/S VGND VGND VPWR VPWR _4016_/B sky130_fd_sc_hd__mux2_1
XFILLER_20_553 VGND VGND VPWR VPWR sky130_fd_sc_hd__decap_3
Xclkbuf_leaf_37_CLK clkbuf_leaf_5_CLK/A VGND VGND VPWR VPWR clkload9/A sky130_fd_sc_hd__clkbuf_8
X_3838_ _3838_/A _4144_/A VGND VGND VPWR VPWR _3838_/Y sky130_fd_sc_hd__nor2_2
X_3769_ _2862_/B _3764_/X _3767_/Y _3888_/A _4854_/B VGND VGND VPWR VPWR _3769_/X
+ sky130_fd_sc_hd__a221o_2
XFILLER_87_520 VGND VGND VPWR VPWR sky130_fd_sc_hd__decap_3
XFILLER_19_21 VGND VGND VPWR VPWR sky130_fd_sc_hd__fill_1
XFILLER_87_553 VGND VGND VPWR VPWR sky130_fd_sc_hd__decap_3
XFILLER_86_49 VGND VGND VPWR VPWR sky130_fd_sc_hd__decap_3
XFILLER_19_65 VGND VGND VPWR VPWR sky130_fd_sc_hd__decap_3
XFILLER_47_428 VGND VGND VPWR VPWR sky130_fd_sc_hd__decap_3
XFILLER_74_247 VGND VGND VPWR VPWR sky130_fd_sc_hd__decap_3
XTAP_TAPCELL_ROW_45_629 VGND VPWR sky130_fd_sc_hd__tapvpwrvgnd_1
XFILLER_70_442 VGND VGND VPWR VPWR sky130_fd_sc_hd__fill_2
XFILLER_82_291 VGND VGND VPWR VPWR sky130_fd_sc_hd__decap_3
XFILLER_70_475 VGND VGND VPWR VPWR sky130_fd_sc_hd__fill_1
XTAP_TAPCELL_ROW_81_971 VGND VPWR sky130_fd_sc_hd__tapvpwrvgnd_1
XFILLER_23_391 VGND VGND VPWR VPWR sky130_fd_sc_hd__fill_1
Xclkbuf_leaf_28_CLK clkload0/A VGND VGND VPWR VPWR _5101_/CLK sky130_fd_sc_hd__clkbuf_8
XFILLER_51_74 VGND VGND VPWR VPWR sky130_fd_sc_hd__decap_3
XPHY_EDGE_ROW_2_Left_96 VGND VGND VPWR VPWR sky130_fd_sc_hd__decap_3
XFILLER_65_214 VGND VGND VPWR VPWR sky130_fd_sc_hd__decap_3
XFILLER_93_523 VGND VGND VPWR VPWR sky130_fd_sc_hd__decap_3
XFILLER_93_501 VGND VGND VPWR VPWR sky130_fd_sc_hd__decap_3
XFILLER_18_6 VGND VGND VPWR VPWR sky130_fd_sc_hd__decap_3
XFILLER_65_225 VGND VGND VPWR VPWR sky130_fd_sc_hd__decap_3
XFILLER_93_545 VGND VGND VPWR VPWR sky130_fd_sc_hd__decap_3
XFILLER_76_82 VGND VGND VPWR VPWR sky130_fd_sc_hd__fill_2
XFILLER_46_461 VGND VGND VPWR VPWR sky130_fd_sc_hd__decap_3
XFILLER_53_409 VGND VGND VPWR VPWR sky130_fd_sc_hd__fill_1
XFILLER_46_483 VGND VGND VPWR VPWR sky130_fd_sc_hd__decap_3
XFILLER_80_217 VGND VGND VPWR VPWR sky130_fd_sc_hd__decap_3
XFILLER_33_122 VGND VGND VPWR VPWR sky130_fd_sc_hd__fill_2
XFILLER_33_144 VGND VGND VPWR VPWR sky130_fd_sc_hd__decap_3
XFILLER_61_431 VGND VGND VPWR VPWR sky130_fd_sc_hd__decap_3
X_4810_ _4801_/Y _4803_/B _4800_/A VGND VGND VPWR VPWR _4811_/B sky130_fd_sc_hd__o21ai_2
XFILLER_92_81 VGND VGND VPWR VPWR sky130_fd_sc_hd__decap_3
XFILLER_21_317 VGND VGND VPWR VPWR sky130_fd_sc_hd__decap_3
XFILLER_21_328 VGND VGND VPWR VPWR sky130_fd_sc_hd__decap_3
XTAP_TAPCELL_ROW_16_353 VGND VPWR sky130_fd_sc_hd__tapvpwrvgnd_1
X_4741_ _4742_/A _4742_/B VGND VGND VPWR VPWR _4741_/Y sky130_fd_sc_hd__nand2_2
X_4672_ _4365_/A _3866_/B _3538_/Y VGND VGND VPWR VPWR _4672_/X sky130_fd_sc_hd__o21a_2
Xclkbuf_leaf_19_CLK clkload2/A VGND VGND VPWR VPWR _5241_/CLK sky130_fd_sc_hd__clkbuf_8
X_3623_ _3705_/A _3623_/B VGND VGND VPWR VPWR _3623_/X sky130_fd_sc_hd__or2_2
X_3554_ _3987_/B VGND VGND VPWR VPWR _3554_/Y sky130_fd_sc_hd__inv_2
X_3485_ _3485_/A _3485_/B VGND VGND VPWR VPWR _3487_/A sky130_fd_sc_hd__nor2_2
X_2505_ _5169_/Q _4376_/A VGND VGND VPWR VPWR _4659_/S sky130_fd_sc_hd__or2_2
XFILLER_69_520 VGND VGND VPWR VPWR sky130_fd_sc_hd__fill_2
X_5224_ _5285_/CLK _5224_/D VGND VGND VPWR VPWR _5224_/Q sky130_fd_sc_hd__dfxtp_2
X_2436_ _5283_/Q _3338_/B VGND VGND VPWR VPWR _5286_/D sky130_fd_sc_hd__and2_2
XFILLER_88_317 VGND VGND VPWR VPWR sky130_fd_sc_hd__decap_3
XFILLER_69_531 VGND VGND VPWR VPWR sky130_fd_sc_hd__decap_3
XFILLER_29_417 VGND VGND VPWR VPWR sky130_fd_sc_hd__decap_3
XFILLER_56_19 VGND VGND VPWR VPWR sky130_fd_sc_hd__fill_1
XFILLER_56_203 VGND VGND VPWR VPWR sky130_fd_sc_hd__fill_2
X_5155_ _5283_/CLK _5155_/D VGND VGND VPWR VPWR _5155_/Q sky130_fd_sc_hd__dfxtp_2
XPHY_EDGE_ROW_16_Left_110 VGND VGND VPWR VPWR sky130_fd_sc_hd__decap_3
XFILLER_84_512 VGND VGND VPWR VPWR sky130_fd_sc_hd__decap_3
XFILLER_56_247 VGND VGND VPWR VPWR sky130_fd_sc_hd__decap_3
X_4106_ _4107_/C _4108_/A VGND VGND VPWR VPWR _4106_/Y sky130_fd_sc_hd__nor2_2
X_5086_ _5102_/CLK _5086_/D VGND VGND VPWR VPWR _5086_/Q sky130_fd_sc_hd__dfxtp_2
XFILLER_56_258 VGND VGND VPWR VPWR sky130_fd_sc_hd__decap_3
XFILLER_71_206 VGND VGND VPWR VPWR sky130_fd_sc_hd__fill_1
X_4037_ _4020_/X _4037_/B _4037_/C _4037_/D VGND VGND VPWR VPWR _4037_/X sky130_fd_sc_hd__and4b_2
XFILLER_37_494 VGND VGND VPWR VPWR sky130_fd_sc_hd__decap_3
XFILLER_71_217 VGND VGND VPWR VPWR sky130_fd_sc_hd__decap_3
XFILLER_71_228 VGND VGND VPWR VPWR sky130_fd_sc_hd__decap_3
XFILLER_72_29 VGND VGND VPWR VPWR sky130_fd_sc_hd__decap_3
XFILLER_12_306 VGND VGND VPWR VPWR sky130_fd_sc_hd__fill_2
XFILLER_12_339 VGND VGND VPWR VPWR sky130_fd_sc_hd__decap_3
XFILLER_52_497 VGND VGND VPWR VPWR sky130_fd_sc_hd__decap_3
X_4939_ _5111_/CLK _4939_/D VGND VGND VPWR VPWR _4939_/Q sky130_fd_sc_hd__dfxtp_2
XFILLER_20_350 VGND VGND VPWR VPWR sky130_fd_sc_hd__fill_1
XTAP_TAPCELL_ROW_50_676 VGND VPWR sky130_fd_sc_hd__tapvpwrvgnd_1
XFILLER_4_527 VGND VGND VPWR VPWR sky130_fd_sc_hd__decap_3
XFILLER_87_372 VGND VGND VPWR VPWR sky130_fd_sc_hd__decap_3
XFILLER_75_501 VGND VGND VPWR VPWR sky130_fd_sc_hd__decap_3
XFILLER_47_225 VGND VGND VPWR VPWR sky130_fd_sc_hd__decap_3
XFILLER_28_450 VGND VGND VPWR VPWR sky130_fd_sc_hd__fill_2
XFILLER_62_206 VGND VGND VPWR VPWR sky130_fd_sc_hd__decap_3
XTAP_TAPCELL_ROW_58_754 VGND VPWR sky130_fd_sc_hd__tapvpwrvgnd_1
XFILLER_75_556 VGND VGND VPWR VPWR sky130_fd_sc_hd__fill_2
XFILLER_28_461 VGND VGND VPWR VPWR sky130_fd_sc_hd__decap_3
XFILLER_46_85 VGND VGND VPWR VPWR sky130_fd_sc_hd__fill_2
XFILLER_62_239 VGND VGND VPWR VPWR sky130_fd_sc_hd__fill_1
XFILLER_15_122 VGND VGND VPWR VPWR sky130_fd_sc_hd__decap_3
XFILLER_43_420 VGND VGND VPWR VPWR sky130_fd_sc_hd__fill_2
XFILLER_30_103 VGND VGND VPWR VPWR sky130_fd_sc_hd__fill_2
XFILLER_43_497 VGND VGND VPWR VPWR sky130_fd_sc_hd__decap_3
XFILLER_62_40 VGND VGND VPWR VPWR sky130_fd_sc_hd__fill_2
XTAP_TAPCELL_ROW_13_323 VGND VPWR sky130_fd_sc_hd__tapvpwrvgnd_1
XFILLER_30_147 VGND VGND VPWR VPWR sky130_fd_sc_hd__decap_3
XFILLER_87_9 VGND VGND VPWR VPWR sky130_fd_sc_hd__decap_3
XFILLER_11_372 VGND VGND VPWR VPWR sky130_fd_sc_hd__fill_2
XFILLER_7_310 VGND VGND VPWR VPWR sky130_fd_sc_hd__decap_3
XFILLER_7_68 VGND VGND VPWR VPWR sky130_fd_sc_hd__decap_3
XFILLER_7_376 VGND VGND VPWR VPWR sky130_fd_sc_hd__decap_3
X_3270_ _5142_/Q _3270_/B VGND VGND VPWR VPWR _3270_/Y sky130_fd_sc_hd__nand2_2
XFILLER_87_92 VGND VGND VPWR VPWR sky130_fd_sc_hd__decap_3
XFILLER_16_3 VGND VGND VPWR VPWR sky130_fd_sc_hd__fill_1
XFILLER_66_523 VGND VGND VPWR VPWR sky130_fd_sc_hd__decap_3
Xclkbuf_leaf_8_CLK clkload1/A VGND VGND VPWR VPWR _5177_/CLK sky130_fd_sc_hd__clkbuf_8
XFILLER_66_556 VGND VGND VPWR VPWR sky130_fd_sc_hd__fill_2
XFILLER_19_483 VGND VGND VPWR VPWR sky130_fd_sc_hd__decap_3
XFILLER_34_442 VGND VGND VPWR VPWR sky130_fd_sc_hd__decap_3
XFILLER_21_103 VGND VGND VPWR VPWR sky130_fd_sc_hd__decap_3
XFILLER_34_475 VGND VGND VPWR VPWR sky130_fd_sc_hd__fill_1
XFILLER_21_136 VGND VGND VPWR VPWR sky130_fd_sc_hd__decap_3
XFILLER_61_294 VGND VGND VPWR VPWR sky130_fd_sc_hd__decap_3
XFILLER_21_158 VGND VGND VPWR VPWR sky130_fd_sc_hd__fill_2
XFILLER_21_169 VGND VGND VPWR VPWR sky130_fd_sc_hd__decap_3
X_4724_ input38/X _4694_/Y _4723_/X _3366_/A VGND VGND VPWR VPWR _5256_/D sky130_fd_sc_hd__o211a_2
X_2985_ _2934_/X _2974_/B _2974_/Y _4913_/Q VGND VGND VPWR VPWR _4913_/D sky130_fd_sc_hd__a22o_2
X_4655_ _4654_/X _4607_/X _4682_/S VGND VGND VPWR VPWR _4655_/X sky130_fd_sc_hd__mux2_1
X_4586_ _4584_/X _4585_/Y _4692_/A VGND VGND VPWR VPWR _5233_/D sky130_fd_sc_hd__a21oi_2
X_3606_ _3705_/A _3606_/B VGND VGND VPWR VPWR _3606_/X sky130_fd_sc_hd__or2_2
XFILLER_1_508 VGND VGND VPWR VPWR sky130_fd_sc_hd__decap_3
X_3537_ _3535_/Y _3536_/X _3919_/S VGND VGND VPWR VPWR _3537_/X sky130_fd_sc_hd__mux2_1
XFILLER_88_114 VGND VGND VPWR VPWR sky130_fd_sc_hd__decap_3
X_3468_ _5168_/Q _5149_/Q VGND VGND VPWR VPWR _3469_/B sky130_fd_sc_hd__or2_2
XFILLER_88_158 VGND VGND VPWR VPWR sky130_fd_sc_hd__decap_3
XFILLER_69_361 VGND VGND VPWR VPWR sky130_fd_sc_hd__decap_3
X_5207_ _5208_/CLK _5207_/D VGND VGND VPWR VPWR _5207_/Q sky130_fd_sc_hd__dfxtp_2
X_3399_ _3393_/B _3393_/C _3393_/A VGND VGND VPWR VPWR _3400_/C sky130_fd_sc_hd__a21bo_2
XFILLER_76_309 VGND VGND VPWR VPWR sky130_fd_sc_hd__decap_3
XFILLER_57_534 VGND VGND VPWR VPWR sky130_fd_sc_hd__fill_2
X_5138_ _5177_/CLK _5138_/D VGND VGND VPWR VPWR _5138_/Q sky130_fd_sc_hd__dfxtp_2
XFILLER_57_556 VGND VGND VPWR VPWR sky130_fd_sc_hd__fill_2
XFILLER_72_504 VGND VGND VPWR VPWR sky130_fd_sc_hd__decap_3
XFILLER_84_342 VGND VGND VPWR VPWR sky130_fd_sc_hd__decap_3
XFILLER_44_228 VGND VGND VPWR VPWR sky130_fd_sc_hd__decap_3
X_5069_ _5069_/CLK _5069_/D VGND VGND VPWR VPWR _5069_/Q sky130_fd_sc_hd__dfxtp_2
XTAP_TAPCELL_ROW_55_724 VGND VPWR sky130_fd_sc_hd__tapvpwrvgnd_1
XFILLER_83_28 VGND VGND VPWR VPWR sky130_fd_sc_hd__decap_3
XFILLER_25_420 VGND VGND VPWR VPWR sky130_fd_sc_hd__fill_2
XFILLER_44_239 VGND VGND VPWR VPWR sky130_fd_sc_hd__decap_3
XFILLER_72_548 VGND VGND VPWR VPWR sky130_fd_sc_hd__decap_3
XTAP_TAPCELL_ROW_27_459 VGND VPWR sky130_fd_sc_hd__tapvpwrvgnd_1
XFILLER_25_464 VGND VGND VPWR VPWR sky130_fd_sc_hd__decap_3
XFILLER_52_261 VGND VGND VPWR VPWR sky130_fd_sc_hd__decap_3
XFILLER_12_103 VGND VGND VPWR VPWR sky130_fd_sc_hd__decap_3
XFILLER_12_125 VGND VGND VPWR VPWR sky130_fd_sc_hd__fill_1
XFILLER_25_497 VGND VGND VPWR VPWR sky130_fd_sc_hd__decap_3
XFILLER_40_412 VGND VGND VPWR VPWR sky130_fd_sc_hd__decap_3
XFILLER_40_456 VGND VGND VPWR VPWR sky130_fd_sc_hd__decap_3
XFILLER_8_118 VGND VGND VPWR VPWR sky130_fd_sc_hd__decap_3
XFILLER_32_32 VGND VGND VPWR VPWR sky130_fd_sc_hd__decap_3
XFILLER_32_65 VGND VGND VPWR VPWR sky130_fd_sc_hd__decap_3
XFILLER_40_489 VGND VGND VPWR VPWR sky130_fd_sc_hd__decap_3
XFILLER_4_346 VGND VGND VPWR VPWR sky130_fd_sc_hd__fill_1
XFILLER_48_501 VGND VGND VPWR VPWR sky130_fd_sc_hd__decap_3
XFILLER_48_545 VGND VGND VPWR VPWR sky130_fd_sc_hd__decap_3
XFILLER_75_320 VGND VGND VPWR VPWR sky130_fd_sc_hd__decap_3
XFILLER_63_537 VGND VGND VPWR VPWR sky130_fd_sc_hd__decap_3
XFILLER_75_375 VGND VGND VPWR VPWR sky130_fd_sc_hd__fill_1
XFILLER_90_323 VGND VGND VPWR VPWR sky130_fd_sc_hd__fill_1
XFILLER_28_291 VGND VGND VPWR VPWR sky130_fd_sc_hd__decap_3
XFILLER_90_356 VGND VGND VPWR VPWR sky130_fd_sc_hd__decap_3
XFILLER_31_401 VGND VGND VPWR VPWR sky130_fd_sc_hd__decap_3
XFILLER_50_209 VGND VGND VPWR VPWR sky130_fd_sc_hd__decap_3
XFILLER_43_294 VGND VGND VPWR VPWR sky130_fd_sc_hd__decap_3
XFILLER_85_6 VGND VGND VPWR VPWR sky130_fd_sc_hd__decap_3
X_2770_ _2768_/X _2769_/X _2855_/S VGND VGND VPWR VPWR _2770_/X sky130_fd_sc_hd__mux2_1
X_4440_ _3825_/B _4449_/S _4127_/Y VGND VGND VPWR VPWR _4440_/Y sky130_fd_sc_hd__o21ai_2
XFILLER_7_184 VGND VGND VPWR VPWR sky130_fd_sc_hd__decap_3
XFILLER_7_151 VGND VGND VPWR VPWR sky130_fd_sc_hd__decap_3
X_4371_ _4320_/A _3817_/B _4321_/B VGND VGND VPWR VPWR _4371_/Y sky130_fd_sc_hd__o21ai_2
X_3322_ _5283_/Q _3338_/B _3322_/C VGND VGND VPWR VPWR _3322_/X sky130_fd_sc_hd__and3_2
XFILLER_39_501 VGND VGND VPWR VPWR sky130_fd_sc_hd__decap_3
X_3253_ _5283_/Q _3338_/B _3253_/C VGND VGND VPWR VPWR _3253_/X sky130_fd_sc_hd__and3_2
X_3184_ _2927_/X _3175_/B _3191_/B1 _5087_/Q VGND VGND VPWR VPWR _5087_/D sky130_fd_sc_hd__a22o_2
XFILLER_85_139 VGND VGND VPWR VPWR sky130_fd_sc_hd__decap_3
XFILLER_26_206 VGND VGND VPWR VPWR sky130_fd_sc_hd__decap_3
XFILLER_54_515 VGND VGND VPWR VPWR sky130_fd_sc_hd__decap_3
XFILLER_66_397 VGND VGND VPWR VPWR sky130_fd_sc_hd__decap_3
XFILLER_81_367 VGND VGND VPWR VPWR sky130_fd_sc_hd__decap_3
XFILLER_34_294 VGND VGND VPWR VPWR sky130_fd_sc_hd__decap_3
XTAP_TAPCELL_ROW_24_429 VGND VPWR sky130_fd_sc_hd__tapvpwrvgnd_1
XFILLER_22_489 VGND VGND VPWR VPWR sky130_fd_sc_hd__fill_1
X_2968_ _2944_/X _2954_/B _2954_/Y _4900_/Q VGND VGND VPWR VPWR _4900_/D sky130_fd_sc_hd__a22o_2
XTAP_TAPCELL_ROW_60_771 VGND VPWR sky130_fd_sc_hd__tapvpwrvgnd_1
X_4707_ _5248_/Q _4725_/B VGND VGND VPWR VPWR _4707_/X sky130_fd_sc_hd__or2_2
X_4638_ _3642_/A _4397_/C _4638_/S VGND VGND VPWR VPWR _4639_/A sky130_fd_sc_hd__mux2_1
X_2899_ _5192_/Q _3046_/C _5193_/Q VGND VGND VPWR VPWR _3192_/A sky130_fd_sc_hd__or3b_2
X_4569_ _5232_/Q _4854_/B VGND VGND VPWR VPWR _4569_/Y sky130_fd_sc_hd__nand2_2
XFILLER_76_106 VGND VGND VPWR VPWR sky130_fd_sc_hd__decap_3
XFILLER_91_109 VGND VGND VPWR VPWR sky130_fd_sc_hd__decap_3
XFILLER_17_228 VGND VGND VPWR VPWR sky130_fd_sc_hd__decap_3
XFILLER_45_537 VGND VGND VPWR VPWR sky130_fd_sc_hd__decap_3
XFILLER_72_345 VGND VGND VPWR VPWR sky130_fd_sc_hd__decap_3
XFILLER_84_183 VGND VGND VPWR VPWR sky130_fd_sc_hd__fill_1
XFILLER_32_209 VGND VGND VPWR VPWR sky130_fd_sc_hd__decap_3
XFILLER_60_529 VGND VGND VPWR VPWR sky130_fd_sc_hd__decap_3
XFILLER_13_434 VGND VGND VPWR VPWR sky130_fd_sc_hd__fill_1
XFILLER_40_253 VGND VGND VPWR VPWR sky130_fd_sc_hd__decap_3
XFILLER_9_416 VGND VGND VPWR VPWR sky130_fd_sc_hd__decap_3
XFILLER_13_489 VGND VGND VPWR VPWR sky130_fd_sc_hd__fill_2
XFILLER_9_449 VGND VGND VPWR VPWR sky130_fd_sc_hd__decap_3
XFILLER_4_25 VGND VGND VPWR VPWR sky130_fd_sc_hd__decap_3
XFILLER_0_360 VGND VGND VPWR VPWR sky130_fd_sc_hd__decap_3
XFILLER_0_382 VGND VGND VPWR VPWR sky130_fd_sc_hd__decap_3
XFILLER_67_128 VGND VGND VPWR VPWR sky130_fd_sc_hd__decap_3
XFILLER_68_83 VGND VGND VPWR VPWR sky130_fd_sc_hd__fill_1
XFILLER_0_393 VGND VGND VPWR VPWR sky130_fd_sc_hd__decap_3
XFILLER_75_161 VGND VGND VPWR VPWR sky130_fd_sc_hd__decap_3
XTAP_TAPCELL_ROW_89_1051 VGND VPWR sky130_fd_sc_hd__tapvpwrvgnd_1
XFILLER_84_60 VGND VGND VPWR VPWR sky130_fd_sc_hd__decap_3
XFILLER_63_356 VGND VGND VPWR VPWR sky130_fd_sc_hd__decap_3
X_3940_ _3939_/Y _3760_/A _3975_/S VGND VGND VPWR VPWR _3941_/C sky130_fd_sc_hd__mux2_1
XFILLER_90_197 VGND VGND VPWR VPWR sky130_fd_sc_hd__decap_3
XFILLER_16_294 VGND VGND VPWR VPWR sky130_fd_sc_hd__decap_3
XFILLER_31_220 VGND VGND VPWR VPWR sky130_fd_sc_hd__decap_3
XFILLER_31_231 VGND VGND VPWR VPWR sky130_fd_sc_hd__decap_3
X_3871_ _4078_/A _3859_/X _3870_/X _4225_/A VGND VGND VPWR VPWR _3871_/X sky130_fd_sc_hd__o22a_2
X_2822_ _4899_/Q _4883_/Q _5107_/Q _5091_/Q _2851_/S0 _2854_/S1 VGND VGND VPWR VPWR
+ _2822_/X sky130_fd_sc_hd__mux4_2
XFILLER_83_3 VGND VGND VPWR VPWR sky130_fd_sc_hd__decap_3
X_2753_ _5115_/Q _5003_/Q _4987_/Q _4971_/Q _2818_/S0 _5136_/Q VGND VGND VPWR VPWR
+ _2754_/B sky130_fd_sc_hd__mux4_2
X_2684_ _2684_/A _4174_/B _4145_/A _2877_/A VGND VGND VPWR VPWR _2888_/B sky130_fd_sc_hd__or4b_2
X_4423_ _4424_/B VGND VGND VPWR VPWR _4436_/B sky130_fd_sc_hd__inv_2
X_4354_ _4354_/A _4354_/B VGND VGND VPWR VPWR _4360_/A sky130_fd_sc_hd__nand2_2
XFILLER_58_106 VGND VGND VPWR VPWR sky130_fd_sc_hd__fill_2
X_3305_ _5272_/Q _3305_/B VGND VGND VPWR VPWR _3305_/X sky130_fd_sc_hd__or2_2
XFILLER_86_404 VGND VGND VPWR VPWR sky130_fd_sc_hd__decap_3
XFILLER_58_128 VGND VGND VPWR VPWR sky130_fd_sc_hd__fill_1
X_4285_ _4284_/X _4281_/Y _4309_/S VGND VGND VPWR VPWR _4487_/A sky130_fd_sc_hd__mux2_1
XFILLER_86_437 VGND VGND VPWR VPWR sky130_fd_sc_hd__decap_3
XFILLER_86_426 VGND VGND VPWR VPWR sky130_fd_sc_hd__decap_3
X_3236_ _5174_/Q _4868_/A2 _4870_/B1 _3235_/X VGND VGND VPWR VPWR _5129_/D sky130_fd_sc_hd__o22a_2
XFILLER_27_526 VGND VGND VPWR VPWR sky130_fd_sc_hd__decap_3
XFILLER_39_364 VGND VGND VPWR VPWR sky130_fd_sc_hd__fill_1
XFILLER_39_375 VGND VGND VPWR VPWR sky130_fd_sc_hd__decap_3
XFILLER_54_301 VGND VGND VPWR VPWR sky130_fd_sc_hd__decap_3
X_3167_ _2931_/X _3173_/A2 _3157_/Y _5072_/Q VGND VGND VPWR VPWR _5072_/D sky130_fd_sc_hd__a22o_2
XFILLER_54_323 VGND VGND VPWR VPWR sky130_fd_sc_hd__fill_1
XFILLER_54_345 VGND VGND VPWR VPWR sky130_fd_sc_hd__decap_3
X_3098_ _2944_/X _3084_/B _3084_/Y _5012_/Q VGND VGND VPWR VPWR _5012_/D sky130_fd_sc_hd__a22o_2
XFILLER_42_518 VGND VGND VPWR VPWR sky130_fd_sc_hd__decap_3
XTAP_TAPCELL_ROW_37_554 VGND VPWR sky130_fd_sc_hd__tapvpwrvgnd_1
XFILLER_81_153 VGND VGND VPWR VPWR sky130_fd_sc_hd__decap_3
XFILLER_54_389 VGND VGND VPWR VPWR sky130_fd_sc_hd__decap_3
XFILLER_13_23 VGND VGND VPWR VPWR sky130_fd_sc_hd__decap_3
XFILLER_22_253 VGND VGND VPWR VPWR sky130_fd_sc_hd__decap_3
XFILLER_6_408 VGND VGND VPWR VPWR sky130_fd_sc_hd__decap_3
XFILLER_89_49 VGND VGND VPWR VPWR sky130_fd_sc_hd__decap_3
XFILLER_89_27 VGND VGND VPWR VPWR sky130_fd_sc_hd__decap_3
XFILLER_1_102 VGND VGND VPWR VPWR sky130_fd_sc_hd__fill_2
XPHY_EDGE_ROW_8_Left_102 VGND VGND VPWR VPWR sky130_fd_sc_hd__decap_3
XFILLER_89_220 VGND VGND VPWR VPWR sky130_fd_sc_hd__decap_3
XFILLER_77_404 VGND VGND VPWR VPWR sky130_fd_sc_hd__decap_3
XFILLER_49_139 VGND VGND VPWR VPWR sky130_fd_sc_hd__decap_3
XFILLER_89_286 VGND VGND VPWR VPWR sky130_fd_sc_hd__decap_3
XFILLER_77_437 VGND VGND VPWR VPWR sky130_fd_sc_hd__decap_3
XFILLER_92_407 VGND VGND VPWR VPWR sky130_fd_sc_hd__decap_3
XFILLER_38_64 VGND VGND VPWR VPWR sky130_fd_sc_hd__decap_3
XFILLER_64_109 VGND VGND VPWR VPWR sky130_fd_sc_hd__decap_3
XFILLER_57_194 VGND VGND VPWR VPWR sky130_fd_sc_hd__decap_3
XFILLER_54_52 VGND VGND VPWR VPWR sky130_fd_sc_hd__decap_3
XFILLER_54_63 VGND VGND VPWR VPWR sky130_fd_sc_hd__decap_3
XFILLER_72_186 VGND VGND VPWR VPWR sky130_fd_sc_hd__decap_3
XTAP_TAPCELL_ROW_0_190 VGND VPWR sky130_fd_sc_hd__tapvpwrvgnd_1
XFILLER_54_85 VGND VGND VPWR VPWR sky130_fd_sc_hd__decap_3
XTAP_TAPCELL_ROW_71_877 VGND VPWR sky130_fd_sc_hd__tapvpwrvgnd_1
XFILLER_13_275 VGND VGND VPWR VPWR sky130_fd_sc_hd__decap_3
Xclkload16 _5101_/CLK VGND VGND VPWR VPWR clkload16/Y sky130_fd_sc_hd__clkinv_2
Xclkload27 _5271_/CLK VGND VGND VPWR VPWR clkload27/Y sky130_fd_sc_hd__clkinv_2
XFILLER_5_441 VGND VGND VPWR VPWR sky130_fd_sc_hd__decap_3
XFILLER_5_452 VGND VGND VPWR VPWR sky130_fd_sc_hd__decap_3
XFILLER_5_474 VGND VGND VPWR VPWR sky130_fd_sc_hd__decap_3
XFILLER_68_404 VGND VGND VPWR VPWR sky130_fd_sc_hd__decap_3
XFILLER_79_82 VGND VGND VPWR VPWR sky130_fd_sc_hd__fill_2
X_4070_ _4070_/A _4070_/B VGND VGND VPWR VPWR _4070_/X sky130_fd_sc_hd__or2_2
XTAP_TAPCELL_ROW_79_955 VGND VPWR sky130_fd_sc_hd__tapvpwrvgnd_1
XFILLER_83_407 VGND VGND VPWR VPWR sky130_fd_sc_hd__decap_3
XFILLER_48_150 VGND VGND VPWR VPWR sky130_fd_sc_hd__fill_1
X_3021_ _2931_/X _3011_/B _3011_/Y _4944_/Q VGND VGND VPWR VPWR _4944_/D sky130_fd_sc_hd__a22o_2
XFILLER_36_312 VGND VGND VPWR VPWR sky130_fd_sc_hd__fill_2
XFILLER_76_492 VGND VGND VPWR VPWR sky130_fd_sc_hd__decap_3
XFILLER_24_507 VGND VGND VPWR VPWR sky130_fd_sc_hd__fill_2
XFILLER_24_518 VGND VGND VPWR VPWR sky130_fd_sc_hd__decap_3
XFILLER_51_315 VGND VGND VPWR VPWR sky130_fd_sc_hd__decap_3
XFILLER_51_337 VGND VGND VPWR VPWR sky130_fd_sc_hd__decap_3
XFILLER_63_186 VGND VGND VPWR VPWR sky130_fd_sc_hd__fill_2
X_4972_ _5117_/CLK _4972_/D VGND VGND VPWR VPWR _4972_/Q sky130_fd_sc_hd__dfxtp_2
XTAP_TAPCELL_ROW_34_524 VGND VPWR sky130_fd_sc_hd__tapvpwrvgnd_1
XFILLER_91_495 VGND VGND VPWR VPWR sky130_fd_sc_hd__decap_3
X_3923_ _4078_/B _3920_/Y _3922_/X _4225_/A VGND VGND VPWR VPWR _3923_/X sky130_fd_sc_hd__a211o_2
X_3854_ _3851_/Y _3853_/Y _3969_/S VGND VGND VPWR VPWR _3854_/X sky130_fd_sc_hd__mux2_1
X_2805_ _5073_/Q _5057_/Q _5041_/Q _5025_/Q _2854_/S0 _5136_/Q VGND VGND VPWR VPWR
+ _2805_/X sky130_fd_sc_hd__mux4_2
X_3785_ _4147_/A _3785_/B VGND VGND VPWR VPWR _3785_/Y sky130_fd_sc_hd__nor2_2
X_2736_ _5137_/Q _2736_/B VGND VGND VPWR VPWR _2736_/X sky130_fd_sc_hd__or2_2
X_2667_ _5167_/Q _4397_/C VGND VGND VPWR VPWR _2670_/A sky130_fd_sc_hd__nand2_2
X_4406_ _4407_/B _4407_/A VGND VGND VPWR VPWR _4406_/X sky130_fd_sc_hd__and2b_2
X_2598_ _4732_/A _4320_/A VGND VGND VPWR VPWR _2601_/A sky130_fd_sc_hd__and2_2
X_4337_ _4393_/D _4327_/A _4336_/Y _4335_/Y _4320_/B VGND VGND VPWR VPWR _4337_/X
+ sky130_fd_sc_hd__o32a_2
X_4268_ _3755_/Y _4267_/X _4224_/B _4082_/X VGND VGND VPWR VPWR _4268_/X sky130_fd_sc_hd__o2bb2a_2
XFILLER_74_407 VGND VGND VPWR VPWR sky130_fd_sc_hd__decap_3
X_3219_ _2924_/X _3227_/A2 _3211_/Y _5118_/Q VGND VGND VPWR VPWR _5118_/D sky130_fd_sc_hd__a22o_2
XFILLER_27_334 VGND VGND VPWR VPWR sky130_fd_sc_hd__fill_2
X_4199_ _4200_/A _4200_/B _4199_/C _4199_/D VGND VGND VPWR VPWR _4199_/X sky130_fd_sc_hd__and4bb_2
XFILLER_15_529 VGND VGND VPWR VPWR sky130_fd_sc_hd__decap_3
XFILLER_54_164 VGND VGND VPWR VPWR sky130_fd_sc_hd__fill_2
XFILLER_54_186 VGND VGND VPWR VPWR sky130_fd_sc_hd__decap_3
XFILLER_54_197 VGND VGND VPWR VPWR sky130_fd_sc_hd__decap_3
XFILLER_82_495 VGND VGND VPWR VPWR sky130_fd_sc_hd__decap_3
XFILLER_82_473 VGND VGND VPWR VPWR sky130_fd_sc_hd__decap_3
XFILLER_23_551 VGND VGND VPWR VPWR sky130_fd_sc_hd__decap_3
XFILLER_42_359 VGND VGND VPWR VPWR sky130_fd_sc_hd__decap_3
XFILLER_24_88 VGND VGND VPWR VPWR sky130_fd_sc_hd__decap_3
XFILLER_24_99 VGND VGND VPWR VPWR sky130_fd_sc_hd__fill_2
XFILLER_10_256 VGND VGND VPWR VPWR sky130_fd_sc_hd__decap_3
XFILLER_6_216 VGND VGND VPWR VPWR sky130_fd_sc_hd__decap_3
XFILLER_6_238 VGND VGND VPWR VPWR sky130_fd_sc_hd__fill_2
XFILLER_77_223 VGND VGND VPWR VPWR sky130_fd_sc_hd__fill_1
XFILLER_77_234 VGND VGND VPWR VPWR sky130_fd_sc_hd__decap_3
XFILLER_1_15 VGND VGND VPWR VPWR sky130_fd_sc_hd__fill_1
XFILLER_65_429 VGND VGND VPWR VPWR sky130_fd_sc_hd__fill_1
XTAP_TAPCELL_ROW_76_925 VGND VPWR sky130_fd_sc_hd__tapvpwrvgnd_1
XTAP_TAPCELL_ROW_86_1021 VGND VPWR sky130_fd_sc_hd__tapvpwrvgnd_1
XFILLER_18_345 VGND VGND VPWR VPWR sky130_fd_sc_hd__fill_2
XFILLER_73_440 VGND VGND VPWR VPWR sky130_fd_sc_hd__decap_3
XFILLER_33_315 VGND VGND VPWR VPWR sky130_fd_sc_hd__decap_3
XFILLER_33_337 VGND VGND VPWR VPWR sky130_fd_sc_hd__decap_3
XFILLER_60_112 VGND VGND VPWR VPWR sky130_fd_sc_hd__decap_3
XFILLER_33_348 VGND VGND VPWR VPWR sky130_fd_sc_hd__decap_3
XFILLER_81_94 VGND VGND VPWR VPWR sky130_fd_sc_hd__decap_3
X_3570_ _4393_/B _4393_/A _3905_/B VGND VGND VPWR VPWR _3571_/A sky130_fd_sc_hd__mux2_1
X_2521_ _2890_/A _2521_/B VGND VGND VPWR VPWR _4192_/A sky130_fd_sc_hd__or2_2
X_5240_ _5241_/CLK _5240_/D VGND VGND VPWR VPWR _5240_/Q sky130_fd_sc_hd__dfxtp_2
X_2452_ _3884_/D _3891_/B VGND VGND VPWR VPWR _4213_/A sky130_fd_sc_hd__or2_2
X_5171_ _5177_/CLK _5171_/D VGND VGND VPWR VPWR _5171_/Q sky130_fd_sc_hd__dfxtp_2
XPHY_EDGE_ROW_18_Right_18 VGND VGND VPWR VPWR sky130_fd_sc_hd__decap_3
XFILLER_68_256 VGND VGND VPWR VPWR sky130_fd_sc_hd__decap_3
X_4122_ _4199_/D _4115_/B _4155_/B VGND VGND VPWR VPWR _4123_/B sky130_fd_sc_hd__a21oi_2
XFILLER_28_109 VGND VGND VPWR VPWR sky130_fd_sc_hd__fill_1
XFILLER_56_407 VGND VGND VPWR VPWR sky130_fd_sc_hd__decap_3
X_4053_ _3831_/A _4278_/B _3885_/Y _4062_/A _4052_/X VGND VGND VPWR VPWR _4054_/B
+ sky130_fd_sc_hd__a221o_2
XFILLER_83_204 VGND VGND VPWR VPWR sky130_fd_sc_hd__fill_2
Xinput3 INSTR_STREAM[11] VGND VGND VPWR VPWR input3/X sky130_fd_sc_hd__clkdlybuf4s25_1
X_3004_ _2934_/X _2992_/Y _2993_/Y _4929_/Q VGND VGND VPWR VPWR _4929_/D sky130_fd_sc_hd__a22o_2
XFILLER_83_237 VGND VGND VPWR VPWR sky130_fd_sc_hd__decap_3
XFILLER_24_304 VGND VGND VPWR VPWR sky130_fd_sc_hd__fill_1
XFILLER_64_473 VGND VGND VPWR VPWR sky130_fd_sc_hd__decap_3
XFILLER_24_337 VGND VGND VPWR VPWR sky130_fd_sc_hd__decap_3
XFILLER_36_197 VGND VGND VPWR VPWR sky130_fd_sc_hd__fill_2
XFILLER_51_134 VGND VGND VPWR VPWR sky130_fd_sc_hd__decap_3
X_4955_ _5111_/CLK _4955_/D VGND VGND VPWR VPWR _4955_/Q sky130_fd_sc_hd__dfxtp_2
XTAP_TAPCELL_ROW_19_384 VGND VPWR sky130_fd_sc_hd__tapvpwrvgnd_1
XPHY_EDGE_ROW_27_Right_27 VGND VGND VPWR VPWR sky130_fd_sc_hd__decap_3
X_3906_ _4079_/A _3905_/B _3905_/Y VGND VGND VPWR VPWR _3906_/X sky130_fd_sc_hd__a21o_2
XFILLER_20_521 VGND VGND VPWR VPWR sky130_fd_sc_hd__decap_3
X_4886_ _5107_/CLK _4886_/D VGND VGND VPWR VPWR _4886_/Q sky130_fd_sc_hd__dfxtp_2
X_3837_ _5165_/Q _4147_/A _4126_/A VGND VGND VPWR VPWR _4144_/A sky130_fd_sc_hd__o21a_2
X_3768_ _3884_/D _3886_/B VGND VGND VPWR VPWR _4434_/A sky130_fd_sc_hd__or2_2
X_2719_ _4951_/Q _4935_/Q _4919_/Q _4903_/Q _5135_/Q _5136_/Q VGND VGND VPWR VPWR
+ _2719_/X sky130_fd_sc_hd__mux4_2
X_3699_ _3693_/X _3695_/X _3698_/X _2430_/Y VGND VGND VPWR VPWR _3785_/B sky130_fd_sc_hd__a22o_2
XPHY_EDGE_ROW_36_Right_36 VGND VGND VPWR VPWR sky130_fd_sc_hd__decap_3
XFILLER_87_532 VGND VGND VPWR VPWR sky130_fd_sc_hd__decap_3
XFILLER_19_109 VGND VGND VPWR VPWR sky130_fd_sc_hd__decap_3
XFILLER_59_256 VGND VGND VPWR VPWR sky130_fd_sc_hd__decap_3
XFILLER_19_77 VGND VGND VPWR VPWR sky130_fd_sc_hd__decap_3
XFILLER_74_215 VGND VGND VPWR VPWR sky130_fd_sc_hd__decap_3
XFILLER_27_153 VGND VGND VPWR VPWR sky130_fd_sc_hd__decap_3
XFILLER_27_164 VGND VGND VPWR VPWR sky130_fd_sc_hd__decap_3
XFILLER_35_32 VGND VGND VPWR VPWR sky130_fd_sc_hd__fill_2
XFILLER_70_421 VGND VGND VPWR VPWR sky130_fd_sc_hd__decap_3
XPHY_EDGE_ROW_45_Right_45 VGND VGND VPWR VPWR sky130_fd_sc_hd__decap_3
XFILLER_82_281 VGND VGND VPWR VPWR sky130_fd_sc_hd__fill_1
XFILLER_15_337 VGND VGND VPWR VPWR sky130_fd_sc_hd__decap_3
XFILLER_27_197 VGND VGND VPWR VPWR sky130_fd_sc_hd__decap_3
XFILLER_42_134 VGND VGND VPWR VPWR sky130_fd_sc_hd__decap_3
XFILLER_30_307 VGND VGND VPWR VPWR sky130_fd_sc_hd__fill_1
XFILLER_70_487 VGND VGND VPWR VPWR sky130_fd_sc_hd__decap_3
XTAP_TAPCELL_ROW_81_972 VGND VPWR sky130_fd_sc_hd__tapvpwrvgnd_1
XFILLER_11_510 VGND VGND VPWR VPWR sky130_fd_sc_hd__decap_3
XFILLER_30_329 VGND VGND VPWR VPWR sky130_fd_sc_hd__fill_1
XFILLER_51_86 VGND VGND VPWR VPWR sky130_fd_sc_hd__fill_2
XPHY_EDGE_ROW_54_Right_54 VGND VGND VPWR VPWR sky130_fd_sc_hd__decap_3
XFILLER_32_9 VGND VGND VPWR VPWR sky130_fd_sc_hd__fill_1
XTAP_TAPCELL_ROW_92_1080 VGND VPWR sky130_fd_sc_hd__tapvpwrvgnd_1
XFILLER_78_510 VGND VGND VPWR VPWR sky130_fd_sc_hd__decap_3
XFILLER_78_554 VGND VGND VPWR VPWR sky130_fd_sc_hd__decap_3
XFILLER_76_94 VGND VGND VPWR VPWR sky130_fd_sc_hd__decap_3
XPHY_EDGE_ROW_63_Right_63 VGND VGND VPWR VPWR sky130_fd_sc_hd__decap_3
XFILLER_93_557 VGND VGND VPWR VPWR sky130_fd_sc_hd__fill_1
XFILLER_18_153 VGND VGND VPWR VPWR sky130_fd_sc_hd__decap_3
XFILLER_61_421 VGND VGND VPWR VPWR sky130_fd_sc_hd__fill_2
XFILLER_92_60 VGND VGND VPWR VPWR sky130_fd_sc_hd__decap_3
XFILLER_33_167 VGND VGND VPWR VPWR sky130_fd_sc_hd__fill_1
XFILLER_61_476 VGND VGND VPWR VPWR sky130_fd_sc_hd__decap_3
XTAP_TAPCELL_ROW_16_354 VGND VPWR sky130_fd_sc_hd__tapvpwrvgnd_1
X_4740_ _4734_/A _4734_/B _4731_/X VGND VGND VPWR VPWR _4742_/B sky130_fd_sc_hd__a21o_2
X_4671_ _4671_/A _4671_/B _4671_/C VGND VGND VPWR VPWR _4671_/X sky130_fd_sc_hd__and3_2
X_3622_ _4900_/Q _4884_/Q _5108_/Q _5092_/Q _3706_/S0 _3706_/S1 VGND VGND VPWR VPWR
+ _3623_/B sky130_fd_sc_hd__mux4_2
XPHY_EDGE_ROW_72_Right_72 VGND VGND VPWR VPWR sky130_fd_sc_hd__decap_3
X_3553_ _3550_/X _3552_/X _3919_/S VGND VGND VPWR VPWR _3987_/B sky130_fd_sc_hd__mux2_1
X_3484_ _5170_/Q _5151_/Q VGND VGND VPWR VPWR _3485_/B sky130_fd_sc_hd__nor2_2
X_2504_ _4376_/A VGND VGND VPWR VPWR _4241_/A sky130_fd_sc_hd__inv_2
XFILLER_88_307 VGND VGND VPWR VPWR sky130_fd_sc_hd__fill_1
X_5223_ _5257_/CLK _5223_/D VGND VGND VPWR VPWR _5223_/Q sky130_fd_sc_hd__dfxtp_2
X_2435_ _5138_/Q VGND VGND VPWR VPWR _2435_/Y sky130_fd_sc_hd__inv_2
XFILLER_88_329 VGND VGND VPWR VPWR sky130_fd_sc_hd__decap_3
X_5154_ _5260_/CLK _5154_/D VGND VGND VPWR VPWR _5154_/Q sky130_fd_sc_hd__dfxtp_2
X_4105_ _3762_/B _4267_/S _4224_/B _4102_/X VGND VGND VPWR VPWR _4108_/A sky130_fd_sc_hd__o31ai_2
XFILLER_29_429 VGND VGND VPWR VPWR sky130_fd_sc_hd__decap_3
X_5085_ _5101_/CLK _5085_/D VGND VGND VPWR VPWR _5085_/Q sky130_fd_sc_hd__dfxtp_2
XPHY_EDGE_ROW_81_Right_81 VGND VGND VPWR VPWR sky130_fd_sc_hd__decap_3
X_4036_ _3963_/A _4018_/X _4017_/X VGND VGND VPWR VPWR _4037_/C sky130_fd_sc_hd__a21oi_2
XFILLER_52_410 VGND VGND VPWR VPWR sky130_fd_sc_hd__decap_3
XFILLER_52_421 VGND VGND VPWR VPWR sky130_fd_sc_hd__decap_3
XFILLER_52_432 VGND VGND VPWR VPWR sky130_fd_sc_hd__decap_3
XFILLER_12_318 VGND VGND VPWR VPWR sky130_fd_sc_hd__decap_3
X_4938_ _5111_/CLK _4938_/D VGND VGND VPWR VPWR _4938_/Q sky130_fd_sc_hd__dfxtp_2
X_4869_ _5178_/Q _3229_/Y _4870_/B1 _3251_/X VGND VGND VPWR VPWR _5178_/D sky130_fd_sc_hd__o22a_2
XFILLER_20_362 VGND VGND VPWR VPWR sky130_fd_sc_hd__fill_2
XFILLER_20_384 VGND VGND VPWR VPWR sky130_fd_sc_hd__decap_3
XTAP_TAPCELL_ROW_50_677 VGND VPWR sky130_fd_sc_hd__tapvpwrvgnd_1
XPHY_EDGE_ROW_90_Right_90 VGND VGND VPWR VPWR sky130_fd_sc_hd__decap_3
XFILLER_4_506 VGND VGND VPWR VPWR sky130_fd_sc_hd__decap_3
XFILLER_21_89 VGND VGND VPWR VPWR sky130_fd_sc_hd__decap_3
XFILLER_4_539 VGND VGND VPWR VPWR sky130_fd_sc_hd__decap_3
XFILLER_87_351 VGND VGND VPWR VPWR sky130_fd_sc_hd__decap_3
XFILLER_47_237 VGND VGND VPWR VPWR sky130_fd_sc_hd__decap_3
XTAP_TAPCELL_ROW_58_755 VGND VPWR sky130_fd_sc_hd__tapvpwrvgnd_1
XFILLER_46_75 VGND VGND VPWR VPWR sky130_fd_sc_hd__fill_1
XFILLER_55_270 VGND VGND VPWR VPWR sky130_fd_sc_hd__decap_3
XFILLER_62_218 VGND VGND VPWR VPWR sky130_fd_sc_hd__fill_1
XFILLER_15_134 VGND VGND VPWR VPWR sky130_fd_sc_hd__decap_3
XFILLER_55_292 VGND VGND VPWR VPWR sky130_fd_sc_hd__decap_3
XFILLER_15_167 VGND VGND VPWR VPWR sky130_fd_sc_hd__fill_1
XFILLER_15_178 VGND VGND VPWR VPWR sky130_fd_sc_hd__decap_3
XFILLER_43_476 VGND VGND VPWR VPWR sky130_fd_sc_hd__decap_3
XFILLER_70_251 VGND VGND VPWR VPWR sky130_fd_sc_hd__fill_1
XFILLER_70_284 VGND VGND VPWR VPWR sky130_fd_sc_hd__decap_3
XTAP_TAPCELL_ROW_13_324 VGND VPWR sky130_fd_sc_hd__tapvpwrvgnd_1
XFILLER_7_25 VGND VGND VPWR VPWR sky130_fd_sc_hd__decap_3
XFILLER_7_344 VGND VGND VPWR VPWR sky130_fd_sc_hd__decap_3
XFILLER_3_550 VGND VGND VPWR VPWR sky130_fd_sc_hd__decap_3
XFILLER_30_6 VGND VGND VPWR VPWR sky130_fd_sc_hd__decap_3
XFILLER_87_60 VGND VGND VPWR VPWR sky130_fd_sc_hd__decap_3
XFILLER_78_351 VGND VGND VPWR VPWR sky130_fd_sc_hd__decap_3
XFILLER_81_505 VGND VGND VPWR VPWR sky130_fd_sc_hd__decap_3
XFILLER_81_538 VGND VGND VPWR VPWR sky130_fd_sc_hd__decap_3
XFILLER_19_495 VGND VGND VPWR VPWR sky130_fd_sc_hd__decap_3
XFILLER_34_421 VGND VGND VPWR VPWR sky130_fd_sc_hd__decap_3
XFILLER_46_281 VGND VGND VPWR VPWR sky130_fd_sc_hd__decap_3
XFILLER_34_454 VGND VGND VPWR VPWR sky130_fd_sc_hd__decap_3
XFILLER_61_262 VGND VGND VPWR VPWR sky130_fd_sc_hd__decap_3
XFILLER_34_498 VGND VGND VPWR VPWR sky130_fd_sc_hd__decap_3
XFILLER_61_284 VGND VGND VPWR VPWR sky130_fd_sc_hd__decap_3
X_2984_ _2931_/X _2974_/B _2974_/Y _4912_/Q VGND VGND VPWR VPWR _4912_/D sky130_fd_sc_hd__a22o_2
X_4723_ _5256_/Q _4725_/B VGND VGND VPWR VPWR _4723_/X sky130_fd_sc_hd__or2_2
X_4654_ _4653_/Y _4626_/X _4681_/S VGND VGND VPWR VPWR _4654_/X sky130_fd_sc_hd__mux2_1
X_4585_ _5233_/Q _4854_/B VGND VGND VPWR VPWR _4585_/Y sky130_fd_sc_hd__nand2_2
X_3605_ _4891_/Q _4875_/Q _5099_/Q _5083_/Q _3706_/S0 _3706_/S1 VGND VGND VPWR VPWR
+ _3606_/B sky130_fd_sc_hd__mux4_2
X_3536_ _3834_/B _3840_/B _3866_/B VGND VGND VPWR VPWR _3536_/X sky130_fd_sc_hd__mux2_1
X_5206_ _5251_/CLK _5206_/D VGND VGND VPWR VPWR _5206_/Q sky130_fd_sc_hd__dfxtp_2
X_3467_ _5168_/Q _5149_/Q VGND VGND VPWR VPWR _3469_/A sky130_fd_sc_hd__nand2_2
XFILLER_88_126 VGND VGND VPWR VPWR sky130_fd_sc_hd__decap_3
XFILLER_57_502 VGND VGND VPWR VPWR sky130_fd_sc_hd__fill_2
X_3398_ _5159_/Q _5140_/Q VGND VGND VPWR VPWR _3400_/B sky130_fd_sc_hd__or2_2
XFILLER_29_204 VGND VGND VPWR VPWR sky130_fd_sc_hd__decap_3
X_5137_ _5260_/CLK _5137_/D VGND VGND VPWR VPWR _5137_/Q sky130_fd_sc_hd__dfxtp_2
XFILLER_84_321 VGND VGND VPWR VPWR sky130_fd_sc_hd__decap_3
X_5068_ _5114_/CLK _5068_/D VGND VGND VPWR VPWR _5068_/Q sky130_fd_sc_hd__dfxtp_2
XFILLER_84_354 VGND VGND VPWR VPWR sky130_fd_sc_hd__decap_3
XFILLER_72_516 VGND VGND VPWR VPWR sky130_fd_sc_hd__decap_3
X_4019_ _3884_/D _3740_/A _3740_/B _3886_/B VGND VGND VPWR VPWR _4037_/D sky130_fd_sc_hd__a211o_2
XTAP_TAPCELL_ROW_55_725 VGND VPWR sky130_fd_sc_hd__tapvpwrvgnd_1
XFILLER_37_281 VGND VGND VPWR VPWR sky130_fd_sc_hd__decap_3
XFILLER_52_251 VGND VGND VPWR VPWR sky130_fd_sc_hd__fill_1
XPHY_EDGE_ROW_0_Right_0 VGND VGND VPWR VPWR sky130_fd_sc_hd__decap_3
XFILLER_40_435 VGND VGND VPWR VPWR sky130_fd_sc_hd__decap_3
XFILLER_12_137 VGND VGND VPWR VPWR sky130_fd_sc_hd__decap_3
XFILLER_12_159 VGND VGND VPWR VPWR sky130_fd_sc_hd__decap_3
XFILLER_32_77 VGND VGND VPWR VPWR sky130_fd_sc_hd__decap_3
XFILLER_32_88 VGND VGND VPWR VPWR sky130_fd_sc_hd__fill_2
XFILLER_32_99 VGND VGND VPWR VPWR sky130_fd_sc_hd__decap_3
XFILLER_4_303 VGND VGND VPWR VPWR sky130_fd_sc_hd__decap_3
XFILLER_0_520 VGND VGND VPWR VPWR sky130_fd_sc_hd__decap_3
XFILLER_0_542 VGND VGND VPWR VPWR sky130_fd_sc_hd__decap_3
XFILLER_79_159 VGND VGND VPWR VPWR sky130_fd_sc_hd__fill_1
XFILLER_48_513 VGND VGND VPWR VPWR sky130_fd_sc_hd__decap_3
XFILLER_48_557 VGND VGND VPWR VPWR sky130_fd_sc_hd__fill_1
XFILLER_57_74 VGND VGND VPWR VPWR sky130_fd_sc_hd__decap_3
XFILLER_16_421 VGND VGND VPWR VPWR sky130_fd_sc_hd__decap_3
XFILLER_16_432 VGND VGND VPWR VPWR sky130_fd_sc_hd__decap_3
XFILLER_75_398 VGND VGND VPWR VPWR sky130_fd_sc_hd__decap_3
XPHY_EDGE_ROW_35_Left_129 VGND VGND VPWR VPWR sky130_fd_sc_hd__decap_3
XFILLER_73_62 VGND VGND VPWR VPWR sky130_fd_sc_hd__decap_3
XFILLER_31_446 VGND VGND VPWR VPWR sky130_fd_sc_hd__fill_2
XFILLER_78_6 VGND VGND VPWR VPWR sky130_fd_sc_hd__decap_3
XPHY_EDGE_ROW_44_Left_138 VGND VGND VPWR VPWR sky130_fd_sc_hd__decap_3
X_4370_ _4410_/A _4370_/B VGND VGND VPWR VPWR _4370_/X sky130_fd_sc_hd__or2_2
XFILLER_7_196 VGND VGND VPWR VPWR sky130_fd_sc_hd__decap_3
X_3321_ input23/X _5286_/D _4868_/A2 _4870_/B1 _5158_/Q VGND VGND VPWR VPWR _5158_/D
+ sky130_fd_sc_hd__a32o_2
X_3252_ _5178_/Q _3229_/Y _4870_/B1 _3251_/X VGND VGND VPWR VPWR _5137_/D sky130_fd_sc_hd__o22a_2
X_3183_ _2924_/X _3191_/A2 _3191_/B1 _5086_/Q VGND VGND VPWR VPWR _5086_/D sky130_fd_sc_hd__a22o_2
XFILLER_26_218 VGND VGND VPWR VPWR sky130_fd_sc_hd__decap_3
XFILLER_66_376 VGND VGND VPWR VPWR sky130_fd_sc_hd__decap_3
XPHY_EDGE_ROW_53_Left_147 VGND VGND VPWR VPWR sky130_fd_sc_hd__decap_3
XFILLER_81_346 VGND VGND VPWR VPWR sky130_fd_sc_hd__decap_3
XFILLER_34_251 VGND VGND VPWR VPWR sky130_fd_sc_hd__fill_1
XFILLER_81_379 VGND VGND VPWR VPWR sky130_fd_sc_hd__decap_3
XFILLER_22_402 VGND VGND VPWR VPWR sky130_fd_sc_hd__fill_1
XFILLER_22_424 VGND VGND VPWR VPWR sky130_fd_sc_hd__decap_3
XFILLER_34_273 VGND VGND VPWR VPWR sky130_fd_sc_hd__decap_3
X_2967_ _2941_/X _2970_/A2 _2954_/Y _4899_/Q VGND VGND VPWR VPWR _4899_/D sky130_fd_sc_hd__a22o_2
XTAP_TAPCELL_ROW_60_772 VGND VPWR sky130_fd_sc_hd__tapvpwrvgnd_1
X_4706_ input44/X _4694_/Y _4705_/X _3366_/A VGND VGND VPWR VPWR _5247_/D sky130_fd_sc_hd__o211a_2
X_2898_ _5188_/Q _5281_/D VGND VGND VPWR VPWR _3046_/C sky130_fd_sc_hd__nand2_2
XPHY_EDGE_ROW_62_Left_156 VGND VGND VPWR VPWR sky130_fd_sc_hd__decap_3
X_4637_ _4625_/Y _4636_/X _4692_/A VGND VGND VPWR VPWR _5237_/D sky130_fd_sc_hd__a21oi_2
X_4568_ _4055_/A _4567_/X _4541_/X VGND VGND VPWR VPWR _4568_/X sky130_fd_sc_hd__a21o_2
XFILLER_89_413 VGND VGND VPWR VPWR sky130_fd_sc_hd__decap_3
XFILLER_78_29 VGND VGND VPWR VPWR sky130_fd_sc_hd__decap_3
XFILLER_78_18 VGND VGND VPWR VPWR sky130_fd_sc_hd__decap_3
X_4499_ _4498_/Y _4420_/A _4681_/S VGND VGND VPWR VPWR _4501_/B sky130_fd_sc_hd__mux2_1
X_3519_ _3693_/A _3516_/X _5134_/Q VGND VGND VPWR VPWR _3519_/X sky130_fd_sc_hd__o21a_2
XFILLER_76_118 VGND VGND VPWR VPWR sky130_fd_sc_hd__decap_3
XFILLER_57_321 VGND VGND VPWR VPWR sky130_fd_sc_hd__decap_3
XFILLER_57_343 VGND VGND VPWR VPWR sky130_fd_sc_hd__decap_3
XTAP_TAPCELL_ROW_68_850 VGND VPWR sky130_fd_sc_hd__tapvpwrvgnd_1
XPHY_EDGE_ROW_71_Left_165 VGND VGND VPWR VPWR sky130_fd_sc_hd__decap_3
XFILLER_27_44 VGND VGND VPWR VPWR sky130_fd_sc_hd__decap_3
XFILLER_45_505 VGND VGND VPWR VPWR sky130_fd_sc_hd__fill_1
XFILLER_57_387 VGND VGND VPWR VPWR sky130_fd_sc_hd__decap_3
XFILLER_84_151 VGND VGND VPWR VPWR sky130_fd_sc_hd__fill_1
XFILLER_45_549 VGND VGND VPWR VPWR sky130_fd_sc_hd__decap_3
XFILLER_72_357 VGND VGND VPWR VPWR sky130_fd_sc_hd__decap_3
XFILLER_72_368 VGND VGND VPWR VPWR sky130_fd_sc_hd__decap_3
XFILLER_72_379 VGND VGND VPWR VPWR sky130_fd_sc_hd__decap_3
XFILLER_13_413 VGND VGND VPWR VPWR sky130_fd_sc_hd__decap_3
XFILLER_25_284 VGND VGND VPWR VPWR sky130_fd_sc_hd__decap_3
XFILLER_43_87 VGND VGND VPWR VPWR sky130_fd_sc_hd__decap_3
XPHY_EDGE_ROW_80_Left_174 VGND VGND VPWR VPWR sky130_fd_sc_hd__decap_3
XFILLER_9_439 VGND VGND VPWR VPWR sky130_fd_sc_hd__fill_2
XFILLER_4_166 VGND VGND VPWR VPWR sky130_fd_sc_hd__decap_3
XFILLER_4_59 VGND VGND VPWR VPWR sky130_fd_sc_hd__decap_3
XFILLER_48_321 VGND VGND VPWR VPWR sky130_fd_sc_hd__decap_3
XFILLER_48_343 VGND VGND VPWR VPWR sky130_fd_sc_hd__decap_3
XFILLER_36_516 VGND VGND VPWR VPWR sky130_fd_sc_hd__decap_3
XFILLER_48_365 VGND VGND VPWR VPWR sky130_fd_sc_hd__decap_3
XFILLER_48_387 VGND VGND VPWR VPWR sky130_fd_sc_hd__decap_3
XFILLER_63_313 VGND VGND VPWR VPWR sky130_fd_sc_hd__decap_3
XFILLER_84_83 VGND VGND VPWR VPWR sky130_fd_sc_hd__fill_1
XFILLER_51_508 VGND VGND VPWR VPWR sky130_fd_sc_hd__decap_3
XFILLER_16_262 VGND VGND VPWR VPWR sky130_fd_sc_hd__decap_3
X_3870_ _4078_/B _3864_/Y _3868_/X _3869_/Y VGND VGND VPWR VPWR _3870_/X sky130_fd_sc_hd__a22o_2
X_2821_ _2857_/A _4808_/B VGND VGND VPWR VPWR _2821_/X sky130_fd_sc_hd__and2_2
XFILLER_31_298 VGND VGND VPWR VPWR sky130_fd_sc_hd__decap_3
X_2752_ _2750_/X _2751_/X _2855_/S VGND VGND VPWR VPWR _2752_/X sky130_fd_sc_hd__mux2_1
XFILLER_76_3 VGND VGND VPWR VPWR sky130_fd_sc_hd__decap_3
X_4422_ _4299_/A _4302_/A _4422_/S VGND VGND VPWR VPWR _4424_/B sky130_fd_sc_hd__mux2_1
X_2683_ _2683_/A _2683_/B VGND VGND VPWR VPWR _4145_/A sky130_fd_sc_hd__nand2_2
XFILLER_8_494 VGND VGND VPWR VPWR sky130_fd_sc_hd__fill_2
X_4353_ _4353_/A _4353_/B VGND VGND VPWR VPWR _4354_/B sky130_fd_sc_hd__nand2_2
X_4284_ _4301_/B _4284_/B VGND VGND VPWR VPWR _4284_/X sky130_fd_sc_hd__and2_2
X_3304_ _5151_/Q _3304_/B VGND VGND VPWR VPWR _3304_/X sky130_fd_sc_hd__xor2_2
X_3235_ _5283_/Q _3338_/B _3235_/C VGND VGND VPWR VPWR _3235_/X sky130_fd_sc_hd__and3_2
XFILLER_86_416 VGND VGND VPWR VPWR sky130_fd_sc_hd__decap_3
XFILLER_39_343 VGND VGND VPWR VPWR sky130_fd_sc_hd__decap_3
XFILLER_86_449 VGND VGND VPWR VPWR sky130_fd_sc_hd__fill_1
XFILLER_27_505 VGND VGND VPWR VPWR sky130_fd_sc_hd__decap_3
XFILLER_66_162 VGND VGND VPWR VPWR sky130_fd_sc_hd__decap_3
X_3166_ _2927_/X _3173_/A2 _3157_/Y _5071_/Q VGND VGND VPWR VPWR _5071_/D sky130_fd_sc_hd__a22o_2
XFILLER_27_538 VGND VGND VPWR VPWR sky130_fd_sc_hd__decap_3
XFILLER_27_549 VGND VGND VPWR VPWR sky130_fd_sc_hd__decap_3
XFILLER_66_195 VGND VGND VPWR VPWR sky130_fd_sc_hd__fill_1
X_3097_ _2941_/X _3100_/A2 _3084_/Y _5011_/Q VGND VGND VPWR VPWR _5011_/D sky130_fd_sc_hd__a22o_2
XTAP_TAPCELL_ROW_65_820 VGND VPWR sky130_fd_sc_hd__tapvpwrvgnd_1
XFILLER_54_368 VGND VGND VPWR VPWR sky130_fd_sc_hd__decap_3
XTAP_TAPCELL_ROW_37_555 VGND VPWR sky130_fd_sc_hd__tapvpwrvgnd_1
XFILLER_22_221 VGND VGND VPWR VPWR sky130_fd_sc_hd__decap_3
XFILLER_62_390 VGND VGND VPWR VPWR sky130_fd_sc_hd__decap_3
XFILLER_10_405 VGND VGND VPWR VPWR sky130_fd_sc_hd__decap_3
XFILLER_10_416 VGND VGND VPWR VPWR sky130_fd_sc_hd__decap_3
XFILLER_22_265 VGND VGND VPWR VPWR sky130_fd_sc_hd__fill_1
X_3999_ _4071_/A _3579_/X _3960_/Y VGND VGND VPWR VPWR _3999_/X sky130_fd_sc_hd__o21a_2
XFILLER_13_57 VGND VGND VPWR VPWR sky130_fd_sc_hd__decap_3
XFILLER_89_39 VGND VGND VPWR VPWR sky130_fd_sc_hd__fill_1
Xmax_cap180 _2676_/S1 VGND VGND VPWR VPWR _2672_/S1 sky130_fd_sc_hd__buf_12
XFILLER_8_6 VGND VGND VPWR VPWR sky130_fd_sc_hd__decap_3
XFILLER_1_169 VGND VGND VPWR VPWR sky130_fd_sc_hd__decap_3
XFILLER_49_107 VGND VGND VPWR VPWR sky130_fd_sc_hd__decap_3
XFILLER_77_416 VGND VGND VPWR VPWR sky130_fd_sc_hd__decap_3
XFILLER_77_449 VGND VGND VPWR VPWR sky130_fd_sc_hd__decap_3
XFILLER_18_516 VGND VGND VPWR VPWR sky130_fd_sc_hd__decap_3
XFILLER_38_76 VGND VGND VPWR VPWR sky130_fd_sc_hd__decap_3
XFILLER_45_302 VGND VGND VPWR VPWR sky130_fd_sc_hd__fill_1
XFILLER_18_549 VGND VGND VPWR VPWR sky130_fd_sc_hd__decap_3
XFILLER_45_313 VGND VGND VPWR VPWR sky130_fd_sc_hd__decap_3
XFILLER_45_335 VGND VGND VPWR VPWR sky130_fd_sc_hd__fill_1
XFILLER_72_121 VGND VGND VPWR VPWR sky130_fd_sc_hd__decap_3
XFILLER_85_482 VGND VGND VPWR VPWR sky130_fd_sc_hd__decap_3
XFILLER_33_508 VGND VGND VPWR VPWR sky130_fd_sc_hd__decap_3
XFILLER_60_305 VGND VGND VPWR VPWR sky130_fd_sc_hd__decap_3
XFILLER_13_210 VGND VGND VPWR VPWR sky130_fd_sc_hd__decap_3
XFILLER_60_349 VGND VGND VPWR VPWR sky130_fd_sc_hd__decap_3
XTAP_TAPCELL_ROW_0_191 VGND VPWR sky130_fd_sc_hd__tapvpwrvgnd_1
XTAP_TAPCELL_ROW_71_878 VGND VPWR sky130_fd_sc_hd__tapvpwrvgnd_1
XFILLER_9_225 VGND VGND VPWR VPWR sky130_fd_sc_hd__fill_2
XFILLER_9_214 VGND VGND VPWR VPWR sky130_fd_sc_hd__fill_1
XFILLER_13_298 VGND VGND VPWR VPWR sky130_fd_sc_hd__decap_3
XFILLER_70_41 VGND VGND VPWR VPWR sky130_fd_sc_hd__decap_3
XFILLER_70_85 VGND VGND VPWR VPWR sky130_fd_sc_hd__decap_3
Xclkload17 _5102_/CLK VGND VGND VPWR VPWR clkload17/X sky130_fd_sc_hd__clkbuf_8
XFILLER_5_420 VGND VGND VPWR VPWR sky130_fd_sc_hd__decap_3
Xclkload28 _5270_/CLK VGND VGND VPWR VPWR clkload28/X sky130_fd_sc_hd__clkbuf_4
XFILLER_5_464 VGND VGND VPWR VPWR sky130_fd_sc_hd__fill_2
XFILLER_5_486 VGND VGND VPWR VPWR sky130_fd_sc_hd__decap_3
XFILLER_68_427 VGND VGND VPWR VPWR sky130_fd_sc_hd__decap_3
XTAP_TAPCELL_ROW_8_280 VGND VPWR sky130_fd_sc_hd__tapvpwrvgnd_1
XFILLER_68_449 VGND VGND VPWR VPWR sky130_fd_sc_hd__decap_3
XTAP_TAPCELL_ROW_79_956 VGND VPWR sky130_fd_sc_hd__tapvpwrvgnd_1
XFILLER_48_162 VGND VGND VPWR VPWR sky130_fd_sc_hd__decap_3
X_3020_ _2927_/X _3011_/B _3011_/Y _4943_/Q VGND VGND VPWR VPWR _4943_/D sky130_fd_sc_hd__a22o_2
XFILLER_76_471 VGND VGND VPWR VPWR sky130_fd_sc_hd__decap_3
XFILLER_91_463 VGND VGND VPWR VPWR sky130_fd_sc_hd__decap_3
XFILLER_36_379 VGND VGND VPWR VPWR sky130_fd_sc_hd__decap_3
X_4971_ clkload9/A _4971_/D VGND VGND VPWR VPWR _4971_/Q sky130_fd_sc_hd__dfxtp_2
XTAP_TAPCELL_ROW_34_525 VGND VPWR sky130_fd_sc_hd__tapvpwrvgnd_1
XFILLER_51_349 VGND VGND VPWR VPWR sky130_fd_sc_hd__decap_3
X_3922_ _3919_/S _3543_/X _3921_/Y VGND VGND VPWR VPWR _3922_/X sky130_fd_sc_hd__o21a_2
X_3853_ _4397_/C _4638_/S _3852_/Y VGND VGND VPWR VPWR _3853_/Y sky130_fd_sc_hd__o21ai_2
X_2804_ _4897_/Q _4881_/Q _5105_/Q _5089_/Q _2854_/S0 _5136_/Q VGND VGND VPWR VPWR
+ _2804_/X sky130_fd_sc_hd__mux4_2
X_3784_ _4378_/A _3784_/B VGND VGND VPWR VPWR _3784_/X sky130_fd_sc_hd__or2_2
X_2735_ _5113_/Q _5001_/Q _4985_/Q _4969_/Q _2818_/S0 _5136_/Q VGND VGND VPWR VPWR
+ _2736_/B sky130_fd_sc_hd__mux4_2
X_2666_ _4397_/C VGND VGND VPWR VPWR _3840_/B sky130_fd_sc_hd__inv_2
X_4405_ _4360_/A _4360_/B _4354_/A VGND VGND VPWR VPWR _4407_/B sky130_fd_sc_hd__o21a_2
X_4336_ _4393_/A _4079_/A _4393_/C VGND VGND VPWR VPWR _4336_/Y sky130_fd_sc_hd__a21oi_2
X_2597_ _2591_/X _2593_/X _2596_/X _2433_/Y VGND VGND VPWR VPWR _4357_/B sky130_fd_sc_hd__a22o_2
XFILLER_59_405 VGND VGND VPWR VPWR sky130_fd_sc_hd__decap_3
XFILLER_59_449 VGND VGND VPWR VPWR sky130_fd_sc_hd__decap_3
X_4267_ _4266_/X _4181_/B _4267_/S VGND VGND VPWR VPWR _4267_/X sky130_fd_sc_hd__mux2_1
XFILLER_86_235 VGND VGND VPWR VPWR sky130_fd_sc_hd__decap_3
X_4198_ _3780_/A _4278_/B _3885_/Y _4207_/A VGND VGND VPWR VPWR _4198_/X sky130_fd_sc_hd__a22o_2
X_3218_ _2921_/X _3227_/A2 _3211_/Y _5117_/Q VGND VGND VPWR VPWR _5117_/D sky130_fd_sc_hd__a22o_2
X_3149_ _2931_/X _3155_/A2 _3139_/Y _5056_/Q VGND VGND VPWR VPWR _5056_/D sky130_fd_sc_hd__a22o_2
XFILLER_82_430 VGND VGND VPWR VPWR sky130_fd_sc_hd__decap_3
XFILLER_42_305 VGND VGND VPWR VPWR sky130_fd_sc_hd__decap_3
XFILLER_42_316 VGND VGND VPWR VPWR sky130_fd_sc_hd__decap_3
XFILLER_42_349 VGND VGND VPWR VPWR sky130_fd_sc_hd__fill_2
XFILLER_24_67 VGND VGND VPWR VPWR sky130_fd_sc_hd__decap_3
XFILLER_50_360 VGND VGND VPWR VPWR sky130_fd_sc_hd__decap_3
XFILLER_10_213 VGND VGND VPWR VPWR sky130_fd_sc_hd__decap_3
XFILLER_6_3 VGND VGND VPWR VPWR sky130_fd_sc_hd__decap_3
XFILLER_1_27 VGND VGND VPWR VPWR sky130_fd_sc_hd__decap_3
XFILLER_65_408 VGND VGND VPWR VPWR sky130_fd_sc_hd__decap_3
XTAP_TAPCELL_ROW_76_926 VGND VPWR sky130_fd_sc_hd__tapvpwrvgnd_1
XTAP_TAPCELL_ROW_5_250 VGND VPWR sky130_fd_sc_hd__tapvpwrvgnd_1
XFILLER_77_279 VGND VGND VPWR VPWR sky130_fd_sc_hd__fill_1
XFILLER_65_41 VGND VGND VPWR VPWR sky130_fd_sc_hd__decap_3
XFILLER_65_74 VGND VGND VPWR VPWR sky130_fd_sc_hd__decap_3
XFILLER_73_452 VGND VGND VPWR VPWR sky130_fd_sc_hd__decap_3
XTAP_TAPCELL_ROW_86_1022 VGND VPWR sky130_fd_sc_hd__tapvpwrvgnd_1
XFILLER_14_552 VGND VGND VPWR VPWR sky130_fd_sc_hd__decap_3
XFILLER_60_157 VGND VGND VPWR VPWR sky130_fd_sc_hd__decap_3
XFILLER_60_179 VGND VGND VPWR VPWR sky130_fd_sc_hd__decap_3
XFILLER_41_393 VGND VGND VPWR VPWR sky130_fd_sc_hd__decap_3
X_2520_ _2890_/A _2521_/B VGND VGND VPWR VPWR _3780_/A sky130_fd_sc_hd__nor2_2
X_2451_ _3884_/D _3891_/B VGND VGND VPWR VPWR _4503_/A sky130_fd_sc_hd__nor2_4
XFILLER_39_3 VGND VGND VPWR VPWR sky130_fd_sc_hd__decap_3
X_5170_ _5177_/CLK _5170_/D VGND VGND VPWR VPWR _5170_/Q sky130_fd_sc_hd__dfxtp_2
X_4121_ _4199_/C _4119_/Y _4120_/Y VGND VGND VPWR VPWR _4121_/X sky130_fd_sc_hd__a21o_2
XFILLER_56_419 VGND VGND VPWR VPWR sky130_fd_sc_hd__fill_1
XFILLER_68_268 VGND VGND VPWR VPWR sky130_fd_sc_hd__decap_3
X_4052_ _4434_/A _3601_/B _2629_/A _3764_/X VGND VGND VPWR VPWR _4052_/X sky130_fd_sc_hd__a2bb2o_2
XFILLER_49_471 VGND VGND VPWR VPWR sky130_fd_sc_hd__decap_3
Xinput4 INSTR_STREAM[12] VGND VGND VPWR VPWR input4/X sky130_fd_sc_hd__clkdlybuf4s25_1
X_3003_ _2931_/X _2993_/B _2993_/Y _4928_/Q VGND VGND VPWR VPWR _4928_/D sky130_fd_sc_hd__a22o_2
XFILLER_64_441 VGND VGND VPWR VPWR sky130_fd_sc_hd__fill_2
XTAP_TAPCELL_ROW_47_650 VGND VPWR sky130_fd_sc_hd__tapvpwrvgnd_1
XFILLER_17_390 VGND VGND VPWR VPWR sky130_fd_sc_hd__fill_2
XFILLER_51_113 VGND VGND VPWR VPWR sky130_fd_sc_hd__decap_3
X_4954_ _5114_/CLK _4954_/D VGND VGND VPWR VPWR _4954_/Q sky130_fd_sc_hd__dfxtp_2
XTAP_TAPCELL_ROW_19_385 VGND VPWR sky130_fd_sc_hd__tapvpwrvgnd_1
X_3905_ _4393_/C _3905_/B VGND VGND VPWR VPWR _3905_/Y sky130_fd_sc_hd__nor2_2
XFILLER_20_533 VGND VGND VPWR VPWR sky130_fd_sc_hd__fill_2
XFILLER_32_371 VGND VGND VPWR VPWR sky130_fd_sc_hd__decap_3
X_4885_ _5103_/CLK _4885_/D VGND VGND VPWR VPWR _4885_/Q sky130_fd_sc_hd__dfxtp_2
X_3836_ _2645_/A _4602_/S _4124_/B VGND VGND VPWR VPWR _4126_/A sky130_fd_sc_hd__o21ai_2
X_3767_ _3884_/D _3886_/B VGND VGND VPWR VPWR _3767_/Y sky130_fd_sc_hd__nor2_2
XFILLER_3_209 VGND VGND VPWR VPWR sky130_fd_sc_hd__decap_3
X_2718_ _5137_/Q _2718_/B VGND VGND VPWR VPWR _2718_/X sky130_fd_sc_hd__or2_2
XFILLER_10_25 VGND VGND VPWR VPWR sky130_fd_sc_hd__decap_3
X_3698_ _3696_/X _3697_/X _3733_/S VGND VGND VPWR VPWR _3698_/X sky130_fd_sc_hd__mux2_1
XFILLER_10_47 VGND VGND VPWR VPWR sky130_fd_sc_hd__fill_2
XFILLER_10_58 VGND VGND VPWR VPWR sky130_fd_sc_hd__decap_3
X_2649_ _2677_/S _2648_/X _5130_/Q VGND VGND VPWR VPWR _2649_/X sky130_fd_sc_hd__o21a_2
XFILLER_59_202 VGND VGND VPWR VPWR sky130_fd_sc_hd__decap_3
XFILLER_87_511 VGND VGND VPWR VPWR sky130_fd_sc_hd__decap_3
XFILLER_19_12 VGND VGND VPWR VPWR sky130_fd_sc_hd__decap_3
X_4319_ _4357_/A _4357_/B VGND VGND VPWR VPWR _4322_/B sky130_fd_sc_hd__nor2_2
XFILLER_87_544 VGND VGND VPWR VPWR sky130_fd_sc_hd__decap_3
XFILLER_47_419 VGND VGND VPWR VPWR sky130_fd_sc_hd__decap_3
XFILLER_59_279 VGND VGND VPWR VPWR sky130_fd_sc_hd__fill_1
XFILLER_74_227 VGND VGND VPWR VPWR sky130_fd_sc_hd__decap_3
XTAP_TAPCELL_ROW_2_220 VGND VPWR sky130_fd_sc_hd__tapvpwrvgnd_1
XFILLER_35_55 VGND VGND VPWR VPWR sky130_fd_sc_hd__fill_1
XFILLER_70_433 VGND VGND VPWR VPWR sky130_fd_sc_hd__decap_3
XTAP_TAPCELL_ROW_81_973 VGND VPWR sky130_fd_sc_hd__tapvpwrvgnd_1
XFILLER_50_190 VGND VGND VPWR VPWR sky130_fd_sc_hd__decap_3
XFILLER_2_253 VGND VGND VPWR VPWR sky130_fd_sc_hd__decap_3
XFILLER_78_522 VGND VGND VPWR VPWR sky130_fd_sc_hd__decap_3
XFILLER_25_9 VGND VGND VPWR VPWR sky130_fd_sc_hd__decap_3
XFILLER_65_205 VGND VGND VPWR VPWR sky130_fd_sc_hd__fill_2
XFILLER_93_514 VGND VGND VPWR VPWR sky130_fd_sc_hd__decap_3
XFILLER_76_51 VGND VGND VPWR VPWR sky130_fd_sc_hd__decap_3
XFILLER_76_40 VGND VGND VPWR VPWR sky130_fd_sc_hd__fill_2
XFILLER_65_238 VGND VGND VPWR VPWR sky130_fd_sc_hd__decap_3
XFILLER_93_536 VGND VGND VPWR VPWR sky130_fd_sc_hd__decap_3
XFILLER_18_121 VGND VGND VPWR VPWR sky130_fd_sc_hd__fill_1
XFILLER_46_430 VGND VGND VPWR VPWR sky130_fd_sc_hd__decap_3
XFILLER_61_411 VGND VGND VPWR VPWR sky130_fd_sc_hd__fill_1
XFILLER_33_113 VGND VGND VPWR VPWR sky130_fd_sc_hd__decap_3
XFILLER_73_293 VGND VGND VPWR VPWR sky130_fd_sc_hd__decap_3
XTAP_TAPCELL_ROW_44_620 VGND VPWR sky130_fd_sc_hd__tapvpwrvgnd_1
XFILLER_92_72 VGND VGND VPWR VPWR sky130_fd_sc_hd__decap_3
XFILLER_61_455 VGND VGND VPWR VPWR sky130_fd_sc_hd__decap_3
XTAP_TAPCELL_ROW_16_355 VGND VPWR sky130_fd_sc_hd__tapvpwrvgnd_1
XFILLER_92_94 VGND VGND VPWR VPWR sky130_fd_sc_hd__fill_1
XFILLER_61_499 VGND VGND VPWR VPWR sky130_fd_sc_hd__decap_3
X_4670_ _4239_/A _4261_/C _4686_/B1 _3778_/B _4669_/X VGND VGND VPWR VPWR _4671_/C
+ sky130_fd_sc_hd__o221a_2
X_3621_ _5076_/Q _5060_/Q _5044_/Q _5028_/Q _3706_/S0 _3706_/S1 VGND VGND VPWR VPWR
+ _3621_/X sky130_fd_sc_hd__mux4_2
X_3552_ _3600_/A _3866_/B _3551_/Y VGND VGND VPWR VPWR _3552_/X sky130_fd_sc_hd__o21a_2
X_2503_ _2497_/X _2499_/X _2502_/X _2433_/Y VGND VGND VPWR VPWR _4376_/A sky130_fd_sc_hd__a22o_2
X_3483_ _5170_/Q _5151_/Q VGND VGND VPWR VPWR _3485_/A sky130_fd_sc_hd__and2_2
XFILLER_69_511 VGND VGND VPWR VPWR sky130_fd_sc_hd__decap_3
X_5222_ _5257_/CLK _5222_/D VGND VGND VPWR VPWR _5222_/Q sky130_fd_sc_hd__dfxtp_2
X_2434_ _5137_/Q VGND VGND VPWR VPWR _2832_/A sky130_fd_sc_hd__inv_2
X_5153_ _5260_/CLK _5153_/D VGND VGND VPWR VPWR _5153_/Q sky130_fd_sc_hd__dfxtp_2
XFILLER_69_555 VGND VGND VPWR VPWR sky130_fd_sc_hd__decap_3
X_4104_ _4104_/A _4225_/A VGND VGND VPWR VPWR _4107_/C sky130_fd_sc_hd__nor2_2
XFILLER_56_238 VGND VGND VPWR VPWR sky130_fd_sc_hd__decap_3
X_5084_ _5114_/CLK _5084_/D VGND VGND VPWR VPWR _5084_/Q sky130_fd_sc_hd__dfxtp_2
XFILLER_49_290 VGND VGND VPWR VPWR sky130_fd_sc_hd__decap_3
X_4035_ _3828_/Y _3986_/Y _4550_/A _4024_/Y _4015_/A VGND VGND VPWR VPWR _4035_/X
+ sky130_fd_sc_hd__o32a_2
XFILLER_37_474 VGND VGND VPWR VPWR sky130_fd_sc_hd__decap_3
XFILLER_37_485 VGND VGND VPWR VPWR sky130_fd_sc_hd__decap_3
XFILLER_52_444 VGND VGND VPWR VPWR sky130_fd_sc_hd__decap_3
XFILLER_52_477 VGND VGND VPWR VPWR sky130_fd_sc_hd__decap_3
X_4937_ _4994_/CLK _4937_/D VGND VGND VPWR VPWR _4937_/Q sky130_fd_sc_hd__dfxtp_2
XFILLER_20_341 VGND VGND VPWR VPWR sky130_fd_sc_hd__fill_1
XFILLER_32_190 VGND VGND VPWR VPWR sky130_fd_sc_hd__decap_3
X_4868_ _5177_/Q _4868_/A2 _4870_/B1 _3249_/X VGND VGND VPWR VPWR _5177_/D sky130_fd_sc_hd__o22a_2
X_3819_ _2862_/A _3817_/Y _3818_/X VGND VGND VPWR VPWR _3820_/B sky130_fd_sc_hd__a21oi_2
XTAP_TAPCELL_ROW_50_678 VGND VPWR sky130_fd_sc_hd__tapvpwrvgnd_1
XFILLER_20_396 VGND VGND VPWR VPWR sky130_fd_sc_hd__decap_3
XFILLER_21_24 VGND VGND VPWR VPWR sky130_fd_sc_hd__decap_3
X_4799_ _5166_/Q _4799_/B VGND VGND VPWR VPWR _4800_/B sky130_fd_sc_hd__or2_2
XFILLER_4_518 VGND VGND VPWR VPWR sky130_fd_sc_hd__decap_3
XFILLER_87_363 VGND VGND VPWR VPWR sky130_fd_sc_hd__decap_3
XFILLER_87_396 VGND VGND VPWR VPWR sky130_fd_sc_hd__decap_3
XFILLER_28_430 VGND VGND VPWR VPWR sky130_fd_sc_hd__decap_3
XFILLER_46_32 VGND VGND VPWR VPWR sky130_fd_sc_hd__fill_2
XTAP_TAPCELL_ROW_58_756 VGND VPWR sky130_fd_sc_hd__tapvpwrvgnd_1
XFILLER_15_113 VGND VGND VPWR VPWR sky130_fd_sc_hd__decap_3
XFILLER_28_496 VGND VGND VPWR VPWR sky130_fd_sc_hd__fill_2
XFILLER_43_411 VGND VGND VPWR VPWR sky130_fd_sc_hd__decap_3
XFILLER_15_146 VGND VGND VPWR VPWR sky130_fd_sc_hd__fill_1
XFILLER_43_455 VGND VGND VPWR VPWR sky130_fd_sc_hd__decap_3
XFILLER_43_488 VGND VGND VPWR VPWR sky130_fd_sc_hd__decap_3
XFILLER_70_296 VGND VGND VPWR VPWR sky130_fd_sc_hd__fill_2
XTAP_TAPCELL_ROW_13_325 VGND VPWR sky130_fd_sc_hd__tapvpwrvgnd_1
XFILLER_11_363 VGND VGND VPWR VPWR sky130_fd_sc_hd__decap_3
XFILLER_7_301 VGND VGND VPWR VPWR sky130_fd_sc_hd__decap_3
XFILLER_87_50 VGND VGND VPWR VPWR sky130_fd_sc_hd__decap_3
XFILLER_23_6 VGND VGND VPWR VPWR sky130_fd_sc_hd__fill_2
XFILLER_87_83 VGND VGND VPWR VPWR sky130_fd_sc_hd__decap_3
XFILLER_78_363 VGND VGND VPWR VPWR sky130_fd_sc_hd__fill_1
XFILLER_66_514 VGND VGND VPWR VPWR sky130_fd_sc_hd__decap_3
XFILLER_66_536 VGND VGND VPWR VPWR sky130_fd_sc_hd__decap_3
XFILLER_78_374 VGND VGND VPWR VPWR sky130_fd_sc_hd__decap_3
XFILLER_81_517 VGND VGND VPWR VPWR sky130_fd_sc_hd__decap_3
XFILLER_34_433 VGND VGND VPWR VPWR sky130_fd_sc_hd__decap_3
XTAP_TAPCELL_ROW_29_480 VGND VPWR sky130_fd_sc_hd__tapvpwrvgnd_1
XFILLER_34_466 VGND VGND VPWR VPWR sky130_fd_sc_hd__decap_3
XFILLER_34_477 VGND VGND VPWR VPWR sky130_fd_sc_hd__decap_3
XFILLER_61_274 VGND VGND VPWR VPWR sky130_fd_sc_hd__decap_3
X_2983_ _2927_/X _2974_/B _2974_/Y _4911_/Q VGND VGND VPWR VPWR _4911_/D sky130_fd_sc_hd__a22o_2
XFILLER_21_149 VGND VGND VPWR VPWR sky130_fd_sc_hd__decap_3
X_4722_ input37/X _4694_/Y _4721_/X _3366_/A VGND VGND VPWR VPWR _5255_/D sky130_fd_sc_hd__o211a_2
X_4653_ _4653_/A VGND VGND VPWR VPWR _4653_/Y sky130_fd_sc_hd__inv_2
Xinput40 MEM_LD_DATA[1] VGND VGND VPWR VPWR input40/X sky130_fd_sc_hd__clkdlybuf4s25_1
X_4584_ _4087_/C _4573_/X _4583_/X _4541_/X VGND VGND VPWR VPWR _4584_/X sky130_fd_sc_hd__a31o_2
X_3604_ _4474_/S _3604_/B VGND VGND VPWR VPWR _3934_/A sky130_fd_sc_hd__nor2_2
X_3535_ _3535_/A VGND VGND VPWR VPWR _3535_/Y sky130_fd_sc_hd__inv_2
X_3466_ _3494_/A _3466_/B VGND VGND VPWR VPWR _5205_/D sky130_fd_sc_hd__nor2_2
X_5205_ _5251_/CLK _5205_/D VGND VGND VPWR VPWR _5205_/Q sky130_fd_sc_hd__dfxtp_2
X_3397_ _5159_/Q _5140_/Q VGND VGND VPWR VPWR _3400_/A sky130_fd_sc_hd__nand2_2
XFILLER_57_514 VGND VGND VPWR VPWR sky130_fd_sc_hd__decap_3
XFILLER_69_374 VGND VGND VPWR VPWR sky130_fd_sc_hd__decap_3
X_5136_ _5177_/CLK _5136_/D VGND VGND VPWR VPWR _5136_/Q sky130_fd_sc_hd__dfxtp_4
X_5067_ _5101_/CLK _5067_/D VGND VGND VPWR VPWR _5067_/Q sky130_fd_sc_hd__dfxtp_2
XFILLER_44_219 VGND VGND VPWR VPWR sky130_fd_sc_hd__decap_3
XFILLER_72_528 VGND VGND VPWR VPWR sky130_fd_sc_hd__fill_1
X_4018_ _4071_/A _3873_/X _3960_/Y VGND VGND VPWR VPWR _4018_/X sky130_fd_sc_hd__o21a_2
XTAP_TAPCELL_ROW_55_726 VGND VPWR sky130_fd_sc_hd__tapvpwrvgnd_1
XFILLER_84_388 VGND VGND VPWR VPWR sky130_fd_sc_hd__decap_3
XFILLER_16_24 VGND VGND VPWR VPWR sky130_fd_sc_hd__decap_3
XFILLER_25_411 VGND VGND VPWR VPWR sky130_fd_sc_hd__decap_3
XFILLER_72_539 VGND VGND VPWR VPWR sky130_fd_sc_hd__decap_3
XFILLER_40_447 VGND VGND VPWR VPWR sky130_fd_sc_hd__decap_3
XFILLER_52_296 VGND VGND VPWR VPWR sky130_fd_sc_hd__decap_3
XFILLER_8_109 VGND VGND VPWR VPWR sky130_fd_sc_hd__decap_3
XFILLER_4_315 VGND VGND VPWR VPWR sky130_fd_sc_hd__decap_3
XFILLER_79_116 VGND VGND VPWR VPWR sky130_fd_sc_hd__fill_1
XFILLER_0_554 VGND VGND VPWR VPWR sky130_fd_sc_hd__decap_3
XFILLER_75_311 VGND VGND VPWR VPWR sky130_fd_sc_hd__decap_3
XFILLER_57_86 VGND VGND VPWR VPWR sky130_fd_sc_hd__decap_3
XFILLER_87_182 VGND VGND VPWR VPWR sky130_fd_sc_hd__fill_2
XFILLER_63_528 VGND VGND VPWR VPWR sky130_fd_sc_hd__decap_3
XFILLER_75_366 VGND VGND VPWR VPWR sky130_fd_sc_hd__decap_3
XFILLER_75_388 VGND VGND VPWR VPWR sky130_fd_sc_hd__decap_3
XFILLER_90_347 VGND VGND VPWR VPWR sky130_fd_sc_hd__decap_3
XFILLER_73_74 VGND VGND VPWR VPWR sky130_fd_sc_hd__decap_3
XFILLER_16_477 VGND VGND VPWR VPWR sky130_fd_sc_hd__decap_3
XFILLER_43_263 VGND VGND VPWR VPWR sky130_fd_sc_hd__decap_3
XTAP_TAPCELL_ROW_26_450 VGND VPWR sky130_fd_sc_hd__tapvpwrvgnd_1
XFILLER_92_9 VGND VGND VPWR VPWR sky130_fd_sc_hd__fill_1
XFILLER_11_160 VGND VGND VPWR VPWR sky130_fd_sc_hd__decap_3
XFILLER_7_142 VGND VGND VPWR VPWR sky130_fd_sc_hd__decap_3
X_3320_ input12/X _5286_/D _4868_/A2 _4870_/B1 _5157_/Q VGND VGND VPWR VPWR _5157_/D
+ sky130_fd_sc_hd__a32o_2
XFILLER_3_381 VGND VGND VPWR VPWR sky130_fd_sc_hd__decap_3
X_3251_ _5283_/Q _3338_/B _3251_/C VGND VGND VPWR VPWR _3251_/X sky130_fd_sc_hd__and3_2
XFILLER_21_3 VGND VGND VPWR VPWR sky130_fd_sc_hd__decap_3
X_3182_ _2921_/X _3191_/A2 _3191_/B1 _5085_/Q VGND VGND VPWR VPWR _5085_/D sky130_fd_sc_hd__a22o_2
XFILLER_85_119 VGND VGND VPWR VPWR sky130_fd_sc_hd__decap_3
XFILLER_66_344 VGND VGND VPWR VPWR sky130_fd_sc_hd__decap_3
XFILLER_78_182 VGND VGND VPWR VPWR sky130_fd_sc_hd__decap_3
XFILLER_54_506 VGND VGND VPWR VPWR sky130_fd_sc_hd__decap_3
XFILLER_66_388 VGND VGND VPWR VPWR sky130_fd_sc_hd__decap_3
XFILLER_62_550 VGND VGND VPWR VPWR sky130_fd_sc_hd__decap_3
XFILLER_81_358 VGND VGND VPWR VPWR sky130_fd_sc_hd__decap_3
XFILLER_34_285 VGND VGND VPWR VPWR sky130_fd_sc_hd__decap_3
XFILLER_22_436 VGND VGND VPWR VPWR sky130_fd_sc_hd__decap_3
X_2966_ _2937_/X _2970_/A2 _2954_/Y _4898_/Q VGND VGND VPWR VPWR _4898_/D sky130_fd_sc_hd__a22o_2
XTAP_TAPCELL_ROW_60_773 VGND VPWR sky130_fd_sc_hd__tapvpwrvgnd_1
XFILLER_30_480 VGND VGND VPWR VPWR sky130_fd_sc_hd__decap_3
X_4705_ _5247_/Q _4725_/B VGND VGND VPWR VPWR _4705_/X sky130_fd_sc_hd__or2_2
X_2897_ _2897_/A _2897_/B VGND VGND VPWR VPWR _2897_/X sky130_fd_sc_hd__or2_2
X_4636_ _4184_/X _4630_/X _4635_/X _4541_/X VGND VGND VPWR VPWR _4636_/X sky130_fd_sc_hd__a31o_2
X_4567_ _4567_/A _4567_/B _4567_/C VGND VGND VPWR VPWR _4567_/X sky130_fd_sc_hd__and3_2
X_4498_ _4318_/A _4638_/S _3867_/Y VGND VGND VPWR VPWR _4498_/Y sky130_fd_sc_hd__o21ai_2
X_3518_ _3705_/A _3518_/B VGND VGND VPWR VPWR _3518_/X sky130_fd_sc_hd__or2_2
XFILLER_89_447 VGND VGND VPWR VPWR sky130_fd_sc_hd__fill_1
XFILLER_89_425 VGND VGND VPWR VPWR sky130_fd_sc_hd__fill_2
X_3449_ _5203_/Q _4854_/B _3447_/Y _3448_/X VGND VGND VPWR VPWR _3450_/B sky130_fd_sc_hd__o2bb2a_2
XFILLER_57_333 VGND VGND VPWR VPWR sky130_fd_sc_hd__decap_3
X_5119_ _5176_/CLK _5119_/D VGND VGND VPWR VPWR _5119_/Q sky130_fd_sc_hd__dfxtp_2
XFILLER_57_377 VGND VGND VPWR VPWR sky130_fd_sc_hd__fill_2
XTAP_TAPCELL_ROW_68_851 VGND VPWR sky130_fd_sc_hd__tapvpwrvgnd_1
XFILLER_57_399 VGND VGND VPWR VPWR sky130_fd_sc_hd__decap_3
XFILLER_13_425 VGND VGND VPWR VPWR sky130_fd_sc_hd__decap_3
XFILLER_13_458 VGND VGND VPWR VPWR sky130_fd_sc_hd__decap_3
XFILLER_43_55 VGND VGND VPWR VPWR sky130_fd_sc_hd__fill_1
XTAP_TAPCELL_ROW_23_420 VGND VPWR sky130_fd_sc_hd__tapvpwrvgnd_1
XFILLER_9_407 VGND VGND VPWR VPWR sky130_fd_sc_hd__decap_3
XFILLER_43_99 VGND VGND VPWR VPWR sky130_fd_sc_hd__decap_3
XFILLER_0_351 VGND VGND VPWR VPWR sky130_fd_sc_hd__decap_3
XFILLER_67_108 VGND VGND VPWR VPWR sky130_fd_sc_hd__decap_3
XFILLER_67_119 VGND VGND VPWR VPWR sky130_fd_sc_hd__decap_3
XFILLER_68_74 VGND VGND VPWR VPWR sky130_fd_sc_hd__fill_1
XFILLER_68_85 VGND VGND VPWR VPWR sky130_fd_sc_hd__decap_3
XFILLER_88_491 VGND VGND VPWR VPWR sky130_fd_sc_hd__decap_3
XFILLER_48_355 VGND VGND VPWR VPWR sky130_fd_sc_hd__decap_3
XFILLER_36_528 VGND VGND VPWR VPWR sky130_fd_sc_hd__fill_1
XFILLER_48_399 VGND VGND VPWR VPWR sky130_fd_sc_hd__decap_3
XFILLER_63_325 VGND VGND VPWR VPWR sky130_fd_sc_hd__fill_2
XFILLER_84_51 VGND VGND VPWR VPWR sky130_fd_sc_hd__decap_3
XFILLER_16_230 VGND VGND VPWR VPWR sky130_fd_sc_hd__fill_2
XFILLER_63_347 VGND VGND VPWR VPWR sky130_fd_sc_hd__decap_3
XFILLER_71_391 VGND VGND VPWR VPWR sky130_fd_sc_hd__fill_1
XFILLER_90_6 VGND VGND VPWR VPWR sky130_fd_sc_hd__decap_3
X_2820_ _2815_/X _2816_/X _2819_/X _2435_/Y VGND VGND VPWR VPWR _4808_/B sky130_fd_sc_hd__a22o_2
XFILLER_12_480 VGND VGND VPWR VPWR sky130_fd_sc_hd__decap_3
X_2751_ _5067_/Q _5051_/Q _5035_/Q _5019_/Q _2851_/S0 _2854_/S1 VGND VGND VPWR VPWR
+ _2751_/X sky130_fd_sc_hd__mux4_2
XFILLER_8_440 VGND VGND VPWR VPWR sky130_fd_sc_hd__decap_3
X_2682_ _2683_/A _2683_/B VGND VGND VPWR VPWR _3838_/A sky130_fd_sc_hd__and2_2
XFILLER_8_473 VGND VGND VPWR VPWR sky130_fd_sc_hd__decap_3
XFILLER_69_3 VGND VGND VPWR VPWR sky130_fd_sc_hd__fill_1
X_4421_ _4281_/Y _4284_/X _4422_/S VGND VGND VPWR VPWR _4558_/S sky130_fd_sc_hd__mux2_1
X_4352_ _4353_/A _4353_/B VGND VGND VPWR VPWR _4354_/A sky130_fd_sc_hd__or2_2
X_4283_ _4732_/A _5156_/Q _5158_/Q VGND VGND VPWR VPWR _4284_/B sky130_fd_sc_hd__o21ai_2
X_3303_ _5271_/Q _3305_/B _3302_/Y _3338_/B VGND VGND VPWR VPWR _5150_/D sky130_fd_sc_hd__o211a_2
XFILLER_58_119 VGND VGND VPWR VPWR sky130_fd_sc_hd__decap_3
X_3234_ _5173_/Q _4868_/A2 _4870_/B1 _3233_/X VGND VGND VPWR VPWR _5128_/D sky130_fd_sc_hd__o22a_2
XFILLER_39_322 VGND VGND VPWR VPWR sky130_fd_sc_hd__decap_3
XFILLER_27_517 VGND VGND VPWR VPWR sky130_fd_sc_hd__decap_3
XFILLER_39_355 VGND VGND VPWR VPWR sky130_fd_sc_hd__decap_3
XFILLER_66_141 VGND VGND VPWR VPWR sky130_fd_sc_hd__fill_2
X_3165_ _2924_/X _3173_/A2 _3157_/Y _5070_/Q VGND VGND VPWR VPWR _5070_/D sky130_fd_sc_hd__a22o_2
X_3096_ _2937_/X _3100_/A2 _3084_/Y _5010_/Q VGND VGND VPWR VPWR _5010_/D sky130_fd_sc_hd__a22o_2
XTAP_TAPCELL_ROW_65_821 VGND VPWR sky130_fd_sc_hd__tapvpwrvgnd_1
XTAP_TAPCELL_ROW_37_556 VGND VPWR sky130_fd_sc_hd__tapvpwrvgnd_1
XFILLER_81_133 VGND VGND VPWR VPWR sky130_fd_sc_hd__decap_3
XFILLER_22_233 VGND VGND VPWR VPWR sky130_fd_sc_hd__fill_2
X_3998_ _3998_/A _3998_/B VGND VGND VPWR VPWR _3998_/X sky130_fd_sc_hd__or2_2
X_2949_ _5276_/Q _5225_/Q _5209_/Q _5275_/Q VGND VGND VPWR VPWR _2949_/X sky130_fd_sc_hd__a22o_2
X_4619_ _2706_/B _4168_/A _4619_/S VGND VGND VPWR VPWR _4619_/X sky130_fd_sc_hd__mux2_1
Xmax_cap170 _5136_/Q VGND VGND VPWR VPWR _2854_/S1 sky130_fd_sc_hd__buf_12
XFILLER_89_211 VGND VGND VPWR VPWR sky130_fd_sc_hd__fill_1
Xmax_cap181 _5128_/Q VGND VGND VPWR VPWR _2676_/S1 sky130_fd_sc_hd__buf_12
XFILLER_77_428 VGND VGND VPWR VPWR sky130_fd_sc_hd__decap_3
XFILLER_38_55 VGND VGND VPWR VPWR sky130_fd_sc_hd__decap_3
XFILLER_38_88 VGND VGND VPWR VPWR sky130_fd_sc_hd__decap_3
XFILLER_18_528 VGND VGND VPWR VPWR sky130_fd_sc_hd__decap_3
XFILLER_45_325 VGND VGND VPWR VPWR sky130_fd_sc_hd__decap_3
XFILLER_85_494 VGND VGND VPWR VPWR sky130_fd_sc_hd__decap_3
XFILLER_54_32 VGND VGND VPWR VPWR sky130_fd_sc_hd__decap_3
XFILLER_72_155 VGND VGND VPWR VPWR sky130_fd_sc_hd__decap_3
XFILLER_54_43 VGND VGND VPWR VPWR sky130_fd_sc_hd__decap_3
XTAP_TAPCELL_ROW_0_192 VGND VPWR sky130_fd_sc_hd__tapvpwrvgnd_1
XFILLER_13_255 VGND VGND VPWR VPWR sky130_fd_sc_hd__decap_3
XFILLER_41_553 VGND VGND VPWR VPWR sky130_fd_sc_hd__decap_3
XTAP_TAPCELL_ROW_71_879 VGND VPWR sky130_fd_sc_hd__tapvpwrvgnd_1
XFILLER_9_248 VGND VGND VPWR VPWR sky130_fd_sc_hd__decap_3
XFILLER_70_97 VGND VGND VPWR VPWR sky130_fd_sc_hd__fill_2
Xclkload29 _5208_/CLK VGND VGND VPWR VPWR clkload29/X sky130_fd_sc_hd__clkbuf_8
Xclkload18 _5107_/CLK VGND VGND VPWR VPWR clkload18/Y sky130_fd_sc_hd__bufinv_16
XFILLER_5_498 VGND VGND VPWR VPWR sky130_fd_sc_hd__decap_3
XFILLER_79_40 VGND VGND VPWR VPWR sky130_fd_sc_hd__decap_3
XTAP_TAPCELL_ROW_8_281 VGND VPWR sky130_fd_sc_hd__tapvpwrvgnd_1
XFILLER_48_141 VGND VGND VPWR VPWR sky130_fd_sc_hd__decap_3
XFILLER_36_325 VGND VGND VPWR VPWR sky130_fd_sc_hd__decap_3
XFILLER_63_111 VGND VGND VPWR VPWR sky130_fd_sc_hd__fill_1
XFILLER_76_483 VGND VGND VPWR VPWR sky130_fd_sc_hd__decap_3
XFILLER_36_347 VGND VGND VPWR VPWR sky130_fd_sc_hd__decap_3
XFILLER_63_122 VGND VGND VPWR VPWR sky130_fd_sc_hd__fill_1
XFILLER_63_155 VGND VGND VPWR VPWR sky130_fd_sc_hd__decap_3
XFILLER_51_306 VGND VGND VPWR VPWR sky130_fd_sc_hd__decap_3
X_4970_ clkload9/A _4970_/D VGND VGND VPWR VPWR _4970_/Q sky130_fd_sc_hd__dfxtp_2
XFILLER_91_486 VGND VGND VPWR VPWR sky130_fd_sc_hd__decap_3
XFILLER_32_531 VGND VGND VPWR VPWR sky130_fd_sc_hd__fill_1
XFILLER_44_380 VGND VGND VPWR VPWR sky130_fd_sc_hd__decap_3
XFILLER_44_391 VGND VGND VPWR VPWR sky130_fd_sc_hd__decap_3
X_3921_ _3919_/S _3550_/X _4078_/B VGND VGND VPWR VPWR _3921_/Y sky130_fd_sc_hd__a21oi_2
XTAP_TAPCELL_ROW_34_526 VGND VPWR sky130_fd_sc_hd__tapvpwrvgnd_1
X_3852_ _3852_/A _4638_/S VGND VGND VPWR VPWR _3852_/Y sky130_fd_sc_hd__nand2_2
X_2803_ _2857_/A _4792_/B VGND VGND VPWR VPWR _2803_/X sky130_fd_sc_hd__and2_2
X_3783_ _5210_/Q _4275_/B _3782_/Y _3366_/A VGND VGND VPWR VPWR _5210_/D sky130_fd_sc_hd__o211a_2
X_2734_ _2732_/X _2733_/X _2855_/S VGND VGND VPWR VPWR _2734_/X sky130_fd_sc_hd__mux2_1
X_2665_ _2660_/X _2661_/X _2664_/X _2433_/Y VGND VGND VPWR VPWR _4332_/C sky130_fd_sc_hd__a22o_2
X_4404_ _4404_/A _4404_/B VGND VGND VPWR VPWR _4407_/A sky130_fd_sc_hd__xnor2_2
X_2596_ _2594_/X _2595_/X _5129_/Q VGND VGND VPWR VPWR _2596_/X sky130_fd_sc_hd__mux2_1
X_4335_ _4318_/A _4321_/B _4320_/A VGND VGND VPWR VPWR _4335_/Y sky130_fd_sc_hd__a21oi_2
XFILLER_86_214 VGND VGND VPWR VPWR sky130_fd_sc_hd__decap_3
XFILLER_86_203 VGND VGND VPWR VPWR sky130_fd_sc_hd__decap_3
X_4266_ _4265_/Y _4220_/X _4266_/S VGND VGND VPWR VPWR _4266_/X sky130_fd_sc_hd__mux2_1
XFILLER_67_461 VGND VGND VPWR VPWR sky130_fd_sc_hd__decap_3
X_4197_ _4175_/A _3999_/X _4070_/X VGND VGND VPWR VPWR _4205_/D sky130_fd_sc_hd__o21ai_2
X_3217_ _2918_/X _3227_/A2 _3211_/Y _5116_/Q VGND VGND VPWR VPWR _5116_/D sky130_fd_sc_hd__a22o_2
XFILLER_67_483 VGND VGND VPWR VPWR sky130_fd_sc_hd__decap_3
X_3148_ _2927_/X _3155_/A2 _3139_/Y _5055_/Q VGND VGND VPWR VPWR _5055_/D sky130_fd_sc_hd__a22o_2
XFILLER_27_347 VGND VGND VPWR VPWR sky130_fd_sc_hd__fill_2
XFILLER_27_358 VGND VGND VPWR VPWR sky130_fd_sc_hd__decap_3
XFILLER_54_133 VGND VGND VPWR VPWR sky130_fd_sc_hd__decap_3
XFILLER_54_144 VGND VGND VPWR VPWR sky130_fd_sc_hd__fill_1
XFILLER_54_155 VGND VGND VPWR VPWR sky130_fd_sc_hd__decap_3
X_3079_ _2941_/X _3066_/B _3066_/Y _4995_/Q VGND VGND VPWR VPWR _4995_/D sky130_fd_sc_hd__a22o_2
XFILLER_82_464 VGND VGND VPWR VPWR sky130_fd_sc_hd__decap_3
XFILLER_24_24 VGND VGND VPWR VPWR sky130_fd_sc_hd__decap_3
XFILLER_35_391 VGND VGND VPWR VPWR sky130_fd_sc_hd__fill_1
XFILLER_10_225 VGND VGND VPWR VPWR sky130_fd_sc_hd__fill_1
XFILLER_6_207 VGND VGND VPWR VPWR sky130_fd_sc_hd__decap_3
XFILLER_40_56 VGND VGND VPWR VPWR sky130_fd_sc_hd__decap_3
XFILLER_77_203 VGND VGND VPWR VPWR sky130_fd_sc_hd__decap_3
XFILLER_49_65 VGND VGND VPWR VPWR sky130_fd_sc_hd__decap_3
XFILLER_77_225 VGND VGND VPWR VPWR sky130_fd_sc_hd__decap_3
XTAP_TAPCELL_ROW_5_251 VGND VPWR sky130_fd_sc_hd__tapvpwrvgnd_1
XFILLER_18_303 VGND VGND VPWR VPWR sky130_fd_sc_hd__decap_3
XFILLER_45_111 VGND VGND VPWR VPWR sky130_fd_sc_hd__fill_1
XFILLER_58_483 VGND VGND VPWR VPWR sky130_fd_sc_hd__decap_3
XTAP_TAPCELL_ROW_76_927 VGND VPWR sky130_fd_sc_hd__tapvpwrvgnd_1
XFILLER_18_336 VGND VGND VPWR VPWR sky130_fd_sc_hd__decap_3
XFILLER_73_431 VGND VGND VPWR VPWR sky130_fd_sc_hd__decap_3
XTAP_TAPCELL_ROW_86_1023 VGND VPWR sky130_fd_sc_hd__tapvpwrvgnd_1
XFILLER_60_103 VGND VGND VPWR VPWR sky130_fd_sc_hd__decap_3
XFILLER_73_464 VGND VGND VPWR VPWR sky130_fd_sc_hd__fill_2
XFILLER_73_475 VGND VGND VPWR VPWR sky130_fd_sc_hd__decap_3
XFILLER_14_520 VGND VGND VPWR VPWR sky130_fd_sc_hd__decap_3
XFILLER_73_497 VGND VGND VPWR VPWR sky130_fd_sc_hd__decap_3
XFILLER_81_52 VGND VGND VPWR VPWR sky130_fd_sc_hd__decap_3
XFILLER_81_85 VGND VGND VPWR VPWR sky130_fd_sc_hd__decap_3
XFILLER_5_273 VGND VGND VPWR VPWR sky130_fd_sc_hd__decap_3
X_2450_ _5183_/Q _5182_/Q _5181_/Q VGND VGND VPWR VPWR _3891_/B sky130_fd_sc_hd__or3b_2
XFILLER_68_203 VGND VGND VPWR VPWR sky130_fd_sc_hd__fill_2
X_4120_ _4199_/C _4119_/Y _4189_/A VGND VGND VPWR VPWR _4120_/Y sky130_fd_sc_hd__o21ai_2
X_4051_ _4051_/A _4051_/B VGND VGND VPWR VPWR _4055_/C sky130_fd_sc_hd__or2_2
XFILLER_36_100 VGND VGND VPWR VPWR sky130_fd_sc_hd__decap_3
Xinput5 INSTR_STREAM[13] VGND VGND VPWR VPWR input5/X sky130_fd_sc_hd__clkdlybuf4s25_1
X_3002_ _2927_/X _2993_/B _2993_/Y _4927_/Q VGND VGND VPWR VPWR _4927_/D sky130_fd_sc_hd__a22o_2
XFILLER_83_217 VGND VGND VPWR VPWR sky130_fd_sc_hd__decap_3
XFILLER_36_133 VGND VGND VPWR VPWR sky130_fd_sc_hd__decap_3
XFILLER_36_144 VGND VGND VPWR VPWR sky130_fd_sc_hd__decap_3
XTAP_TAPCELL_ROW_47_651 VGND VPWR sky130_fd_sc_hd__tapvpwrvgnd_1
X_4953_ _4994_/CLK _4953_/D VGND VGND VPWR VPWR _4953_/Q sky130_fd_sc_hd__dfxtp_2
XTAP_TAPCELL_ROW_19_386 VGND VPWR sky130_fd_sc_hd__tapvpwrvgnd_1
XFILLER_91_294 VGND VGND VPWR VPWR sky130_fd_sc_hd__decap_3
XFILLER_51_169 VGND VGND VPWR VPWR sky130_fd_sc_hd__decap_3
X_3904_ _4393_/A _3905_/B _3903_/Y VGND VGND VPWR VPWR _3904_/Y sky130_fd_sc_hd__o21ai_2
XFILLER_20_501 VGND VGND VPWR VPWR sky130_fd_sc_hd__decap_3
XFILLER_20_512 VGND VGND VPWR VPWR sky130_fd_sc_hd__decap_3
XFILLER_32_383 VGND VGND VPWR VPWR sky130_fd_sc_hd__decap_3
X_4884_ _5109_/CLK _4884_/D VGND VGND VPWR VPWR _4884_/Q sky130_fd_sc_hd__dfxtp_2
XFILLER_20_556 VGND VGND VPWR VPWR sky130_fd_sc_hd__fill_2
X_3835_ _5164_/Q _4397_/B VGND VGND VPWR VPWR _4124_/B sky130_fd_sc_hd__and2b_2
X_3766_ _5182_/Q _3766_/B VGND VGND VPWR VPWR _3886_/B sky130_fd_sc_hd__nand2_2
X_2717_ _5111_/Q _4999_/Q _4983_/Q _4967_/Q _5135_/Q _5136_/Q VGND VGND VPWR VPWR
+ _2718_/B sky130_fd_sc_hd__mux4_2
X_3697_ _5120_/Q _5008_/Q _4992_/Q _4976_/Q _3732_/S0 _3732_/S1 VGND VGND VPWR VPWR
+ _3697_/X sky130_fd_sc_hd__mux4_2
X_2648_ _5071_/Q _5055_/Q _5039_/Q _5023_/Q _2672_/S0 _2672_/S1 VGND VGND VPWR VPWR
+ _2648_/X sky130_fd_sc_hd__mux4_2
X_2579_ _2660_/A _2579_/B VGND VGND VPWR VPWR _2579_/X sky130_fd_sc_hd__or2_2
XFILLER_87_501 VGND VGND VPWR VPWR sky130_fd_sc_hd__decap_3
XFILLER_59_225 VGND VGND VPWR VPWR sky130_fd_sc_hd__fill_1
XFILLER_59_236 VGND VGND VPWR VPWR sky130_fd_sc_hd__decap_3
X_4318_ _4318_/A _4320_/B VGND VGND VPWR VPWR _4356_/A sky130_fd_sc_hd__nor2_2
XFILLER_87_523 VGND VGND VPWR VPWR sky130_fd_sc_hd__decap_3
X_4249_ _2695_/B _3764_/X _4278_/B _3778_/B _4168_/A VGND VGND VPWR VPWR _4249_/X
+ sky130_fd_sc_hd__a221o_2
XFILLER_87_556 VGND VGND VPWR VPWR sky130_fd_sc_hd__fill_2
XFILLER_19_57 VGND VGND VPWR VPWR sky130_fd_sc_hd__decap_3
XFILLER_19_68 VGND VGND VPWR VPWR sky130_fd_sc_hd__decap_3
XFILLER_27_100 VGND VGND VPWR VPWR sky130_fd_sc_hd__decap_3
XTAP_TAPCELL_ROW_2_221 VGND VPWR sky130_fd_sc_hd__tapvpwrvgnd_1
XFILLER_35_12 VGND VGND VPWR VPWR sky130_fd_sc_hd__decap_3
XFILLER_35_23 VGND VGND VPWR VPWR sky130_fd_sc_hd__decap_3
XFILLER_55_464 VGND VGND VPWR VPWR sky130_fd_sc_hd__fill_2
XFILLER_70_412 VGND VGND VPWR VPWR sky130_fd_sc_hd__decap_3
XFILLER_82_272 VGND VGND VPWR VPWR sky130_fd_sc_hd__decap_3
XFILLER_82_294 VGND VGND VPWR VPWR sky130_fd_sc_hd__decap_3
XTAP_TAPCELL_ROW_81_974 VGND VPWR sky130_fd_sc_hd__tapvpwrvgnd_1
XFILLER_11_523 VGND VGND VPWR VPWR sky130_fd_sc_hd__decap_3
XFILLER_23_372 VGND VGND VPWR VPWR sky130_fd_sc_hd__fill_2
XFILLER_11_556 VGND VGND VPWR VPWR sky130_fd_sc_hd__fill_2
XFILLER_51_77 VGND VGND VPWR VPWR sky130_fd_sc_hd__decap_3
XTAP_TAPCELL_ROW_92_1071 VGND VPWR sky130_fd_sc_hd__tapvpwrvgnd_1
XFILLER_78_545 VGND VGND VPWR VPWR sky130_fd_sc_hd__decap_3
XFILLER_18_9 VGND VGND VPWR VPWR sky130_fd_sc_hd__fill_2
XFILLER_65_217 VGND VGND VPWR VPWR sky130_fd_sc_hd__decap_3
XFILLER_93_526 VGND VGND VPWR VPWR sky130_fd_sc_hd__decap_3
XFILLER_76_85 VGND VGND VPWR VPWR sky130_fd_sc_hd__decap_3
XFILLER_93_548 VGND VGND VPWR VPWR sky130_fd_sc_hd__decap_3
XFILLER_46_464 VGND VGND VPWR VPWR sky130_fd_sc_hd__decap_3
XFILLER_46_486 VGND VGND VPWR VPWR sky130_fd_sc_hd__decap_3
XFILLER_61_434 VGND VGND VPWR VPWR sky130_fd_sc_hd__decap_3
XTAP_TAPCELL_ROW_44_621 VGND VPWR sky130_fd_sc_hd__tapvpwrvgnd_1
XFILLER_33_147 VGND VGND VPWR VPWR sky130_fd_sc_hd__decap_3
XFILLER_33_169 VGND VGND VPWR VPWR sky130_fd_sc_hd__decap_3
XTAP_TAPCELL_ROW_16_356 VGND VPWR sky130_fd_sc_hd__tapvpwrvgnd_1
X_3620_ _4357_/B _4286_/A VGND VGND VPWR VPWR _3892_/A sky130_fd_sc_hd__xnor2_2
X_3551_ _3825_/B _3866_/B VGND VGND VPWR VPWR _3551_/Y sky130_fd_sc_hd__nand2b_2
X_2502_ _2500_/X _2501_/X _2660_/A VGND VGND VPWR VPWR _2502_/X sky130_fd_sc_hd__mux2_1
X_3482_ _3494_/A _3482_/B VGND VGND VPWR VPWR _5207_/D sky130_fd_sc_hd__nor2_2
X_5221_ _5257_/CLK _5221_/D VGND VGND VPWR VPWR _5221_/Q sky130_fd_sc_hd__dfxtp_2
X_2433_ _5130_/Q VGND VGND VPWR VPWR _2433_/Y sky130_fd_sc_hd__inv_2
XFILLER_69_534 VGND VGND VPWR VPWR sky130_fd_sc_hd__fill_2
X_5152_ _5208_/CLK _5152_/D VGND VGND VPWR VPWR _5152_/Q sky130_fd_sc_hd__dfxtp_2
X_4103_ _4103_/A _4103_/B VGND VGND VPWR VPWR _4224_/B sky130_fd_sc_hd__nand2_2
X_5083_ _5083_/CLK _5083_/D VGND VGND VPWR VPWR _5083_/Q sky130_fd_sc_hd__dfxtp_2
XFILLER_84_515 VGND VGND VPWR VPWR sky130_fd_sc_hd__decap_3
X_4034_ _3615_/B _4022_/A _4009_/X _4503_/A VGND VGND VPWR VPWR _4034_/X sky130_fd_sc_hd__o31a_2
XFILLER_52_401 VGND VGND VPWR VPWR sky130_fd_sc_hd__decap_3
XFILLER_37_497 VGND VGND VPWR VPWR sky130_fd_sc_hd__decap_3
XFILLER_64_272 VGND VGND VPWR VPWR sky130_fd_sc_hd__fill_2
XFILLER_64_283 VGND VGND VPWR VPWR sky130_fd_sc_hd__decap_3
XFILLER_12_309 VGND VGND VPWR VPWR sky130_fd_sc_hd__decap_3
XFILLER_24_158 VGND VGND VPWR VPWR sky130_fd_sc_hd__fill_2
X_4936_ _5010_/CLK _4936_/D VGND VGND VPWR VPWR _4936_/Q sky130_fd_sc_hd__dfxtp_2
XFILLER_32_180 VGND VGND VPWR VPWR sky130_fd_sc_hd__decap_3
X_4867_ _5176_/Q _4868_/A2 _4870_/B1 _3247_/X VGND VGND VPWR VPWR _5176_/D sky130_fd_sc_hd__o22a_2
X_3818_ _4732_/A _4320_/A VGND VGND VPWR VPWR _3818_/X sky130_fd_sc_hd__and2b_2
XTAP_TAPCELL_ROW_50_679 VGND VPWR sky130_fd_sc_hd__tapvpwrvgnd_1
X_4798_ _5166_/Q _4799_/B VGND VGND VPWR VPWR _4800_/A sky130_fd_sc_hd__nand2_2
XFILLER_21_47 VGND VGND VPWR VPWR sky130_fd_sc_hd__fill_1
X_3749_ _3749_/A _4011_/A _3749_/C _3749_/D VGND VGND VPWR VPWR _3750_/A sky130_fd_sc_hd__or4_2
XFILLER_79_309 VGND VGND VPWR VPWR sky130_fd_sc_hd__decap_3
XFILLER_87_342 VGND VGND VPWR VPWR sky130_fd_sc_hd__decap_3
XFILLER_87_331 VGND VGND VPWR VPWR sky130_fd_sc_hd__decap_3
XFILLER_47_228 VGND VGND VPWR VPWR sky130_fd_sc_hd__fill_1
XFILLER_87_386 VGND VGND VPWR VPWR sky130_fd_sc_hd__decap_3
XFILLER_87_375 VGND VGND VPWR VPWR sky130_fd_sc_hd__decap_3
XTAP_TAPCELL_ROW_58_757 VGND VPWR sky130_fd_sc_hd__tapvpwrvgnd_1
XFILLER_28_464 VGND VGND VPWR VPWR sky130_fd_sc_hd__decap_3
XFILLER_62_209 VGND VGND VPWR VPWR sky130_fd_sc_hd__decap_3
XFILLER_15_125 VGND VGND VPWR VPWR sky130_fd_sc_hd__decap_3
XFILLER_28_486 VGND VGND VPWR VPWR sky130_fd_sc_hd__decap_3
XFILLER_15_158 VGND VGND VPWR VPWR sky130_fd_sc_hd__decap_3
XFILLER_15_169 VGND VGND VPWR VPWR sky130_fd_sc_hd__decap_3
XFILLER_70_275 VGND VGND VPWR VPWR sky130_fd_sc_hd__decap_3
XTAP_TAPCELL_ROW_13_326 VGND VPWR sky130_fd_sc_hd__tapvpwrvgnd_1
XFILLER_7_313 VGND VGND VPWR VPWR sky130_fd_sc_hd__decap_3
XFILLER_7_335 VGND VGND VPWR VPWR sky130_fd_sc_hd__fill_1
XFILLER_7_379 VGND VGND VPWR VPWR sky130_fd_sc_hd__decap_3
XFILLER_11_91 VGND VGND VPWR VPWR sky130_fd_sc_hd__decap_3
XFILLER_3_541 VGND VGND VPWR VPWR sky130_fd_sc_hd__decap_3
XFILLER_66_526 VGND VGND VPWR VPWR sky130_fd_sc_hd__decap_3
XFILLER_93_312 VGND VGND VPWR VPWR sky130_fd_sc_hd__decap_3
XFILLER_34_401 VGND VGND VPWR VPWR sky130_fd_sc_hd__decap_3
XFILLER_93_389 VGND VGND VPWR VPWR sky130_fd_sc_hd__decap_3
XFILLER_19_486 VGND VGND VPWR VPWR sky130_fd_sc_hd__decap_3
XFILLER_46_261 VGND VGND VPWR VPWR sky130_fd_sc_hd__fill_2
XTAP_TAPCELL_ROW_29_481 VGND VPWR sky130_fd_sc_hd__tapvpwrvgnd_1
XFILLER_34_445 VGND VGND VPWR VPWR sky130_fd_sc_hd__decap_3
XFILLER_61_231 VGND VGND VPWR VPWR sky130_fd_sc_hd__decap_3
XFILLER_21_106 VGND VGND VPWR VPWR sky130_fd_sc_hd__decap_3
XFILLER_34_489 VGND VGND VPWR VPWR sky130_fd_sc_hd__decap_3
X_2982_ _2924_/X _2974_/B _2974_/Y _4910_/Q VGND VGND VPWR VPWR _4910_/D sky130_fd_sc_hd__a22o_2
XFILLER_14_191 VGND VGND VPWR VPWR sky130_fd_sc_hd__decap_3
XFILLER_21_139 VGND VGND VPWR VPWR sky130_fd_sc_hd__fill_2
XFILLER_61_297 VGND VGND VPWR VPWR sky130_fd_sc_hd__decap_3
X_4721_ _5255_/Q _4725_/B VGND VGND VPWR VPWR _4721_/X sky130_fd_sc_hd__or2_2
X_4652_ _4376_/A _4638_/S _3852_/Y VGND VGND VPWR VPWR _4653_/A sky130_fd_sc_hd__o21a_2
Xinput30 INSTR_STREAM[7] VGND VGND VPWR VPWR _3330_/C sky130_fd_sc_hd__clkdlybuf4s25_1
X_3603_ _4357_/A _4281_/A VGND VGND VPWR VPWR _3604_/B sky130_fd_sc_hd__and2_2
X_4583_ _4437_/X _4578_/Y _4581_/X _4582_/X VGND VGND VPWR VPWR _4583_/X sky130_fd_sc_hd__o211a_2
Xinput41 MEM_LD_DATA[2] VGND VGND VPWR VPWR input41/X sky130_fd_sc_hd__clkdlybuf4s25_1
X_3534_ _4397_/B _3701_/A _3866_/B VGND VGND VPWR VPWR _3535_/A sky130_fd_sc_hd__mux2_1
X_3465_ _5205_/Q _4854_/B _3463_/X _3464_/Y VGND VGND VPWR VPWR _3466_/B sky130_fd_sc_hd__a22oi_2
X_5204_ _5251_/CLK _5204_/D VGND VGND VPWR VPWR _5204_/Q sky130_fd_sc_hd__dfxtp_2
XFILLER_88_117 VGND VGND VPWR VPWR sky130_fd_sc_hd__decap_3
XFILLER_69_353 VGND VGND VPWR VPWR sky130_fd_sc_hd__decap_3
X_3396_ _5197_/Q _4854_/B VGND VGND VPWR VPWR _3396_/Y sky130_fd_sc_hd__nand2_2
XFILLER_69_364 VGND VGND VPWR VPWR sky130_fd_sc_hd__fill_1
X_5135_ _5176_/CLK _5135_/D VGND VGND VPWR VPWR _5135_/Q sky130_fd_sc_hd__dfxtp_4
XFILLER_84_312 VGND VGND VPWR VPWR sky130_fd_sc_hd__fill_1
X_5066_ _5099_/CLK _5066_/D VGND VGND VPWR VPWR _5066_/Q sky130_fd_sc_hd__dfxtp_2
XFILLER_84_345 VGND VGND VPWR VPWR sky130_fd_sc_hd__decap_3
XFILLER_72_507 VGND VGND VPWR VPWR sky130_fd_sc_hd__decap_3
X_4017_ _4016_/A _3877_/X _4016_/Y _4070_/A VGND VGND VPWR VPWR _4017_/X sky130_fd_sc_hd__o211a_2
XFILLER_37_272 VGND VGND VPWR VPWR sky130_fd_sc_hd__decap_3
XTAP_TAPCELL_ROW_55_727 VGND VPWR sky130_fd_sc_hd__tapvpwrvgnd_1
XFILLER_16_47 VGND VGND VPWR VPWR sky130_fd_sc_hd__decap_3
XFILLER_25_467 VGND VGND VPWR VPWR sky130_fd_sc_hd__decap_3
XFILLER_12_106 VGND VGND VPWR VPWR sky130_fd_sc_hd__fill_2
XFILLER_40_415 VGND VGND VPWR VPWR sky130_fd_sc_hd__decap_3
XFILLER_52_264 VGND VGND VPWR VPWR sky130_fd_sc_hd__fill_2
XFILLER_40_459 VGND VGND VPWR VPWR sky130_fd_sc_hd__decap_3
X_4919_ clkload3/A _4919_/D VGND VGND VPWR VPWR _4919_/Q sky130_fd_sc_hd__dfxtp_2
XFILLER_32_35 VGND VGND VPWR VPWR sky130_fd_sc_hd__decap_3
XFILLER_20_161 VGND VGND VPWR VPWR sky130_fd_sc_hd__decap_3
XFILLER_32_68 VGND VGND VPWR VPWR sky130_fd_sc_hd__decap_3
XFILLER_4_338 VGND VGND VPWR VPWR sky130_fd_sc_hd__decap_3
XFILLER_0_500 VGND VGND VPWR VPWR sky130_fd_sc_hd__decap_3
XFILLER_0_511 VGND VGND VPWR VPWR sky130_fd_sc_hd__decap_3
XFILLER_0_533 VGND VGND VPWR VPWR sky130_fd_sc_hd__decap_3
XFILLER_48_504 VGND VGND VPWR VPWR sky130_fd_sc_hd__decap_3
XFILLER_87_161 VGND VGND VPWR VPWR sky130_fd_sc_hd__decap_3
XFILLER_87_150 VGND VGND VPWR VPWR sky130_fd_sc_hd__fill_1
XFILLER_48_548 VGND VGND VPWR VPWR sky130_fd_sc_hd__decap_3
XFILLER_75_323 VGND VGND VPWR VPWR sky130_fd_sc_hd__decap_3
XFILLER_28_294 VGND VGND VPWR VPWR sky130_fd_sc_hd__decap_3
XFILLER_43_242 VGND VGND VPWR VPWR sky130_fd_sc_hd__decap_3
XFILLER_71_551 VGND VGND VPWR VPWR sky130_fd_sc_hd__decap_3
XFILLER_90_359 VGND VGND VPWR VPWR sky130_fd_sc_hd__decap_3
XFILLER_31_426 VGND VGND VPWR VPWR sky130_fd_sc_hd__decap_3
XTAP_TAPCELL_ROW_26_451 VGND VPWR sky130_fd_sc_hd__tapvpwrvgnd_1
XFILLER_43_297 VGND VGND VPWR VPWR sky130_fd_sc_hd__decap_3
XFILLER_85_9 VGND VGND VPWR VPWR sky130_fd_sc_hd__decap_3
XFILLER_7_110 VGND VGND VPWR VPWR sky130_fd_sc_hd__fill_2
XFILLER_7_154 VGND VGND VPWR VPWR sky130_fd_sc_hd__fill_2
XFILLER_7_187 VGND VGND VPWR VPWR sky130_fd_sc_hd__decap_3
XFILLER_3_393 VGND VGND VPWR VPWR sky130_fd_sc_hd__decap_3
X_3250_ _5177_/Q _4868_/A2 _4870_/B1 _3249_/X VGND VGND VPWR VPWR _5136_/D sky130_fd_sc_hd__o22a_2
XFILLER_39_515 VGND VGND VPWR VPWR sky130_fd_sc_hd__decap_3
XFILLER_66_312 VGND VGND VPWR VPWR sky130_fd_sc_hd__decap_3
X_3181_ _2918_/X _3191_/A2 _3191_/B1 _5084_/Q VGND VGND VPWR VPWR _5084_/D sky130_fd_sc_hd__a22o_2
XFILLER_78_161 VGND VGND VPWR VPWR sky130_fd_sc_hd__fill_1
XFILLER_14_3 VGND VGND VPWR VPWR sky130_fd_sc_hd__decap_3
XFILLER_39_537 VGND VGND VPWR VPWR sky130_fd_sc_hd__decap_3
XFILLER_19_250 VGND VGND VPWR VPWR sky130_fd_sc_hd__decap_3
XFILLER_26_209 VGND VGND VPWR VPWR sky130_fd_sc_hd__decap_3
XFILLER_54_518 VGND VGND VPWR VPWR sky130_fd_sc_hd__decap_3
XFILLER_93_197 VGND VGND VPWR VPWR sky130_fd_sc_hd__decap_3
XFILLER_81_337 VGND VGND VPWR VPWR sky130_fd_sc_hd__decap_3
XFILLER_34_253 VGND VGND VPWR VPWR sky130_fd_sc_hd__decap_3
XFILLER_22_459 VGND VGND VPWR VPWR sky130_fd_sc_hd__decap_3
XFILLER_34_297 VGND VGND VPWR VPWR sky130_fd_sc_hd__decap_3
X_4704_ input43/X _4694_/Y _4703_/X _3366_/A VGND VGND VPWR VPWR _5246_/D sky130_fd_sc_hd__o211a_2
X_2965_ _2934_/X _2970_/A2 _2954_/Y _4897_/Q VGND VGND VPWR VPWR _4897_/D sky130_fd_sc_hd__a22o_2
XTAP_TAPCELL_ROW_60_774 VGND VPWR sky130_fd_sc_hd__tapvpwrvgnd_1
XFILLER_30_492 VGND VGND VPWR VPWR sky130_fd_sc_hd__decap_3
X_2896_ _5277_/Q _5242_/Q _5226_/Q _4854_/A VGND VGND VPWR VPWR _2897_/B sky130_fd_sc_hd__a22o_2
X_4635_ _4312_/Y _4516_/X _4633_/X _4634_/X VGND VGND VPWR VPWR _4635_/X sky130_fd_sc_hd__o211a_2
XFILLER_8_70 VGND VGND VPWR VPWR sky130_fd_sc_hd__decap_3
X_4566_ _4312_/Y _4564_/X _4565_/X _4312_/A VGND VGND VPWR VPWR _4567_/C sky130_fd_sc_hd__a22o_2
X_3517_ _4888_/Q _4872_/Q _5096_/Q _5080_/Q _3706_/S0 _3706_/S1 VGND VGND VPWR VPWR
+ _3518_/B sky130_fd_sc_hd__mux4_2
XFILLER_1_308 VGND VGND VPWR VPWR sky130_fd_sc_hd__decap_3
X_4497_ _4466_/Y _4468_/Y _4496_/Y _4522_/A VGND VGND VPWR VPWR _4497_/X sky130_fd_sc_hd__a31o_2
X_3448_ _3447_/A _3447_/B _3458_/A VGND VGND VPWR VPWR _3448_/X sky130_fd_sc_hd__a21o_2
XFILLER_69_150 VGND VGND VPWR VPWR sky130_fd_sc_hd__decap_3
X_3379_ _5156_/Q _5153_/Q VGND VGND VPWR VPWR _3379_/Y sky130_fd_sc_hd__xnor2_2
XFILLER_76_109 VGND VGND VPWR VPWR sky130_fd_sc_hd__decap_3
XFILLER_57_312 VGND VGND VPWR VPWR sky130_fd_sc_hd__decap_3
X_5118_ _5118_/CLK _5118_/D VGND VGND VPWR VPWR _5118_/Q sky130_fd_sc_hd__dfxtp_2
XFILLER_84_120 VGND VGND VPWR VPWR sky130_fd_sc_hd__fill_1
XFILLER_27_24 VGND VGND VPWR VPWR sky130_fd_sc_hd__fill_2
XTAP_TAPCELL_ROW_68_852 VGND VPWR sky130_fd_sc_hd__tapvpwrvgnd_1
XFILLER_27_57 VGND VGND VPWR VPWR sky130_fd_sc_hd__fill_1
X_5049_ _5069_/CLK _5049_/D VGND VGND VPWR VPWR _5049_/Q sky130_fd_sc_hd__dfxtp_2
XFILLER_84_197 VGND VGND VPWR VPWR sky130_fd_sc_hd__decap_3
XFILLER_72_348 VGND VGND VPWR VPWR sky130_fd_sc_hd__decap_3
XFILLER_13_404 VGND VGND VPWR VPWR sky130_fd_sc_hd__decap_3
XFILLER_40_234 VGND VGND VPWR VPWR sky130_fd_sc_hd__fill_1
XTAP_TAPCELL_ROW_23_421 VGND VPWR sky130_fd_sc_hd__tapvpwrvgnd_1
XFILLER_40_256 VGND VGND VPWR VPWR sky130_fd_sc_hd__fill_2
XFILLER_43_78 VGND VGND VPWR VPWR sky130_fd_sc_hd__decap_3
XFILLER_9_419 VGND VGND VPWR VPWR sky130_fd_sc_hd__fill_1
XFILLER_21_470 VGND VGND VPWR VPWR sky130_fd_sc_hd__decap_3
XFILLER_68_42 VGND VGND VPWR VPWR sky130_fd_sc_hd__decap_3
XFILLER_0_363 VGND VGND VPWR VPWR sky130_fd_sc_hd__fill_1
XFILLER_0_385 VGND VGND VPWR VPWR sky130_fd_sc_hd__decap_3
XFILLER_0_396 VGND VGND VPWR VPWR sky130_fd_sc_hd__decap_3
XFILLER_48_378 VGND VGND VPWR VPWR sky130_fd_sc_hd__decap_3
XTAP_TAPCELL_ROW_89_1043 VGND VPWR sky130_fd_sc_hd__tapvpwrvgnd_1
XFILLER_75_164 VGND VGND VPWR VPWR sky130_fd_sc_hd__decap_3
XFILLER_75_186 VGND VGND VPWR VPWR sky130_fd_sc_hd__fill_2
XFILLER_84_74 VGND VGND VPWR VPWR sky130_fd_sc_hd__decap_3
XFILLER_84_63 VGND VGND VPWR VPWR sky130_fd_sc_hd__decap_3
XFILLER_44_551 VGND VGND VPWR VPWR sky130_fd_sc_hd__decap_3
XFILLER_63_359 VGND VGND VPWR VPWR sky130_fd_sc_hd__decap_3
XFILLER_16_253 VGND VGND VPWR VPWR sky130_fd_sc_hd__decap_3
XFILLER_16_297 VGND VGND VPWR VPWR sky130_fd_sc_hd__decap_3
XFILLER_31_223 VGND VGND VPWR VPWR sky130_fd_sc_hd__fill_1
XFILLER_31_234 VGND VGND VPWR VPWR sky130_fd_sc_hd__decap_3
XFILLER_31_245 VGND VGND VPWR VPWR sky130_fd_sc_hd__decap_3
X_2750_ _4891_/Q _4875_/Q _5099_/Q _5083_/Q _2851_/S0 _2854_/S1 VGND VGND VPWR VPWR
+ _2750_/X sky130_fd_sc_hd__mux4_2
XFILLER_83_6 VGND VGND VPWR VPWR sky130_fd_sc_hd__decap_3
XFILLER_12_492 VGND VGND VPWR VPWR sky130_fd_sc_hd__decap_3
X_2681_ _5166_/Q _4397_/D VGND VGND VPWR VPWR _2683_/B sky130_fd_sc_hd__or2_2
X_4420_ _4420_/A _4420_/B VGND VGND VPWR VPWR _4426_/A sky130_fd_sc_hd__or2_2
X_4351_ _4351_/A _4351_/B VGND VGND VPWR VPWR _4353_/B sky130_fd_sc_hd__xnor2_2
X_4282_ _5158_/Q _4732_/A _5156_/Q VGND VGND VPWR VPWR _4301_/B sky130_fd_sc_hd__or3_2
X_3302_ _3300_/Y _3304_/B _3305_/B VGND VGND VPWR VPWR _3302_/Y sky130_fd_sc_hd__o21ai_2
X_3233_ _5283_/Q _3338_/B input9/X VGND VGND VPWR VPWR _3233_/X sky130_fd_sc_hd__and3_2
XFILLER_86_429 VGND VGND VPWR VPWR sky130_fd_sc_hd__fill_1
XFILLER_86_407 VGND VGND VPWR VPWR sky130_fd_sc_hd__decap_3
XFILLER_79_470 VGND VGND VPWR VPWR sky130_fd_sc_hd__fill_2
XFILLER_39_334 VGND VGND VPWR VPWR sky130_fd_sc_hd__fill_2
XFILLER_66_153 VGND VGND VPWR VPWR sky130_fd_sc_hd__fill_1
X_3164_ _2921_/X _3173_/A2 _3157_/Y _5069_/Q VGND VGND VPWR VPWR _5069_/D sky130_fd_sc_hd__a22o_2
XFILLER_27_529 VGND VGND VPWR VPWR sky130_fd_sc_hd__decap_3
XFILLER_39_378 VGND VGND VPWR VPWR sky130_fd_sc_hd__decap_3
XFILLER_54_304 VGND VGND VPWR VPWR sky130_fd_sc_hd__decap_3
X_3095_ _2934_/X _3100_/A2 _3084_/Y _5009_/Q VGND VGND VPWR VPWR _5009_/D sky130_fd_sc_hd__a22o_2
XTAP_TAPCELL_ROW_65_822 VGND VPWR sky130_fd_sc_hd__tapvpwrvgnd_1
XFILLER_54_348 VGND VGND VPWR VPWR sky130_fd_sc_hd__decap_3
XFILLER_66_197 VGND VGND VPWR VPWR sky130_fd_sc_hd__decap_3
XTAP_TAPCELL_ROW_37_557 VGND VPWR sky130_fd_sc_hd__tapvpwrvgnd_1
XFILLER_81_156 VGND VGND VPWR VPWR sky130_fd_sc_hd__decap_3
XFILLER_22_212 VGND VGND VPWR VPWR sky130_fd_sc_hd__decap_3
XFILLER_62_381 VGND VGND VPWR VPWR sky130_fd_sc_hd__decap_3
XFILLER_22_256 VGND VGND VPWR VPWR sky130_fd_sc_hd__decap_3
X_3997_ _3616_/A _3741_/Y _3800_/Y _4021_/B VGND VGND VPWR VPWR _3998_/B sky130_fd_sc_hd__a31o_2
XFILLER_13_26 VGND VGND VPWR VPWR sky130_fd_sc_hd__decap_3
XFILLER_22_289 VGND VGND VPWR VPWR sky130_fd_sc_hd__fill_1
X_2948_ _4885_/Q _2902_/Y _2947_/X _2902_/B VGND VGND VPWR VPWR _4885_/D sky130_fd_sc_hd__a22o_2
X_4618_ _4191_/A _2683_/B _3778_/D _2683_/A _4617_/X VGND VGND VPWR VPWR _4618_/X
+ sky130_fd_sc_hd__o221a_2
X_2879_ _2877_/A _3776_/B _2656_/A VGND VGND VPWR VPWR _2880_/B sky130_fd_sc_hd__a21bo_2
X_4549_ _4437_/X _4545_/X _4546_/X _4547_/X VGND VGND VPWR VPWR _4550_/D sky130_fd_sc_hd__o211a_2
Xmax_cap160 _3589_/Y VGND VGND VPWR VPWR _4684_/B1 sky130_fd_sc_hd__buf_6
Xmax_cap171 _2854_/S0 VGND VGND VPWR VPWR _2851_/S0 sky130_fd_sc_hd__buf_12
Xmax_cap182 _2676_/S0 VGND VGND VPWR VPWR _2672_/S0 sky130_fd_sc_hd__buf_12
XFILLER_89_223 VGND VGND VPWR VPWR sky130_fd_sc_hd__fill_1
XFILLER_89_289 VGND VGND VPWR VPWR sky130_fd_sc_hd__decap_3
XFILLER_77_407 VGND VGND VPWR VPWR sky130_fd_sc_hd__decap_3
XFILLER_72_112 VGND VGND VPWR VPWR sky130_fd_sc_hd__decap_3
XFILLER_45_337 VGND VGND VPWR VPWR sky130_fd_sc_hd__fill_2
XFILLER_57_197 VGND VGND VPWR VPWR sky130_fd_sc_hd__decap_3
XFILLER_26_551 VGND VGND VPWR VPWR sky130_fd_sc_hd__decap_3
XFILLER_54_55 VGND VGND VPWR VPWR sky130_fd_sc_hd__decap_3
XFILLER_54_66 VGND VGND VPWR VPWR sky130_fd_sc_hd__decap_3
XFILLER_41_521 VGND VGND VPWR VPWR sky130_fd_sc_hd__fill_2
XFILLER_41_532 VGND VGND VPWR VPWR sky130_fd_sc_hd__decap_3
XFILLER_53_381 VGND VGND VPWR VPWR sky130_fd_sc_hd__decap_3
XTAP_TAPCELL_ROW_0_193 VGND VPWR sky130_fd_sc_hd__tapvpwrvgnd_1
XFILLER_13_278 VGND VGND VPWR VPWR sky130_fd_sc_hd__fill_2
XFILLER_5_411 VGND VGND VPWR VPWR sky130_fd_sc_hd__decap_3
Xclkload19 _5110_/CLK VGND VGND VPWR VPWR clkload19/Y sky130_fd_sc_hd__clkinv_2
XFILLER_5_444 VGND VGND VPWR VPWR sky130_fd_sc_hd__decap_3
XFILLER_5_455 VGND VGND VPWR VPWR sky130_fd_sc_hd__decap_3
XFILLER_5_477 VGND VGND VPWR VPWR sky130_fd_sc_hd__decap_3
XFILLER_68_407 VGND VGND VPWR VPWR sky130_fd_sc_hd__decap_3
XTAP_TAPCELL_ROW_8_282 VGND VPWR sky130_fd_sc_hd__tapvpwrvgnd_1
XFILLER_76_462 VGND VGND VPWR VPWR sky130_fd_sc_hd__decap_3
XFILLER_76_495 VGND VGND VPWR VPWR sky130_fd_sc_hd__decap_3
XFILLER_48_197 VGND VGND VPWR VPWR sky130_fd_sc_hd__fill_1
X_3920_ _3920_/A VGND VGND VPWR VPWR _3920_/Y sky130_fd_sc_hd__inv_2
XFILLER_32_510 VGND VGND VPWR VPWR sky130_fd_sc_hd__decap_3
XTAP_TAPCELL_ROW_34_527 VGND VPWR sky130_fd_sc_hd__tapvpwrvgnd_1
XFILLER_91_498 VGND VGND VPWR VPWR sky130_fd_sc_hd__decap_3
X_3851_ _3851_/A VGND VGND VPWR VPWR _3851_/Y sky130_fd_sc_hd__inv_2
X_3782_ _3782_/A _3782_/B _3782_/C VGND VGND VPWR VPWR _3782_/Y sky130_fd_sc_hd__nand3_2
X_2802_ _2797_/X _2798_/X _2801_/X _2435_/Y VGND VGND VPWR VPWR _4792_/B sky130_fd_sc_hd__a22o_2
XFILLER_81_3 VGND VGND VPWR VPWR sky130_fd_sc_hd__decap_3
X_2733_ _5065_/Q _5049_/Q _5033_/Q _5017_/Q _2851_/S0 _2854_/S1 VGND VGND VPWR VPWR
+ _2733_/X sky130_fd_sc_hd__mux4_2
XFILLER_8_282 VGND VGND VPWR VPWR sky130_fd_sc_hd__fill_1
X_2664_ _2662_/X _2663_/X _5129_/Q VGND VGND VPWR VPWR _2664_/X sky130_fd_sc_hd__mux2_1
X_4403_ _4404_/A _4404_/B VGND VGND VPWR VPWR _4462_/B sky130_fd_sc_hd__and2b_2
X_2595_ _4952_/Q _4936_/Q _4920_/Q _4904_/Q _5127_/Q _5128_/Q VGND VGND VPWR VPWR
+ _2595_/X sky130_fd_sc_hd__mux4_2
X_4334_ _4397_/B _4334_/B _4334_/C VGND VGND VPWR VPWR _4334_/X sky130_fd_sc_hd__or3_2
XFILLER_59_429 VGND VGND VPWR VPWR sky130_fd_sc_hd__decap_3
X_4265_ _4515_/A _4265_/B VGND VGND VPWR VPWR _4265_/Y sky130_fd_sc_hd__nand2_2
X_4196_ _4225_/A _4196_/B VGND VGND VPWR VPWR _4647_/A sky130_fd_sc_hd__or2_2
X_3216_ _2914_/X _3227_/A2 _3211_/Y _5115_/Q VGND VGND VPWR VPWR _5115_/D sky130_fd_sc_hd__a22o_2
X_3147_ _2924_/X _3155_/A2 _3139_/Y _5054_/Q VGND VGND VPWR VPWR _5054_/D sky130_fd_sc_hd__a22o_2
XFILLER_82_410 VGND VGND VPWR VPWR sky130_fd_sc_hd__fill_1
XFILLER_27_337 VGND VGND VPWR VPWR sky130_fd_sc_hd__fill_2
XFILLER_54_112 VGND VGND VPWR VPWR sky130_fd_sc_hd__decap_3
XFILLER_82_421 VGND VGND VPWR VPWR sky130_fd_sc_hd__decap_3
X_3078_ _2937_/X _3065_/Y _3066_/Y _4994_/Q VGND VGND VPWR VPWR _4994_/D sky130_fd_sc_hd__a22o_2
XFILLER_23_532 VGND VGND VPWR VPWR sky130_fd_sc_hd__decap_3
XFILLER_54_189 VGND VGND VPWR VPWR sky130_fd_sc_hd__decap_3
XPHY_EDGE_ROW_59_Left_153 VGND VGND VPWR VPWR sky130_fd_sc_hd__decap_3
XFILLER_82_498 VGND VGND VPWR VPWR sky130_fd_sc_hd__fill_2
XFILLER_23_554 VGND VGND VPWR VPWR sky130_fd_sc_hd__decap_3
XFILLER_50_351 VGND VGND VPWR VPWR sky130_fd_sc_hd__decap_3
XFILLER_10_204 VGND VGND VPWR VPWR sky130_fd_sc_hd__decap_3
XFILLER_10_259 VGND VGND VPWR VPWR sky130_fd_sc_hd__fill_1
XFILLER_40_24 VGND VGND VPWR VPWR sky130_fd_sc_hd__decap_3
XFILLER_6_219 VGND VGND VPWR VPWR sky130_fd_sc_hd__decap_3
XPHY_EDGE_ROW_68_Left_162 VGND VGND VPWR VPWR sky130_fd_sc_hd__decap_3
XFILLER_77_237 VGND VGND VPWR VPWR sky130_fd_sc_hd__decap_3
XFILLER_58_451 VGND VGND VPWR VPWR sky130_fd_sc_hd__fill_1
XTAP_TAPCELL_ROW_5_252 VGND VPWR sky130_fd_sc_hd__tapvpwrvgnd_1
XFILLER_77_248 VGND VGND VPWR VPWR sky130_fd_sc_hd__decap_3
XFILLER_58_473 VGND VGND VPWR VPWR sky130_fd_sc_hd__decap_3
XTAP_TAPCELL_ROW_76_928 VGND VPWR sky130_fd_sc_hd__tapvpwrvgnd_1
XFILLER_58_495 VGND VGND VPWR VPWR sky130_fd_sc_hd__decap_3
XFILLER_73_443 VGND VGND VPWR VPWR sky130_fd_sc_hd__decap_3
XFILLER_85_281 VGND VGND VPWR VPWR sky130_fd_sc_hd__fill_1
XPHY_EDGE_ROW_77_Left_171 VGND VGND VPWR VPWR sky130_fd_sc_hd__decap_3
XFILLER_26_381 VGND VGND VPWR VPWR sky130_fd_sc_hd__decap_3
XFILLER_60_115 VGND VGND VPWR VPWR sky130_fd_sc_hd__fill_2
XFILLER_60_137 VGND VGND VPWR VPWR sky130_fd_sc_hd__decap_3
XFILLER_60_148 VGND VGND VPWR VPWR sky130_fd_sc_hd__decap_3
XFILLER_14_80 VGND VGND VPWR VPWR sky130_fd_sc_hd__decap_3
XFILLER_81_97 VGND VGND VPWR VPWR sky130_fd_sc_hd__decap_3
XFILLER_14_91 VGND VGND VPWR VPWR sky130_fd_sc_hd__decap_3
XPHY_EDGE_ROW_86_Left_180 VGND VGND VPWR VPWR sky130_fd_sc_hd__decap_3
XFILLER_5_252 VGND VGND VPWR VPWR sky130_fd_sc_hd__decap_3
XFILLER_1_491 VGND VGND VPWR VPWR sky130_fd_sc_hd__decap_3
XFILLER_68_259 VGND VGND VPWR VPWR sky130_fd_sc_hd__decap_3
X_4050_ _4267_/S _3941_/C _4049_/Y VGND VGND VPWR VPWR _4051_/B sky130_fd_sc_hd__a21o_2
Xinput6 INSTR_STREAM[14] VGND VGND VPWR VPWR input6/X sky130_fd_sc_hd__clkdlybuf4s25_1
X_3001_ _2924_/X _2993_/B _2993_/Y _4926_/Q VGND VGND VPWR VPWR _4926_/D sky130_fd_sc_hd__a22o_2
XFILLER_64_421 VGND VGND VPWR VPWR sky130_fd_sc_hd__decap_3
XFILLER_64_432 VGND VGND VPWR VPWR sky130_fd_sc_hd__decap_3
XFILLER_76_292 VGND VGND VPWR VPWR sky130_fd_sc_hd__decap_3
XTAP_TAPCELL_ROW_47_652 VGND VPWR sky130_fd_sc_hd__tapvpwrvgnd_1
XFILLER_91_262 VGND VGND VPWR VPWR sky130_fd_sc_hd__fill_1
XFILLER_51_137 VGND VGND VPWR VPWR sky130_fd_sc_hd__decap_3
X_4952_ _5010_/CLK _4952_/D VGND VGND VPWR VPWR _4952_/Q sky130_fd_sc_hd__dfxtp_2
XFILLER_32_351 VGND VGND VPWR VPWR sky130_fd_sc_hd__fill_2
X_4883_ _5069_/CLK _4883_/D VGND VGND VPWR VPWR _4883_/Q sky130_fd_sc_hd__dfxtp_2
X_3903_ _4397_/B _3905_/B VGND VGND VPWR VPWR _3903_/Y sky130_fd_sc_hd__nand2b_2
XFILLER_20_524 VGND VGND VPWR VPWR sky130_fd_sc_hd__fill_1
XFILLER_32_362 VGND VGND VPWR VPWR sky130_fd_sc_hd__fill_2
X_3834_ _5166_/Q _3834_/B VGND VGND VPWR VPWR _3834_/Y sky130_fd_sc_hd__nor2_2
XFILLER_32_395 VGND VGND VPWR VPWR sky130_fd_sc_hd__decap_3
X_3765_ _3884_/D _3770_/B _5182_/Q VGND VGND VPWR VPWR _4522_/A sky130_fd_sc_hd__or3b_2
X_3696_ _4960_/Q _4944_/Q _4928_/Q _4912_/Q _3732_/S0 _3732_/S1 VGND VGND VPWR VPWR
+ _3696_/X sky130_fd_sc_hd__mux4_2
X_2716_ _2714_/X _2715_/X _2855_/S VGND VGND VPWR VPWR _2716_/X sky130_fd_sc_hd__mux2_1
X_2647_ _2660_/A _2647_/B VGND VGND VPWR VPWR _2647_/X sky130_fd_sc_hd__or2_2
X_2578_ _4889_/Q _4873_/Q _5097_/Q _5081_/Q _2672_/S0 _2672_/S1 VGND VGND VPWR VPWR
+ _2579_/B sky130_fd_sc_hd__mux4_2
X_4317_ _4487_/A _4308_/X _4312_/Y _4316_/Y VGND VGND VPWR VPWR _4317_/X sky130_fd_sc_hd__a211o_2
XFILLER_59_259 VGND VGND VPWR VPWR sky130_fd_sc_hd__decap_3
X_4248_ _3884_/D _4669_/S _3665_/B _3886_/B VGND VGND VPWR VPWR _4250_/B sky130_fd_sc_hd__a211o_2
XFILLER_55_410 VGND VGND VPWR VPWR sky130_fd_sc_hd__decap_3
XFILLER_74_218 VGND VGND VPWR VPWR sky130_fd_sc_hd__decap_3
XTAP_TAPCELL_ROW_2_222 VGND VPWR sky130_fd_sc_hd__tapvpwrvgnd_1
XFILLER_67_281 VGND VGND VPWR VPWR sky130_fd_sc_hd__decap_3
X_4179_ _4397_/C _4397_/D _4449_/S VGND VGND VPWR VPWR _4179_/X sky130_fd_sc_hd__mux2_1
XFILLER_27_167 VGND VGND VPWR VPWR sky130_fd_sc_hd__fill_1
XFILLER_70_402 VGND VGND VPWR VPWR sky130_fd_sc_hd__decap_3
XFILLER_15_318 VGND VGND VPWR VPWR sky130_fd_sc_hd__fill_1
XFILLER_35_57 VGND VGND VPWR VPWR sky130_fd_sc_hd__decap_3
XFILLER_42_115 VGND VGND VPWR VPWR sky130_fd_sc_hd__decap_3
XFILLER_70_424 VGND VGND VPWR VPWR sky130_fd_sc_hd__decap_3
XFILLER_42_137 VGND VGND VPWR VPWR sky130_fd_sc_hd__decap_3
XFILLER_42_159 VGND VGND VPWR VPWR sky130_fd_sc_hd__decap_3
XTAP_TAPCELL_ROW_81_975 VGND VPWR sky130_fd_sc_hd__tapvpwrvgnd_1
XFILLER_11_502 VGND VGND VPWR VPWR sky130_fd_sc_hd__fill_2
XFILLER_11_513 VGND VGND VPWR VPWR sky130_fd_sc_hd__decap_3
XFILLER_50_181 VGND VGND VPWR VPWR sky130_fd_sc_hd__decap_3
XFILLER_51_34 VGND VGND VPWR VPWR sky130_fd_sc_hd__decap_3
XPHY_EDGE_ROW_14_Right_14 VGND VGND VPWR VPWR sky130_fd_sc_hd__decap_3
XFILLER_2_200 VGND VGND VPWR VPWR sky130_fd_sc_hd__decap_3
XTAP_TAPCELL_ROW_92_1072 VGND VPWR sky130_fd_sc_hd__tapvpwrvgnd_1
XPHY_EDGE_ROW_23_Right_23 VGND VGND VPWR VPWR sky130_fd_sc_hd__decap_3
XFILLER_78_513 VGND VGND VPWR VPWR sky130_fd_sc_hd__decap_3
XFILLER_93_505 VGND VGND VPWR VPWR sky130_fd_sc_hd__decap_3
XFILLER_78_557 VGND VGND VPWR VPWR sky130_fd_sc_hd__fill_1
XFILLER_46_421 VGND VGND VPWR VPWR sky130_fd_sc_hd__decap_3
XFILLER_76_97 VGND VGND VPWR VPWR sky130_fd_sc_hd__decap_3
XFILLER_18_156 VGND VGND VPWR VPWR sky130_fd_sc_hd__decap_3
XFILLER_61_402 VGND VGND VPWR VPWR sky130_fd_sc_hd__decap_3
XTAP_TAPCELL_ROW_44_622 VGND VPWR sky130_fd_sc_hd__tapvpwrvgnd_1
XFILLER_92_63 VGND VGND VPWR VPWR sky130_fd_sc_hd__decap_3
XFILLER_61_479 VGND VGND VPWR VPWR sky130_fd_sc_hd__decap_3
XTAP_TAPCELL_ROW_16_357 VGND VPWR sky130_fd_sc_hd__tapvpwrvgnd_1
XPHY_EDGE_ROW_32_Right_32 VGND VGND VPWR VPWR sky130_fd_sc_hd__decap_3
XFILLER_92_85 VGND VGND VPWR VPWR sky130_fd_sc_hd__decap_3
XFILLER_25_90 VGND VGND VPWR VPWR sky130_fd_sc_hd__decap_3
XFILLER_14_384 VGND VGND VPWR VPWR sky130_fd_sc_hd__decap_3
X_3550_ _4393_/D _3866_/B _3549_/Y VGND VGND VPWR VPWR _3550_/X sky130_fd_sc_hd__o21a_2
X_2501_ _4964_/Q _4948_/Q _4932_/Q _4916_/Q _2676_/S0 _2676_/S1 VGND VGND VPWR VPWR
+ _2501_/X sky130_fd_sc_hd__mux4_2
X_5220_ _5254_/CLK _5220_/D VGND VGND VPWR VPWR _5220_/Q sky130_fd_sc_hd__dfxtp_2
X_3481_ _5207_/Q _4854_/B _3479_/Y _3480_/X VGND VGND VPWR VPWR _3482_/B sky130_fd_sc_hd__o2bb2a_2
XFILLER_44_3 VGND VGND VPWR VPWR sky130_fd_sc_hd__decap_3
XFILLER_69_502 VGND VGND VPWR VPWR sky130_fd_sc_hd__fill_2
X_2432_ _2660_/A VGND VGND VPWR VPWR _2677_/S sky130_fd_sc_hd__inv_2
XPHY_EDGE_ROW_41_Right_41 VGND VGND VPWR VPWR sky130_fd_sc_hd__decap_3
X_5151_ _5208_/CLK _5151_/D VGND VGND VPWR VPWR _5151_/Q sky130_fd_sc_hd__dfxtp_2
X_4102_ _4267_/S _3993_/X _4101_/Y _4051_/A VGND VGND VPWR VPWR _4102_/X sky130_fd_sc_hd__a211o_2
X_5082_ _5099_/CLK _5082_/D VGND VGND VPWR VPWR _5082_/Q sky130_fd_sc_hd__dfxtp_2
X_4033_ _3615_/B _4009_/X _4022_/A VGND VGND VPWR VPWR _4033_/Y sky130_fd_sc_hd__o21ai_2
XFILLER_49_281 VGND VGND VPWR VPWR sky130_fd_sc_hd__decap_3
XFILLER_52_413 VGND VGND VPWR VPWR sky130_fd_sc_hd__decap_3
XFILLER_52_424 VGND VGND VPWR VPWR sky130_fd_sc_hd__decap_3
XFILLER_52_435 VGND VGND VPWR VPWR sky130_fd_sc_hd__decap_3
XFILLER_64_295 VGND VGND VPWR VPWR sky130_fd_sc_hd__decap_3
XPHY_EDGE_ROW_50_Right_50 VGND VGND VPWR VPWR sky130_fd_sc_hd__decap_3
X_4935_ clkload8/A _4935_/D VGND VGND VPWR VPWR _4935_/Q sky130_fd_sc_hd__dfxtp_2
XFILLER_20_332 VGND VGND VPWR VPWR sky130_fd_sc_hd__decap_3
X_4866_ _5175_/Q _4868_/A2 _4870_/B1 _3237_/X VGND VGND VPWR VPWR _5175_/D sky130_fd_sc_hd__o22a_2
XFILLER_20_365 VGND VGND VPWR VPWR sky130_fd_sc_hd__fill_1
X_4797_ _5267_/Q _4847_/B _4795_/Y _4796_/X _3338_/B VGND VGND VPWR VPWR _5267_/D
+ sky130_fd_sc_hd__o221a_2
X_3817_ _5156_/Q _3817_/B VGND VGND VPWR VPWR _3817_/Y sky130_fd_sc_hd__nand2_2
XFILLER_20_387 VGND VGND VPWR VPWR sky130_fd_sc_hd__decap_3
X_3748_ _3889_/B _3748_/B _3977_/A VGND VGND VPWR VPWR _3749_/D sky130_fd_sc_hd__or3_2
XFILLER_4_509 VGND VGND VPWR VPWR sky130_fd_sc_hd__decap_3
X_3679_ _4897_/Q _4881_/Q _5105_/Q _5089_/Q _3706_/S0 _3706_/S1 VGND VGND VPWR VPWR
+ _3680_/B sky130_fd_sc_hd__mux4_2
XFILLER_87_310 VGND VGND VPWR VPWR sky130_fd_sc_hd__decap_3
XFILLER_87_354 VGND VGND VPWR VPWR sky130_fd_sc_hd__decap_3
XFILLER_75_505 VGND VGND VPWR VPWR sky130_fd_sc_hd__decap_3
XFILLER_28_421 VGND VGND VPWR VPWR sky130_fd_sc_hd__decap_3
XFILLER_55_273 VGND VGND VPWR VPWR sky130_fd_sc_hd__decap_3
XFILLER_55_295 VGND VGND VPWR VPWR sky130_fd_sc_hd__decap_3
XFILLER_70_210 VGND VGND VPWR VPWR sky130_fd_sc_hd__decap_3
XFILLER_15_137 VGND VGND VPWR VPWR sky130_fd_sc_hd__decap_3
XFILLER_43_446 VGND VGND VPWR VPWR sky130_fd_sc_hd__fill_2
XFILLER_43_479 VGND VGND VPWR VPWR sky130_fd_sc_hd__decap_3
XFILLER_70_287 VGND VGND VPWR VPWR sky130_fd_sc_hd__decap_3
XFILLER_11_332 VGND VGND VPWR VPWR sky130_fd_sc_hd__decap_3
XTAP_TAPCELL_ROW_13_327 VGND VPWR sky130_fd_sc_hd__tapvpwrvgnd_1
XFILLER_11_354 VGND VGND VPWR VPWR sky130_fd_sc_hd__decap_3
XFILLER_62_99 VGND VGND VPWR VPWR sky130_fd_sc_hd__decap_3
XFILLER_7_28 VGND VGND VPWR VPWR sky130_fd_sc_hd__decap_3
XFILLER_7_347 VGND VGND VPWR VPWR sky130_fd_sc_hd__decap_3
XFILLER_3_520 VGND VGND VPWR VPWR sky130_fd_sc_hd__decap_3
XFILLER_3_553 VGND VGND VPWR VPWR sky130_fd_sc_hd__decap_3
XFILLER_30_9 VGND VGND VPWR VPWR sky130_fd_sc_hd__decap_3
XFILLER_87_74 VGND VGND VPWR VPWR sky130_fd_sc_hd__decap_3
XFILLER_87_63 VGND VGND VPWR VPWR sky130_fd_sc_hd__decap_3
XFILLER_78_354 VGND VGND VPWR VPWR sky130_fd_sc_hd__decap_3
XFILLER_78_321 VGND VGND VPWR VPWR sky130_fd_sc_hd__decap_3
XFILLER_93_302 VGND VGND VPWR VPWR sky130_fd_sc_hd__decap_3
XFILLER_81_508 VGND VGND VPWR VPWR sky130_fd_sc_hd__fill_1
XFILLER_19_498 VGND VGND VPWR VPWR sky130_fd_sc_hd__fill_1
XFILLER_34_424 VGND VGND VPWR VPWR sky130_fd_sc_hd__decap_3
XFILLER_46_284 VGND VGND VPWR VPWR sky130_fd_sc_hd__decap_3
XFILLER_61_210 VGND VGND VPWR VPWR sky130_fd_sc_hd__decap_3
XFILLER_34_457 VGND VGND VPWR VPWR sky130_fd_sc_hd__decap_3
XFILLER_61_265 VGND VGND VPWR VPWR sky130_fd_sc_hd__decap_3
X_2981_ _2921_/X _2974_/B _2974_/Y _4909_/Q VGND VGND VPWR VPWR _4909_/D sky130_fd_sc_hd__a22o_2
X_4720_ input36/X _4694_/Y _4719_/X _3366_/A VGND VGND VPWR VPWR _5254_/D sky130_fd_sc_hd__o211a_2
X_4651_ _4692_/A _4651_/B VGND VGND VPWR VPWR _5238_/D sky130_fd_sc_hd__nor2_2
Xinput31 INSTR_STREAM[8] VGND VGND VPWR VPWR _3332_/C sky130_fd_sc_hd__clkdlybuf4s25_1
Xinput20 INSTR_STREAM[27] VGND VGND VPWR VPWR _3346_/C sky130_fd_sc_hd__clkdlybuf4s25_1
X_3602_ _4357_/A _4281_/A VGND VGND VPWR VPWR _4474_/S sky130_fd_sc_hd__nor2_2
X_4582_ _4090_/A _4261_/C _4686_/B1 _4086_/A _4580_/X VGND VGND VPWR VPWR _4582_/X
+ sky130_fd_sc_hd__o221a_2
Xinput42 MEM_LD_DATA[3] VGND VGND VPWR VPWR input42/X sky130_fd_sc_hd__clkdlybuf4s25_1
X_3533_ _4286_/B _5156_/Q _4422_/S VGND VGND VPWR VPWR _4638_/S sky130_fd_sc_hd__mux2_4
X_3464_ _3454_/A _3457_/X _3462_/Y _3458_/A VGND VGND VPWR VPWR _3464_/Y sky130_fd_sc_hd__a31oi_2
XFILLER_69_310 VGND VGND VPWR VPWR sky130_fd_sc_hd__decap_3
X_5203_ _5251_/CLK _5203_/D VGND VGND VPWR VPWR _5203_/Q sky130_fd_sc_hd__dfxtp_2
XFILLER_88_129 VGND VGND VPWR VPWR sky130_fd_sc_hd__fill_1
X_5134_ _5216_/CLK _5134_/D VGND VGND VPWR VPWR _5134_/Q sky130_fd_sc_hd__dfxtp_2
X_3395_ _3388_/Y _3394_/X _3494_/A VGND VGND VPWR VPWR _5196_/D sky130_fd_sc_hd__a21oi_2
XFILLER_57_505 VGND VGND VPWR VPWR sky130_fd_sc_hd__fill_2
X_5065_ _5105_/CLK _5065_/D VGND VGND VPWR VPWR _5065_/Q sky130_fd_sc_hd__dfxtp_2
XFILLER_84_324 VGND VGND VPWR VPWR sky130_fd_sc_hd__decap_3
XFILLER_72_519 VGND VGND VPWR VPWR sky130_fd_sc_hd__decap_3
X_4016_ _4016_/A _4016_/B VGND VGND VPWR VPWR _4016_/Y sky130_fd_sc_hd__nand2_2
XFILLER_84_357 VGND VGND VPWR VPWR sky130_fd_sc_hd__fill_2
XFILLER_25_402 VGND VGND VPWR VPWR sky130_fd_sc_hd__decap_3
XFILLER_37_284 VGND VGND VPWR VPWR sky130_fd_sc_hd__decap_3
XTAP_TAPCELL_ROW_55_728 VGND VPWR sky130_fd_sc_hd__tapvpwrvgnd_1
XFILLER_40_438 VGND VGND VPWR VPWR sky130_fd_sc_hd__decap_3
X_4918_ clkload7/A _4918_/D VGND VGND VPWR VPWR _4918_/Q sky130_fd_sc_hd__dfxtp_2
X_4849_ _5184_/Q _3357_/B _4854_/B VGND VGND VPWR VPWR _4849_/X sky130_fd_sc_hd__a21o_2
XFILLER_4_306 VGND VGND VPWR VPWR sky130_fd_sc_hd__fill_2
XFILLER_0_523 VGND VGND VPWR VPWR sky130_fd_sc_hd__decap_3
XFILLER_0_545 VGND VGND VPWR VPWR sky130_fd_sc_hd__decap_3
XFILLER_48_516 VGND VGND VPWR VPWR sky130_fd_sc_hd__decap_3
XFILLER_48_527 VGND VGND VPWR VPWR sky130_fd_sc_hd__decap_3
XFILLER_57_44 VGND VGND VPWR VPWR sky130_fd_sc_hd__decap_3
XFILLER_57_66 VGND VGND VPWR VPWR sky130_fd_sc_hd__fill_1
XFILLER_57_77 VGND VGND VPWR VPWR sky130_fd_sc_hd__decap_3
XFILLER_75_346 VGND VGND VPWR VPWR sky130_fd_sc_hd__decap_3
XFILLER_63_508 VGND VGND VPWR VPWR sky130_fd_sc_hd__decap_3
XFILLER_28_262 VGND VGND VPWR VPWR sky130_fd_sc_hd__decap_3
XFILLER_43_221 VGND VGND VPWR VPWR sky130_fd_sc_hd__decap_3
XFILLER_73_32 VGND VGND VPWR VPWR sky130_fd_sc_hd__decap_3
XFILLER_73_54 VGND VGND VPWR VPWR sky130_fd_sc_hd__fill_2
XFILLER_73_65 VGND VGND VPWR VPWR sky130_fd_sc_hd__decap_3
XTAP_TAPCELL_ROW_26_452 VGND VPWR sky130_fd_sc_hd__tapvpwrvgnd_1
XFILLER_7_122 VGND VGND VPWR VPWR sky130_fd_sc_hd__decap_3
XFILLER_78_9 VGND VGND VPWR VPWR sky130_fd_sc_hd__decap_3
XFILLER_7_199 VGND VGND VPWR VPWR sky130_fd_sc_hd__decap_3
XPHY_EDGE_ROW_13_Left_107 VGND VGND VPWR VPWR sky130_fd_sc_hd__decap_3
XFILLER_39_505 VGND VGND VPWR VPWR sky130_fd_sc_hd__fill_1
X_3180_ _2914_/X _3191_/A2 _3191_/B1 _5083_/Q VGND VGND VPWR VPWR _5083_/D sky130_fd_sc_hd__a22o_2
XFILLER_66_379 VGND VGND VPWR VPWR sky130_fd_sc_hd__decap_3
XFILLER_81_316 VGND VGND VPWR VPWR sky130_fd_sc_hd__decap_3
XFILLER_62_530 VGND VGND VPWR VPWR sky130_fd_sc_hd__fill_2
XFILLER_62_541 VGND VGND VPWR VPWR sky130_fd_sc_hd__decap_3
XFILLER_81_349 VGND VGND VPWR VPWR sky130_fd_sc_hd__decap_3
XFILLER_34_276 VGND VGND VPWR VPWR sky130_fd_sc_hd__decap_3
XPHY_EDGE_ROW_22_Left_116 VGND VGND VPWR VPWR sky130_fd_sc_hd__decap_3
XFILLER_22_427 VGND VGND VPWR VPWR sky130_fd_sc_hd__decap_3
X_2964_ _2931_/X _2970_/A2 _2954_/Y _4896_/Q VGND VGND VPWR VPWR _4896_/D sky130_fd_sc_hd__a22o_2
X_4703_ _5246_/Q _4725_/B VGND VGND VPWR VPWR _4703_/X sky130_fd_sc_hd__or2_2
XTAP_TAPCELL_ROW_60_775 VGND VPWR sky130_fd_sc_hd__tapvpwrvgnd_1
XFILLER_30_460 VGND VGND VPWR VPWR sky130_fd_sc_hd__fill_2
X_2895_ _5276_/Q _5210_/Q _5194_/Q _5275_/Q VGND VGND VPWR VPWR _2897_/A sky130_fd_sc_hd__a22o_2
X_4634_ _4166_/A _4261_/C _4686_/B1 _4173_/A _4632_/X VGND VGND VPWR VPWR _4634_/X
+ sky130_fd_sc_hd__o221a_2
XFILLER_8_82 VGND VGND VPWR VPWR sky130_fd_sc_hd__fill_2
X_4565_ _4485_/X _4482_/X _4572_/S VGND VGND VPWR VPWR _4565_/X sky130_fd_sc_hd__mux2_1
X_3516_ _5064_/Q _5048_/Q _5032_/Q _5016_/Q _3706_/S0 _3706_/S1 VGND VGND VPWR VPWR
+ _3516_/X sky130_fd_sc_hd__mux4_2
X_4496_ _4522_/B _4522_/C VGND VGND VPWR VPWR _4496_/Y sky130_fd_sc_hd__xnor2_2
XPHY_EDGE_ROW_4_Right_4 VGND VGND VPWR VPWR sky130_fd_sc_hd__decap_3
XPHY_EDGE_ROW_31_Left_125 VGND VGND VPWR VPWR sky130_fd_sc_hd__decap_3
XFILLER_89_416 VGND VGND VPWR VPWR sky130_fd_sc_hd__fill_2
X_3447_ _3447_/A _3447_/B VGND VGND VPWR VPWR _3447_/Y sky130_fd_sc_hd__nor2_2
XFILLER_89_449 VGND VGND VPWR VPWR sky130_fd_sc_hd__decap_3
XFILLER_69_162 VGND VGND VPWR VPWR sky130_fd_sc_hd__fill_1
X_3378_ _4854_/B _3378_/B VGND VGND VPWR VPWR _3458_/A sky130_fd_sc_hd__or2_2
XFILLER_57_324 VGND VGND VPWR VPWR sky130_fd_sc_hd__decap_3
X_5117_ _5117_/CLK _5117_/D VGND VGND VPWR VPWR _5117_/Q sky130_fd_sc_hd__dfxtp_2
XFILLER_57_346 VGND VGND VPWR VPWR sky130_fd_sc_hd__decap_3
X_5048_ _5069_/CLK _5048_/D VGND VGND VPWR VPWR _5048_/Q sky130_fd_sc_hd__dfxtp_2
XFILLER_27_47 VGND VGND VPWR VPWR sky130_fd_sc_hd__decap_3
XFILLER_72_316 VGND VGND VPWR VPWR sky130_fd_sc_hd__decap_3
XPHY_EDGE_ROW_40_Left_134 VGND VGND VPWR VPWR sky130_fd_sc_hd__decap_3
XFILLER_13_416 VGND VGND VPWR VPWR sky130_fd_sc_hd__decap_3
XFILLER_80_360 VGND VGND VPWR VPWR sky130_fd_sc_hd__decap_3
XFILLER_13_449 VGND VGND VPWR VPWR sky130_fd_sc_hd__decap_3
XFILLER_25_287 VGND VGND VPWR VPWR sky130_fd_sc_hd__decap_3
XTAP_TAPCELL_ROW_23_422 VGND VPWR sky130_fd_sc_hd__tapvpwrvgnd_1
XFILLER_21_482 VGND VGND VPWR VPWR sky130_fd_sc_hd__decap_3
XFILLER_4_169 VGND VGND VPWR VPWR sky130_fd_sc_hd__fill_1
XFILLER_4_29 VGND VGND VPWR VPWR sky130_fd_sc_hd__decap_3
XFILLER_48_302 VGND VGND VPWR VPWR sky130_fd_sc_hd__decap_3
XFILLER_68_65 VGND VGND VPWR VPWR sky130_fd_sc_hd__decap_3
XFILLER_48_324 VGND VGND VPWR VPWR sky130_fd_sc_hd__decap_3
XFILLER_88_482 VGND VGND VPWR VPWR sky130_fd_sc_hd__decap_3
XFILLER_48_346 VGND VGND VPWR VPWR sky130_fd_sc_hd__fill_1
XFILLER_48_368 VGND VGND VPWR VPWR sky130_fd_sc_hd__decap_3
XTAP_TAPCELL_ROW_89_1044 VGND VPWR sky130_fd_sc_hd__tapvpwrvgnd_1
XFILLER_36_519 VGND VGND VPWR VPWR sky130_fd_sc_hd__decap_3
XFILLER_63_316 VGND VGND VPWR VPWR sky130_fd_sc_hd__decap_3
XFILLER_84_42 VGND VGND VPWR VPWR sky130_fd_sc_hd__decap_3
XFILLER_16_221 VGND VGND VPWR VPWR sky130_fd_sc_hd__decap_3
XFILLER_16_265 VGND VGND VPWR VPWR sky130_fd_sc_hd__decap_3
XFILLER_31_202 VGND VGND VPWR VPWR sky130_fd_sc_hd__decap_3
XFILLER_71_382 VGND VGND VPWR VPWR sky130_fd_sc_hd__decap_3
XFILLER_71_393 VGND VGND VPWR VPWR sky130_fd_sc_hd__decap_3
X_2680_ _5166_/Q _4397_/D VGND VGND VPWR VPWR _2683_/A sky130_fd_sc_hd__nand2_2
XFILLER_76_6 VGND VGND VPWR VPWR sky130_fd_sc_hd__decap_3
X_4350_ _4397_/A _4350_/B VGND VGND VPWR VPWR _4351_/B sky130_fd_sc_hd__xnor2_2
X_3301_ _5150_/Q _3301_/B VGND VGND VPWR VPWR _3304_/B sky130_fd_sc_hd__and2_2
X_4281_ _4281_/A _4287_/A VGND VGND VPWR VPWR _4281_/Y sky130_fd_sc_hd__xnor2_2
X_3232_ _5172_/Q _4868_/A2 _4870_/B1 _3231_/X VGND VGND VPWR VPWR _5127_/D sky130_fd_sc_hd__o22a_2
XFILLER_86_419 VGND VGND VPWR VPWR sky130_fd_sc_hd__fill_1
XFILLER_39_313 VGND VGND VPWR VPWR sky130_fd_sc_hd__decap_3
X_3163_ _2918_/X _3173_/A2 _3157_/Y _5068_/Q VGND VGND VPWR VPWR _5068_/D sky130_fd_sc_hd__a22o_2
XFILLER_27_508 VGND VGND VPWR VPWR sky130_fd_sc_hd__decap_3
XFILLER_39_346 VGND VGND VPWR VPWR sky130_fd_sc_hd__decap_3
XFILLER_66_121 VGND VGND VPWR VPWR sky130_fd_sc_hd__fill_1
XFILLER_66_165 VGND VGND VPWR VPWR sky130_fd_sc_hd__decap_3
X_3094_ _2931_/X _3100_/A2 _3084_/Y _5008_/Q VGND VGND VPWR VPWR _5008_/D sky130_fd_sc_hd__a22o_2
XTAP_TAPCELL_ROW_65_823 VGND VPWR sky130_fd_sc_hd__tapvpwrvgnd_1
XFILLER_81_124 VGND VGND VPWR VPWR sky130_fd_sc_hd__decap_3
XFILLER_22_224 VGND VGND VPWR VPWR sky130_fd_sc_hd__decap_3
XFILLER_50_533 VGND VGND VPWR VPWR sky130_fd_sc_hd__decap_3
XFILLER_62_393 VGND VGND VPWR VPWR sky130_fd_sc_hd__decap_3
XFILLER_10_408 VGND VGND VPWR VPWR sky130_fd_sc_hd__fill_2
X_3996_ _3741_/Y _3800_/Y _3616_/A VGND VGND VPWR VPWR _3998_/A sky130_fd_sc_hd__a21oi_2
XFILLER_10_419 VGND VGND VPWR VPWR sky130_fd_sc_hd__fill_1
X_2947_ _5275_/Q _5208_/Q _2947_/B1 _5240_/Q _2946_/X VGND VGND VPWR VPWR _2947_/X
+ sky130_fd_sc_hd__a221o_2
XFILLER_13_49 VGND VGND VPWR VPWR sky130_fd_sc_hd__decap_3
X_4617_ _2703_/A _2683_/B _3747_/A _3689_/X VGND VGND VPWR VPWR _4617_/X sky130_fd_sc_hd__o2bb2a_2
X_2878_ _2887_/A _2878_/B VGND VGND VPWR VPWR _2878_/Y sky130_fd_sc_hd__nor2_2
X_4548_ _4684_/B1 _3740_/B _3740_/A _3363_/A VGND VGND VPWR VPWR _4550_/C sky130_fd_sc_hd__o2bb2a_2
Xmax_cap161 _4503_/A VGND VGND VPWR VPWR _4168_/A sky130_fd_sc_hd__buf_8
XFILLER_89_202 VGND VGND VPWR VPWR sky130_fd_sc_hd__decap_3
X_4479_ _4684_/B1 _3604_/B _4473_/X VGND VGND VPWR VPWR _4479_/Y sky130_fd_sc_hd__a21oi_2
Xmax_cap172 _5135_/Q VGND VGND VPWR VPWR _2854_/S0 sky130_fd_sc_hd__buf_12
Xmax_cap183 _5127_/Q VGND VGND VPWR VPWR _2676_/S0 sky130_fd_sc_hd__buf_12
XFILLER_8_9 VGND VGND VPWR VPWR sky130_fd_sc_hd__decap_3
XFILLER_77_419 VGND VGND VPWR VPWR sky130_fd_sc_hd__decap_3
XFILLER_57_110 VGND VGND VPWR VPWR sky130_fd_sc_hd__fill_2
XFILLER_38_79 VGND VGND VPWR VPWR sky130_fd_sc_hd__decap_3
XFILLER_57_143 VGND VGND VPWR VPWR sky130_fd_sc_hd__fill_1
XFILLER_85_452 VGND VGND VPWR VPWR sky130_fd_sc_hd__decap_3
XFILLER_85_441 VGND VGND VPWR VPWR sky130_fd_sc_hd__decap_3
XFILLER_18_519 VGND VGND VPWR VPWR sky130_fd_sc_hd__decap_3
XFILLER_45_316 VGND VGND VPWR VPWR sky130_fd_sc_hd__decap_3
XPHY_EDGE_ROW_79_Right_79 VGND VGND VPWR VPWR sky130_fd_sc_hd__decap_3
XFILLER_85_485 VGND VGND VPWR VPWR sky130_fd_sc_hd__decap_3
XFILLER_85_463 VGND VGND VPWR VPWR sky130_fd_sc_hd__fill_1
XFILLER_72_124 VGND VGND VPWR VPWR sky130_fd_sc_hd__fill_2
XFILLER_72_146 VGND VGND VPWR VPWR sky130_fd_sc_hd__decap_3
XFILLER_13_213 VGND VGND VPWR VPWR sky130_fd_sc_hd__decap_3
XTAP_TAPCELL_ROW_0_194 VGND VPWR sky130_fd_sc_hd__tapvpwrvgnd_1
XFILLER_13_246 VGND VGND VPWR VPWR sky130_fd_sc_hd__decap_3
XFILLER_70_44 VGND VGND VPWR VPWR sky130_fd_sc_hd__decap_3
XFILLER_21_290 VGND VGND VPWR VPWR sky130_fd_sc_hd__decap_3
XFILLER_70_88 VGND VGND VPWR VPWR sky130_fd_sc_hd__decap_3
XPHY_EDGE_ROW_88_Right_88 VGND VGND VPWR VPWR sky130_fd_sc_hd__decap_3
XFILLER_5_489 VGND VGND VPWR VPWR sky130_fd_sc_hd__decap_3
XFILLER_0_172 VGND VGND VPWR VPWR sky130_fd_sc_hd__decap_3
XTAP_TAPCELL_ROW_79_948 VGND VPWR sky130_fd_sc_hd__tapvpwrvgnd_1
XFILLER_48_121 VGND VGND VPWR VPWR sky130_fd_sc_hd__decap_3
XFILLER_76_430 VGND VGND VPWR VPWR sky130_fd_sc_hd__decap_3
XFILLER_48_165 VGND VGND VPWR VPWR sky130_fd_sc_hd__decap_3
XFILLER_91_411 VGND VGND VPWR VPWR sky130_fd_sc_hd__fill_2
XFILLER_76_474 VGND VGND VPWR VPWR sky130_fd_sc_hd__fill_2
XFILLER_36_338 VGND VGND VPWR VPWR sky130_fd_sc_hd__decap_3
XFILLER_48_187 VGND VGND VPWR VPWR sky130_fd_sc_hd__decap_3
XFILLER_63_113 VGND VGND VPWR VPWR sky130_fd_sc_hd__decap_3
XFILLER_63_135 VGND VGND VPWR VPWR sky130_fd_sc_hd__decap_3
XFILLER_17_552 VGND VGND VPWR VPWR sky130_fd_sc_hd__decap_3
XFILLER_32_533 VGND VGND VPWR VPWR sky130_fd_sc_hd__decap_3
XFILLER_44_371 VGND VGND VPWR VPWR sky130_fd_sc_hd__decap_3
XTAP_TAPCELL_ROW_34_528 VGND VPWR sky130_fd_sc_hd__tapvpwrvgnd_1
X_3850_ _3701_/A _4397_/D _3866_/B VGND VGND VPWR VPWR _3851_/A sky130_fd_sc_hd__mux2_1
X_3781_ _2601_/Y _3776_/X _3780_/X _3584_/Y VGND VGND VPWR VPWR _3782_/C sky130_fd_sc_hd__o31a_2
X_2801_ _2799_/X _2800_/X _5137_/Q VGND VGND VPWR VPWR _2801_/X sky130_fd_sc_hd__mux2_1
XTAP_TAPCELL_ROW_70_870 VGND VPWR sky130_fd_sc_hd__tapvpwrvgnd_1
XFILLER_74_3 VGND VGND VPWR VPWR sky130_fd_sc_hd__fill_1
X_2732_ _4889_/Q _4873_/Q _5097_/Q _5081_/Q _2851_/S0 _2854_/S1 VGND VGND VPWR VPWR
+ _2732_/X sky130_fd_sc_hd__mux4_2
XFILLER_8_250 VGND VGND VPWR VPWR sky130_fd_sc_hd__fill_2
X_2663_ _4962_/Q _4946_/Q _4930_/Q _4914_/Q _5127_/Q _5128_/Q VGND VGND VPWR VPWR
+ _2663_/X sky130_fd_sc_hd__mux4_2
X_4402_ _4402_/A _4402_/B VGND VGND VPWR VPWR _4404_/B sky130_fd_sc_hd__xnor2_2
X_2594_ _5112_/Q _5000_/Q _4984_/Q _4968_/Q _5127_/Q _5128_/Q VGND VGND VPWR VPWR
+ _2594_/X sky130_fd_sc_hd__mux4_2
X_4333_ _4334_/B _4333_/B VGND VGND VPWR VPWR _4502_/A sky130_fd_sc_hd__or2_2
XFILLER_59_408 VGND VGND VPWR VPWR sky130_fd_sc_hd__decap_3
X_4264_ _4365_/A _4449_/S VGND VGND VPWR VPWR _4265_/B sky130_fd_sc_hd__nand2_2
X_3215_ _2911_/X _3227_/A2 _3211_/Y _5114_/Q VGND VGND VPWR VPWR _5114_/D sky130_fd_sc_hd__a22o_2
XFILLER_86_238 VGND VGND VPWR VPWR sky130_fd_sc_hd__fill_2
XFILLER_67_441 VGND VGND VPWR VPWR sky130_fd_sc_hd__decap_3
XFILLER_67_452 VGND VGND VPWR VPWR sky130_fd_sc_hd__decap_3
X_4195_ _4194_/X _4101_/B _4267_/S VGND VGND VPWR VPWR _4195_/X sky130_fd_sc_hd__mux2_1
XFILLER_79_290 VGND VGND VPWR VPWR sky130_fd_sc_hd__decap_3
XFILLER_67_474 VGND VGND VPWR VPWR sky130_fd_sc_hd__decap_3
X_3146_ _2921_/X _3155_/A2 _3139_/Y _5053_/Q VGND VGND VPWR VPWR _5053_/D sky130_fd_sc_hd__a22o_2
X_3077_ _2934_/X _3066_/B _3066_/Y _4993_/Q VGND VGND VPWR VPWR _4993_/D sky130_fd_sc_hd__a22o_2
XFILLER_82_433 VGND VGND VPWR VPWR sky130_fd_sc_hd__fill_2
XFILLER_42_319 VGND VGND VPWR VPWR sky130_fd_sc_hd__decap_3
XFILLER_82_477 VGND VGND VPWR VPWR sky130_fd_sc_hd__decap_3
XFILLER_82_455 VGND VGND VPWR VPWR sky130_fd_sc_hd__decap_3
XFILLER_10_216 VGND VGND VPWR VPWR sky130_fd_sc_hd__decap_3
XFILLER_50_363 VGND VGND VPWR VPWR sky130_fd_sc_hd__fill_1
X_3979_ _2577_/Y _3764_/X _3767_/Y _3743_/Y _4503_/A VGND VGND VPWR VPWR _3979_/X
+ sky130_fd_sc_hd__a221o_2
XFILLER_6_6 VGND VGND VPWR VPWR sky130_fd_sc_hd__decap_3
XFILLER_49_45 VGND VGND VPWR VPWR sky130_fd_sc_hd__decap_3
XFILLER_58_430 VGND VGND VPWR VPWR sky130_fd_sc_hd__decap_3
XTAP_TAPCELL_ROW_5_253 VGND VPWR sky130_fd_sc_hd__tapvpwrvgnd_1
XFILLER_18_327 VGND VGND VPWR VPWR sky130_fd_sc_hd__decap_3
XFILLER_45_113 VGND VGND VPWR VPWR sky130_fd_sc_hd__decap_3
XFILLER_65_44 VGND VGND VPWR VPWR sky130_fd_sc_hd__fill_1
XTAP_TAPCELL_ROW_86_1014 VGND VPWR sky130_fd_sc_hd__tapvpwrvgnd_1
XFILLER_65_77 VGND VGND VPWR VPWR sky130_fd_sc_hd__fill_2
XFILLER_73_455 VGND VGND VPWR VPWR sky130_fd_sc_hd__decap_3
XTAP_TAPCELL_ROW_84_995 VGND VPWR sky130_fd_sc_hd__tapvpwrvgnd_1
XFILLER_14_533 VGND VGND VPWR VPWR sky130_fd_sc_hd__fill_1
XFILLER_14_555 VGND VGND VPWR VPWR sky130_fd_sc_hd__decap_3
XFILLER_41_385 VGND VGND VPWR VPWR sky130_fd_sc_hd__fill_2
XFILLER_41_396 VGND VGND VPWR VPWR sky130_fd_sc_hd__fill_1
XFILLER_5_264 VGND VGND VPWR VPWR sky130_fd_sc_hd__decap_3
XFILLER_1_470 VGND VGND VPWR VPWR sky130_fd_sc_hd__decap_3
XFILLER_39_6 VGND VGND VPWR VPWR sky130_fd_sc_hd__decap_3
XFILLER_68_249 VGND VGND VPWR VPWR sky130_fd_sc_hd__decap_3
XFILLER_49_452 VGND VGND VPWR VPWR sky130_fd_sc_hd__fill_1
XFILLER_49_474 VGND VGND VPWR VPWR sky130_fd_sc_hd__decap_3
Xinput7 INSTR_STREAM[15] VGND VGND VPWR VPWR input7/X sky130_fd_sc_hd__clkdlybuf4s25_1
X_3000_ _2921_/X _2992_/Y _2993_/Y _4925_/Q VGND VGND VPWR VPWR _4925_/D sky130_fd_sc_hd__a22o_2
XFILLER_36_124 VGND VGND VPWR VPWR sky130_fd_sc_hd__fill_1
XFILLER_76_271 VGND VGND VPWR VPWR sky130_fd_sc_hd__fill_1
XFILLER_51_105 VGND VGND VPWR VPWR sky130_fd_sc_hd__decap_3
XFILLER_51_116 VGND VGND VPWR VPWR sky130_fd_sc_hd__fill_1
X_4951_ clkload8/A _4951_/D VGND VGND VPWR VPWR _4951_/Q sky130_fd_sc_hd__dfxtp_2
XFILLER_17_393 VGND VGND VPWR VPWR sky130_fd_sc_hd__decap_3
XFILLER_32_330 VGND VGND VPWR VPWR sky130_fd_sc_hd__decap_3
X_4882_ _5103_/CLK _4882_/D VGND VGND VPWR VPWR _4882_/Q sky130_fd_sc_hd__dfxtp_2
X_3902_ _3961_/S _3899_/X _3901_/X _4016_/A VGND VGND VPWR VPWR _3902_/X sky130_fd_sc_hd__o211a_2
XFILLER_32_374 VGND VGND VPWR VPWR sky130_fd_sc_hd__decap_3
X_3833_ _3827_/X _3832_/X _3776_/X VGND VGND VPWR VPWR _4192_/B sky130_fd_sc_hd__a21oi_2
X_3764_ _5183_/Q _5182_/Q _5181_/Q _3891_/A VGND VGND VPWR VPWR _3764_/X sky130_fd_sc_hd__and4_2
X_3695_ _3705_/A _3694_/X _5134_/Q VGND VGND VPWR VPWR _3695_/X sky130_fd_sc_hd__o21a_2
X_2715_ _5063_/Q _5047_/Q _5031_/Q _5015_/Q _2851_/S0 _2854_/S1 VGND VGND VPWR VPWR
+ _2715_/X sky130_fd_sc_hd__mux4_2
X_2646_ _4895_/Q _4879_/Q _5103_/Q _5087_/Q _2672_/S0 _2672_/S1 VGND VGND VPWR VPWR
+ _2647_/B sky130_fd_sc_hd__mux4_2
X_2577_ _5159_/Q _4318_/A VGND VGND VPWR VPWR _2577_/Y sky130_fd_sc_hd__nand2_2
XFILLER_59_205 VGND VGND VPWR VPWR sky130_fd_sc_hd__decap_3
X_4316_ _4487_/A _4316_/B VGND VGND VPWR VPWR _4316_/Y sky130_fd_sc_hd__nor2_2
XFILLER_87_514 VGND VGND VPWR VPWR sky130_fd_sc_hd__decap_3
XFILLER_19_15 VGND VGND VPWR VPWR sky130_fd_sc_hd__decap_3
X_4247_ _4175_/A _4045_/X _4070_/X VGND VGND VPWR VPWR _4250_/C sky130_fd_sc_hd__o21ai_2
XFILLER_87_547 VGND VGND VPWR VPWR sky130_fd_sc_hd__decap_3
X_4178_ _4173_/A _4278_/B _4070_/X _4175_/X _4177_/X VGND VGND VPWR VPWR _4185_/C
+ sky130_fd_sc_hd__a221o_2
XFILLER_27_113 VGND VGND VPWR VPWR sky130_fd_sc_hd__decap_3
XTAP_TAPCELL_ROW_2_223 VGND VPWR sky130_fd_sc_hd__tapvpwrvgnd_1
X_3129_ _2924_/X _3121_/B _3121_/Y _5038_/Q VGND VGND VPWR VPWR _5038_/D sky130_fd_sc_hd__a22o_2
XFILLER_55_488 VGND VGND VPWR VPWR sky130_fd_sc_hd__decap_3
XFILLER_70_436 VGND VGND VPWR VPWR sky130_fd_sc_hd__decap_3
XFILLER_23_363 VGND VGND VPWR VPWR sky130_fd_sc_hd__decap_3
XFILLER_50_160 VGND VGND VPWR VPWR sky130_fd_sc_hd__fill_1
XFILLER_50_193 VGND VGND VPWR VPWR sky130_fd_sc_hd__decap_3
XFILLER_7_529 VGND VGND VPWR VPWR sky130_fd_sc_hd__decap_3
XFILLER_4_3 VGND VGND VPWR VPWR sky130_fd_sc_hd__decap_3
XTAP_TAPCELL_ROW_92_1073 VGND VPWR sky130_fd_sc_hd__tapvpwrvgnd_1
XFILLER_78_536 VGND VGND VPWR VPWR sky130_fd_sc_hd__fill_2
XFILLER_78_525 VGND VGND VPWR VPWR sky130_fd_sc_hd__fill_1
XFILLER_93_517 VGND VGND VPWR VPWR sky130_fd_sc_hd__decap_3
XFILLER_76_54 VGND VGND VPWR VPWR sky130_fd_sc_hd__fill_2
XFILLER_46_433 VGND VGND VPWR VPWR sky130_fd_sc_hd__decap_3
XFILLER_93_539 VGND VGND VPWR VPWR sky130_fd_sc_hd__decap_3
XFILLER_46_455 VGND VGND VPWR VPWR sky130_fd_sc_hd__decap_3
XFILLER_33_116 VGND VGND VPWR VPWR sky130_fd_sc_hd__decap_3
XTAP_TAPCELL_ROW_44_623 VGND VPWR sky130_fd_sc_hd__tapvpwrvgnd_1
XFILLER_61_447 VGND VGND VPWR VPWR sky130_fd_sc_hd__fill_1
XFILLER_61_458 VGND VGND VPWR VPWR sky130_fd_sc_hd__decap_3
XFILLER_92_75 VGND VGND VPWR VPWR sky130_fd_sc_hd__decap_3
XTAP_TAPCELL_ROW_16_358 VGND VPWR sky130_fd_sc_hd__tapvpwrvgnd_1
X_3480_ _3479_/A _3479_/B _3458_/A VGND VGND VPWR VPWR _3480_/X sky130_fd_sc_hd__a21o_2
X_2500_ _5124_/Q _5012_/Q _4996_/Q _4980_/Q _2676_/S0 _2676_/S1 VGND VGND VPWR VPWR
+ _2500_/X sky130_fd_sc_hd__mux4_2
X_2431_ _3494_/A VGND VGND VPWR VPWR _3366_/A sky130_fd_sc_hd__inv_6
XFILLER_37_3 VGND VGND VPWR VPWR sky130_fd_sc_hd__decap_3
XFILLER_69_514 VGND VGND VPWR VPWR sky130_fd_sc_hd__decap_3
X_5150_ _5208_/CLK _5150_/D VGND VGND VPWR VPWR _5150_/Q sky130_fd_sc_hd__dfxtp_2
X_4101_ _4267_/S _4101_/B VGND VGND VPWR VPWR _4101_/Y sky130_fd_sc_hd__nor2_2
X_5081_ _5105_/CLK _5081_/D VGND VGND VPWR VPWR _5081_/Q sky130_fd_sc_hd__dfxtp_2
XFILLER_2_62 VGND VGND VPWR VPWR sky130_fd_sc_hd__decap_3
XFILLER_49_260 VGND VGND VPWR VPWR sky130_fd_sc_hd__decap_3
X_4032_ _4051_/A _4224_/A _4225_/B _4078_/A _4026_/X VGND VGND VPWR VPWR _4037_/B
+ sky130_fd_sc_hd__o221a_2
XFILLER_84_506 VGND VGND VPWR VPWR sky130_fd_sc_hd__decap_3
XFILLER_37_411 VGND VGND VPWR VPWR sky130_fd_sc_hd__decap_3
XFILLER_49_293 VGND VGND VPWR VPWR sky130_fd_sc_hd__decap_3
XFILLER_37_488 VGND VGND VPWR VPWR sky130_fd_sc_hd__decap_3
XFILLER_52_447 VGND VGND VPWR VPWR sky130_fd_sc_hd__decap_3
X_4934_ clkload7/A _4934_/D VGND VGND VPWR VPWR _4934_/Q sky130_fd_sc_hd__dfxtp_2
XFILLER_32_171 VGND VGND VPWR VPWR sky130_fd_sc_hd__decap_3
XFILLER_32_193 VGND VGND VPWR VPWR sky130_fd_sc_hd__decap_3
XFILLER_60_480 VGND VGND VPWR VPWR sky130_fd_sc_hd__decap_3
X_4865_ _5174_/Q _4868_/A2 _4870_/B1 _3235_/X VGND VGND VPWR VPWR _5174_/D sky130_fd_sc_hd__o22a_2
X_4796_ _4795_/A _4795_/B _4854_/B VGND VGND VPWR VPWR _4796_/X sky130_fd_sc_hd__a21o_2
X_3816_ _5168_/Q _3852_/A VGND VGND VPWR VPWR _3842_/B sky130_fd_sc_hd__nor2_2
XFILLER_20_399 VGND VGND VPWR VPWR sky130_fd_sc_hd__fill_1
XFILLER_21_27 VGND VGND VPWR VPWR sky130_fd_sc_hd__decap_3
X_3747_ _3747_/A _4062_/A _4090_/A _4022_/A VGND VGND VPWR VPWR _3749_/C sky130_fd_sc_hd__or4_2
X_3678_ _4166_/A VGND VGND VPWR VPWR _4200_/A sky130_fd_sc_hd__inv_2
X_2629_ _2629_/A _2629_/B VGND VGND VPWR VPWR _2629_/Y sky130_fd_sc_hd__nand2_2
XFILLER_87_322 VGND VGND VPWR VPWR sky130_fd_sc_hd__decap_3
X_5279_ _5285_/CLK _5279_/D VGND VGND VPWR VPWR _5279_/Q sky130_fd_sc_hd__dfxtp_2
XFILLER_87_366 VGND VGND VPWR VPWR sky130_fd_sc_hd__decap_3
XFILLER_28_433 VGND VGND VPWR VPWR sky130_fd_sc_hd__decap_3
XTAP_TAPCELL_ROW_58_748 VGND VPWR sky130_fd_sc_hd__tapvpwrvgnd_1
XFILLER_87_399 VGND VGND VPWR VPWR sky130_fd_sc_hd__decap_3
XFILLER_28_455 VGND VGND VPWR VPWR sky130_fd_sc_hd__decap_3
XFILLER_83_550 VGND VGND VPWR VPWR sky130_fd_sc_hd__decap_3
XFILLER_15_116 VGND VGND VPWR VPWR sky130_fd_sc_hd__decap_3
XFILLER_43_414 VGND VGND VPWR VPWR sky130_fd_sc_hd__decap_3
XFILLER_43_458 VGND VGND VPWR VPWR sky130_fd_sc_hd__fill_1
XFILLER_70_222 VGND VGND VPWR VPWR sky130_fd_sc_hd__decap_3
XTAP_TAPCELL_ROW_13_328 VGND VPWR sky130_fd_sc_hd__tapvpwrvgnd_1
XFILLER_11_366 VGND VGND VPWR VPWR sky130_fd_sc_hd__decap_3
XFILLER_7_304 VGND VGND VPWR VPWR sky130_fd_sc_hd__decap_3
XFILLER_11_60 VGND VGND VPWR VPWR sky130_fd_sc_hd__decap_3
XFILLER_3_532 VGND VGND VPWR VPWR sky130_fd_sc_hd__decap_3
XFILLER_87_86 VGND VGND VPWR VPWR sky130_fd_sc_hd__decap_3
XFILLER_87_53 VGND VGND VPWR VPWR sky130_fd_sc_hd__decap_3
XFILLER_66_517 VGND VGND VPWR VPWR sky130_fd_sc_hd__decap_3
XFILLER_78_377 VGND VGND VPWR VPWR sky130_fd_sc_hd__decap_3
XFILLER_66_539 VGND VGND VPWR VPWR sky130_fd_sc_hd__decap_3
XFILLER_34_436 VGND VGND VPWR VPWR sky130_fd_sc_hd__decap_3
XFILLER_61_222 VGND VGND VPWR VPWR sky130_fd_sc_hd__fill_2
XFILLER_34_469 VGND VGND VPWR VPWR sky130_fd_sc_hd__decap_3
XFILLER_61_277 VGND VGND VPWR VPWR sky130_fd_sc_hd__decap_3
X_2980_ _2918_/X _2974_/B _2974_/Y _4908_/Q VGND VGND VPWR VPWR _4908_/D sky130_fd_sc_hd__a22o_2
XFILLER_42_480 VGND VGND VPWR VPWR sky130_fd_sc_hd__decap_3
X_4650_ _5238_/Q _4854_/B _4541_/X _4649_/X VGND VGND VPWR VPWR _4651_/B sky130_fd_sc_hd__o2bb2a_2
Xinput21 INSTR_STREAM[28] VGND VGND VPWR VPWR _3348_/C sky130_fd_sc_hd__clkdlybuf4s25_1
Xinput10 INSTR_STREAM[18] VGND VGND VPWR VPWR _3235_/C sky130_fd_sc_hd__clkdlybuf4s25_1
X_3601_ _4559_/S _3601_/B VGND VGND VPWR VPWR _4062_/A sky130_fd_sc_hd__nor2_2
X_4581_ _3363_/A _4213_/A _4581_/S VGND VGND VPWR VPWR _4581_/X sky130_fd_sc_hd__mux2_1
Xinput43 MEM_LD_DATA[4] VGND VGND VPWR VPWR input43/X sky130_fd_sc_hd__clkdlybuf4s25_1
Xinput32 INSTR_STREAM[9] VGND VGND VPWR VPWR _3334_/C sky130_fd_sc_hd__clkdlybuf4s25_1
X_3532_ _3527_/X _3528_/X _3531_/X _2430_/Y VGND VGND VPWR VPWR _4286_/B sky130_fd_sc_hd__a22o_2
X_3463_ _3454_/A _3457_/X _3462_/Y VGND VGND VPWR VPWR _3463_/X sky130_fd_sc_hd__a21o_2
Xclkbuf_leaf_30_CLK clkload0/A VGND VGND VPWR VPWR _5107_/CLK sky130_fd_sc_hd__clkbuf_8
X_5202_ _5251_/CLK _5202_/D VGND VGND VPWR VPWR _5202_/Q sky130_fd_sc_hd__dfxtp_2
XFILLER_69_322 VGND VGND VPWR VPWR sky130_fd_sc_hd__decap_3
XFILLER_69_344 VGND VGND VPWR VPWR sky130_fd_sc_hd__decap_3
X_5133_ _5177_/CLK _5133_/D VGND VGND VPWR VPWR _5133_/Q sky130_fd_sc_hd__dfxtp_2
X_3394_ _3394_/A _3458_/A _3392_/X VGND VGND VPWR VPWR _3394_/X sky130_fd_sc_hd__or3b_2
XFILLER_69_377 VGND VGND VPWR VPWR sky130_fd_sc_hd__decap_3
X_5064_ _5069_/CLK _5064_/D VGND VGND VPWR VPWR _5064_/Q sky130_fd_sc_hd__dfxtp_2
XFILLER_84_336 VGND VGND VPWR VPWR sky130_fd_sc_hd__decap_3
X_4015_ _4015_/A _4015_/B VGND VGND VPWR VPWR _4550_/A sky130_fd_sc_hd__nand2_2
XFILLER_25_414 VGND VGND VPWR VPWR sky130_fd_sc_hd__decap_3
XFILLER_37_252 VGND VGND VPWR VPWR sky130_fd_sc_hd__decap_3
XFILLER_52_200 VGND VGND VPWR VPWR sky130_fd_sc_hd__decap_3
XFILLER_16_27 VGND VGND VPWR VPWR sky130_fd_sc_hd__fill_1
XFILLER_25_447 VGND VGND VPWR VPWR sky130_fd_sc_hd__fill_1
XFILLER_25_458 VGND VGND VPWR VPWR sky130_fd_sc_hd__decap_3
XFILLER_80_531 VGND VGND VPWR VPWR sky130_fd_sc_hd__fill_1
XFILLER_33_491 VGND VGND VPWR VPWR sky130_fd_sc_hd__decap_3
XFILLER_52_299 VGND VGND VPWR VPWR sky130_fd_sc_hd__decap_3
X_4917_ _5008_/CLK _4917_/D VGND VGND VPWR VPWR _4917_/Q sky130_fd_sc_hd__dfxtp_2
X_4848_ _5275_/Q _4847_/B _4847_/Y _3366_/A VGND VGND VPWR VPWR _5275_/D sky130_fd_sc_hd__o211a_2
XFILLER_32_59 VGND VGND VPWR VPWR sky130_fd_sc_hd__decap_3
X_4779_ _4772_/A _4772_/B _4772_/C _4770_/A VGND VGND VPWR VPWR _4780_/B sky130_fd_sc_hd__a31o_2
XFILLER_4_318 VGND VGND VPWR VPWR sky130_fd_sc_hd__fill_2
Xclkbuf_leaf_21_CLK clkload2/A VGND VGND VPWR VPWR _5257_/CLK sky130_fd_sc_hd__clkbuf_8
XFILLER_0_557 VGND VGND VPWR VPWR sky130_fd_sc_hd__fill_1
XFILLER_75_314 VGND VGND VPWR VPWR sky130_fd_sc_hd__decap_3
XFILLER_57_89 VGND VGND VPWR VPWR sky130_fd_sc_hd__decap_3
XFILLER_75_369 VGND VGND VPWR VPWR sky130_fd_sc_hd__fill_1
XFILLER_90_317 VGND VGND VPWR VPWR sky130_fd_sc_hd__decap_3
XFILLER_71_520 VGND VGND VPWR VPWR sky130_fd_sc_hd__fill_1
XFILLER_71_542 VGND VGND VPWR VPWR sky130_fd_sc_hd__decap_3
XFILLER_83_391 VGND VGND VPWR VPWR sky130_fd_sc_hd__fill_1
XFILLER_43_266 VGND VGND VPWR VPWR sky130_fd_sc_hd__fill_1
XFILLER_73_77 VGND VGND VPWR VPWR sky130_fd_sc_hd__decap_3
XTAP_TAPCELL_ROW_26_453 VGND VPWR sky130_fd_sc_hd__tapvpwrvgnd_1
XFILLER_24_480 VGND VGND VPWR VPWR sky130_fd_sc_hd__decap_3
XFILLER_43_288 VGND VGND VPWR VPWR sky130_fd_sc_hd__decap_3
XFILLER_11_141 VGND VGND VPWR VPWR sky130_fd_sc_hd__fill_2
XFILLER_11_163 VGND VGND VPWR VPWR sky130_fd_sc_hd__decap_3
XFILLER_7_101 VGND VGND VPWR VPWR sky130_fd_sc_hd__decap_3
XFILLER_7_145 VGND VGND VPWR VPWR sky130_fd_sc_hd__decap_3
XFILLER_7_178 VGND VGND VPWR VPWR sky130_fd_sc_hd__decap_3
Xclkbuf_leaf_12_CLK clkload1/A VGND VGND VPWR VPWR _5271_/CLK sky130_fd_sc_hd__clkbuf_8
XFILLER_21_6 VGND VGND VPWR VPWR sky130_fd_sc_hd__fill_2
XFILLER_78_152 VGND VGND VPWR VPWR sky130_fd_sc_hd__decap_3
XFILLER_78_130 VGND VGND VPWR VPWR sky130_fd_sc_hd__decap_3
XFILLER_93_111 VGND VGND VPWR VPWR sky130_fd_sc_hd__fill_1
XFILLER_93_100 VGND VGND VPWR VPWR sky130_fd_sc_hd__fill_2
XFILLER_78_185 VGND VGND VPWR VPWR sky130_fd_sc_hd__decap_3
XFILLER_54_509 VGND VGND VPWR VPWR sky130_fd_sc_hd__decap_3
XFILLER_66_347 VGND VGND VPWR VPWR sky130_fd_sc_hd__decap_3
XFILLER_34_200 VGND VGND VPWR VPWR sky130_fd_sc_hd__decap_3
XFILLER_93_177 VGND VGND VPWR VPWR sky130_fd_sc_hd__decap_3
XFILLER_62_553 VGND VGND VPWR VPWR sky130_fd_sc_hd__decap_3
XFILLER_15_480 VGND VGND VPWR VPWR sky130_fd_sc_hd__decap_3
XFILLER_22_439 VGND VGND VPWR VPWR sky130_fd_sc_hd__fill_2
XFILLER_34_288 VGND VGND VPWR VPWR sky130_fd_sc_hd__decap_3
X_2963_ _2927_/X _2954_/B _2954_/Y _4895_/Q VGND VGND VPWR VPWR _4895_/D sky130_fd_sc_hd__a22o_2
X_4702_ input42/X _4694_/Y _4701_/X _3366_/A VGND VGND VPWR VPWR _5245_/D sky130_fd_sc_hd__o211a_2
XFILLER_30_483 VGND VGND VPWR VPWR sky130_fd_sc_hd__decap_3
X_2894_ _2894_/A _4236_/B _4236_/C VGND VGND VPWR VPWR _2894_/X sky130_fd_sc_hd__and3_2
XTAP_TAPCELL_ROW_60_776 VGND VPWR sky130_fd_sc_hd__tapvpwrvgnd_1
X_4633_ _4191_/A _3567_/S _4633_/S VGND VGND VPWR VPWR _4633_/X sky130_fd_sc_hd__mux2_1
XFILLER_8_61 VGND VGND VPWR VPWR sky130_fd_sc_hd__decap_3
X_4564_ _4564_/A _4571_/B VGND VGND VPWR VPWR _4564_/X sky130_fd_sc_hd__or2_2
X_3515_ _4281_/A _5158_/Q _4422_/S VGND VGND VPWR VPWR _3515_/X sky130_fd_sc_hd__mux2_2
X_4495_ _4389_/A _4464_/B _4463_/A VGND VGND VPWR VPWR _4522_/C sky130_fd_sc_hd__a21oi_2
X_3446_ _3457_/A _3446_/B VGND VGND VPWR VPWR _3447_/B sky130_fd_sc_hd__nand2b_2
XFILLER_69_141 VGND VGND VPWR VPWR sky130_fd_sc_hd__decap_3
X_3377_ _5193_/Q _4275_/B _3358_/X _3366_/A VGND VGND VPWR VPWR _5193_/D sky130_fd_sc_hd__o211a_2
X_5116_ clkload9/A _5116_/D VGND VGND VPWR VPWR _5116_/Q sky130_fd_sc_hd__dfxtp_2
X_5047_ _5069_/CLK _5047_/D VGND VGND VPWR VPWR _5047_/Q sky130_fd_sc_hd__dfxtp_2
XTAP_TAPCELL_ROW_68_843 VGND VPWR sky130_fd_sc_hd__tapvpwrvgnd_1
XFILLER_25_222 VGND VGND VPWR VPWR sky130_fd_sc_hd__fill_2
XFILLER_65_391 VGND VGND VPWR VPWR sky130_fd_sc_hd__fill_1
XFILLER_72_339 VGND VGND VPWR VPWR sky130_fd_sc_hd__decap_3
XFILLER_13_428 VGND VGND VPWR VPWR sky130_fd_sc_hd__decap_3
XTAP_TAPCELL_ROW_23_423 VGND VPWR sky130_fd_sc_hd__tapvpwrvgnd_1
XFILLER_21_461 VGND VGND VPWR VPWR sky130_fd_sc_hd__decap_3
XFILLER_68_11 VGND VGND VPWR VPWR sky130_fd_sc_hd__fill_1
XFILLER_0_321 VGND VGND VPWR VPWR sky130_fd_sc_hd__decap_3
XFILLER_0_354 VGND VGND VPWR VPWR sky130_fd_sc_hd__decap_3
XFILLER_0_365 VGND VGND VPWR VPWR sky130_fd_sc_hd__decap_3
XFILLER_0_376 VGND VGND VPWR VPWR sky130_fd_sc_hd__decap_3
XFILLER_68_88 VGND VGND VPWR VPWR sky130_fd_sc_hd__decap_3
XFILLER_75_111 VGND VGND VPWR VPWR sky130_fd_sc_hd__fill_1
XFILLER_88_494 VGND VGND VPWR VPWR sky130_fd_sc_hd__decap_3
XFILLER_48_358 VGND VGND VPWR VPWR sky130_fd_sc_hd__decap_3
XFILLER_75_122 VGND VGND VPWR VPWR sky130_fd_sc_hd__decap_3
XTAP_TAPCELL_ROW_89_1045 VGND VPWR sky130_fd_sc_hd__tapvpwrvgnd_1
XFILLER_75_155 VGND VGND VPWR VPWR sky130_fd_sc_hd__decap_3
XFILLER_84_54 VGND VGND VPWR VPWR sky130_fd_sc_hd__decap_3
XFILLER_16_200 VGND VGND VPWR VPWR sky130_fd_sc_hd__decap_3
XFILLER_44_520 VGND VGND VPWR VPWR sky130_fd_sc_hd__fill_2
XFILLER_44_531 VGND VGND VPWR VPWR sky130_fd_sc_hd__fill_1
XFILLER_44_542 VGND VGND VPWR VPWR sky130_fd_sc_hd__decap_3
XFILLER_71_361 VGND VGND VPWR VPWR sky130_fd_sc_hd__decap_3
XFILLER_31_214 VGND VGND VPWR VPWR sky130_fd_sc_hd__decap_3
XFILLER_31_225 VGND VGND VPWR VPWR sky130_fd_sc_hd__decap_3
Xclkbuf_leaf_1_CLK clkbuf_leaf_5_CLK/A VGND VGND VPWR VPWR _4994_/CLK sky130_fd_sc_hd__clkbuf_8
XFILLER_12_472 VGND VGND VPWR VPWR sky130_fd_sc_hd__decap_3
XFILLER_8_421 VGND VGND VPWR VPWR sky130_fd_sc_hd__fill_1
XFILLER_12_483 VGND VGND VPWR VPWR sky130_fd_sc_hd__decap_3
XFILLER_8_443 VGND VGND VPWR VPWR sky130_fd_sc_hd__fill_1
X_3300_ _5150_/Q _3301_/B VGND VGND VPWR VPWR _3300_/Y sky130_fd_sc_hd__nor2_2
X_4280_ _4281_/A _4286_/A _4286_/B VGND VGND VPWR VPWR _4298_/B sky130_fd_sc_hd__or3_2
X_3231_ _5283_/Q _3338_/B input8/X VGND VGND VPWR VPWR _3231_/X sky130_fd_sc_hd__and3_2
XFILLER_79_461 VGND VGND VPWR VPWR sky130_fd_sc_hd__decap_3
XFILLER_39_325 VGND VGND VPWR VPWR sky130_fd_sc_hd__fill_1
X_3162_ _2914_/X _3173_/A2 _3157_/Y _5067_/Q VGND VGND VPWR VPWR _5067_/D sky130_fd_sc_hd__a22o_2
XFILLER_39_358 VGND VGND VPWR VPWR sky130_fd_sc_hd__decap_3
XFILLER_54_317 VGND VGND VPWR VPWR sky130_fd_sc_hd__decap_3
X_3093_ _2927_/X _3084_/B _3084_/Y _5007_/Q VGND VGND VPWR VPWR _5007_/D sky130_fd_sc_hd__a22o_2
XFILLER_47_380 VGND VGND VPWR VPWR sky130_fd_sc_hd__decap_3
XFILLER_54_339 VGND VGND VPWR VPWR sky130_fd_sc_hd__decap_3
XFILLER_81_147 VGND VGND VPWR VPWR sky130_fd_sc_hd__decap_3
XFILLER_81_136 VGND VGND VPWR VPWR sky130_fd_sc_hd__decap_3
XFILLER_50_523 VGND VGND VPWR VPWR sky130_fd_sc_hd__decap_3
X_3995_ _4078_/A _4196_/B _3994_/X _4051_/A _3988_/X VGND VGND VPWR VPWR _3995_/X
+ sky130_fd_sc_hd__o221a_2
X_2946_ _5277_/Q _5256_/Q _5224_/Q _5276_/Q VGND VGND VPWR VPWR _2946_/X sky130_fd_sc_hd__a22o_2
X_2877_ _2877_/A _3776_/B VGND VGND VPWR VPWR _2878_/B sky130_fd_sc_hd__xnor2_2
X_4616_ _4437_/X _4472_/X _4615_/X _4666_/A VGND VGND VPWR VPWR _4616_/X sky130_fd_sc_hd__a22o_2
X_4547_ _2703_/A _2624_/B _4062_/B _4213_/A VGND VGND VPWR VPWR _4547_/X sky130_fd_sc_hd__o2bb2a_2
Xmax_cap162 _2443_/X VGND VGND VPWR VPWR _4191_/A sky130_fd_sc_hd__buf_6
Xmax_cap140 _3157_/B VGND VGND VPWR VPWR _3173_/A2 sky130_fd_sc_hd__buf_6
X_4478_ _3934_/A _4021_/B _3894_/X _3820_/A _4474_/X VGND VGND VPWR VPWR _4481_/B
+ sky130_fd_sc_hd__o221a_2
Xmax_cap173 _5135_/Q VGND VGND VPWR VPWR _2818_/S0 sky130_fd_sc_hd__buf_12
Xmax_cap184 _3366_/A VGND VGND VPWR VPWR _3338_/B sky130_fd_sc_hd__buf_12
XFILLER_89_225 VGND VGND VPWR VPWR sky130_fd_sc_hd__fill_1
X_3429_ _5163_/Q _5144_/Q VGND VGND VPWR VPWR _3432_/B sky130_fd_sc_hd__or2_2
XFILLER_38_25 VGND VGND VPWR VPWR sky130_fd_sc_hd__decap_3
XFILLER_38_58 VGND VGND VPWR VPWR sky130_fd_sc_hd__decap_3
XFILLER_38_380 VGND VGND VPWR VPWR sky130_fd_sc_hd__decap_3
XFILLER_85_497 VGND VGND VPWR VPWR sky130_fd_sc_hd__fill_2
XFILLER_54_35 VGND VGND VPWR VPWR sky130_fd_sc_hd__fill_2
XFILLER_54_46 VGND VGND VPWR VPWR sky130_fd_sc_hd__decap_3
XFILLER_60_309 VGND VGND VPWR VPWR sky130_fd_sc_hd__decap_3
XFILLER_72_158 VGND VGND VPWR VPWR sky130_fd_sc_hd__decap_3
XFILLER_13_225 VGND VGND VPWR VPWR sky130_fd_sc_hd__decap_3
XFILLER_53_372 VGND VGND VPWR VPWR sky130_fd_sc_hd__decap_3
XTAP_TAPCELL_ROW_0_195 VGND VPWR sky130_fd_sc_hd__tapvpwrvgnd_1
XFILLER_41_556 VGND VGND VPWR VPWR sky130_fd_sc_hd__fill_2
XFILLER_79_43 VGND VGND VPWR VPWR sky130_fd_sc_hd__decap_3
XFILLER_0_162 VGND VGND VPWR VPWR sky130_fd_sc_hd__decap_3
XTAP_TAPCELL_ROW_8_273 VGND VPWR sky130_fd_sc_hd__tapvpwrvgnd_1
XTAP_TAPCELL_ROW_79_949 VGND VPWR sky130_fd_sc_hd__tapvpwrvgnd_1
XFILLER_48_144 VGND VGND VPWR VPWR sky130_fd_sc_hd__decap_3
XFILLER_76_453 VGND VGND VPWR VPWR sky130_fd_sc_hd__decap_3
XFILLER_36_306 VGND VGND VPWR VPWR sky130_fd_sc_hd__fill_2
XFILLER_91_401 VGND VGND VPWR VPWR sky130_fd_sc_hd__decap_3
XFILLER_76_486 VGND VGND VPWR VPWR sky130_fd_sc_hd__decap_3
XFILLER_29_391 VGND VGND VPWR VPWR sky130_fd_sc_hd__fill_1
XFILLER_36_328 VGND VGND VPWR VPWR sky130_fd_sc_hd__decap_3
XFILLER_51_309 VGND VGND VPWR VPWR sky130_fd_sc_hd__decap_3
XFILLER_63_158 VGND VGND VPWR VPWR sky130_fd_sc_hd__decap_3
XFILLER_91_456 VGND VGND VPWR VPWR sky130_fd_sc_hd__fill_2
XFILLER_32_501 VGND VGND VPWR VPWR sky130_fd_sc_hd__decap_3
XFILLER_44_383 VGND VGND VPWR VPWR sky130_fd_sc_hd__fill_2
XTAP_TAPCELL_ROW_34_529 VGND VPWR sky130_fd_sc_hd__tapvpwrvgnd_1
XFILLER_91_489 VGND VGND VPWR VPWR sky130_fd_sc_hd__decap_3
XFILLER_44_394 VGND VGND VPWR VPWR sky130_fd_sc_hd__fill_2
XFILLER_71_191 VGND VGND VPWR VPWR sky130_fd_sc_hd__fill_2
X_3780_ _3780_/A _3820_/A _3780_/C _3780_/D VGND VGND VPWR VPWR _3780_/X sky130_fd_sc_hd__or4_2
X_2800_ _4960_/Q _4944_/Q _4928_/Q _4912_/Q _2818_/S0 _5136_/Q VGND VGND VPWR VPWR
+ _2800_/X sky130_fd_sc_hd__mux4_2
XTAP_TAPCELL_ROW_70_871 VGND VPWR sky130_fd_sc_hd__tapvpwrvgnd_1
X_2731_ _2857_/A _4732_/B VGND VGND VPWR VPWR _2731_/X sky130_fd_sc_hd__and2_2
XFILLER_12_291 VGND VGND VPWR VPWR sky130_fd_sc_hd__decap_3
XFILLER_8_262 VGND VGND VPWR VPWR sky130_fd_sc_hd__fill_2
X_4401_ _4398_/X _4399_/X _4402_/A _4458_/B VGND VGND VPWR VPWR _4462_/A sky130_fd_sc_hd__o211a_2
X_2662_ _5122_/Q _5010_/Q _4994_/Q _4978_/Q _5127_/Q _5128_/Q VGND VGND VPWR VPWR
+ _2662_/X sky130_fd_sc_hd__mux4_2
X_2593_ _2677_/S _2592_/X _5130_/Q VGND VGND VPWR VPWR _2593_/X sky130_fd_sc_hd__o21a_2
X_4332_ _4397_/A _4397_/B _4332_/C _4397_/D VGND VGND VPWR VPWR _4333_/B sky130_fd_sc_hd__or4_2
XFILLER_5_95 VGND VGND VPWR VPWR sky130_fd_sc_hd__decap_3
X_4263_ _4378_/A _4449_/S VGND VGND VPWR VPWR _4515_/A sky130_fd_sc_hd__or2_2
X_3214_ _2908_/X _3227_/A2 _3211_/Y _5113_/Q VGND VGND VPWR VPWR _5113_/D sky130_fd_sc_hd__a22o_2
XFILLER_86_217 VGND VGND VPWR VPWR sky130_fd_sc_hd__fill_2
XFILLER_67_420 VGND VGND VPWR VPWR sky130_fd_sc_hd__decap_3
X_4194_ _4193_/X _4148_/X _4266_/S VGND VGND VPWR VPWR _4194_/X sky130_fd_sc_hd__mux2_1
XFILLER_39_155 VGND VGND VPWR VPWR sky130_fd_sc_hd__decap_3
XFILLER_67_464 VGND VGND VPWR VPWR sky130_fd_sc_hd__fill_1
XFILLER_67_486 VGND VGND VPWR VPWR sky130_fd_sc_hd__decap_3
X_3145_ _2918_/X _3155_/A2 _3139_/Y _5052_/Q VGND VGND VPWR VPWR _5052_/D sky130_fd_sc_hd__a22o_2
XFILLER_82_401 VGND VGND VPWR VPWR sky130_fd_sc_hd__decap_3
XFILLER_27_328 VGND VGND VPWR VPWR sky130_fd_sc_hd__decap_3
XFILLER_39_188 VGND VGND VPWR VPWR sky130_fd_sc_hd__decap_3
XFILLER_54_103 VGND VGND VPWR VPWR sky130_fd_sc_hd__decap_3
XFILLER_54_136 VGND VGND VPWR VPWR sky130_fd_sc_hd__decap_3
X_3076_ _2931_/X _3065_/Y _3066_/Y _4992_/Q VGND VGND VPWR VPWR _4992_/D sky130_fd_sc_hd__a22o_2
XFILLER_54_158 VGND VGND VPWR VPWR sky130_fd_sc_hd__decap_3
XFILLER_82_467 VGND VGND VPWR VPWR sky130_fd_sc_hd__decap_3
XFILLER_23_512 VGND VGND VPWR VPWR sky130_fd_sc_hd__decap_3
XFILLER_23_523 VGND VGND VPWR VPWR sky130_fd_sc_hd__decap_3
XFILLER_24_27 VGND VGND VPWR VPWR sky130_fd_sc_hd__fill_1
XFILLER_50_342 VGND VGND VPWR VPWR sky130_fd_sc_hd__decap_3
X_3978_ _3978_/A _4509_/A VGND VGND VPWR VPWR _3981_/C sky130_fd_sc_hd__or2_2
X_2929_ _5276_/Q _5219_/Q _5203_/Q _5275_/Q VGND VGND VPWR VPWR _2931_/A sky130_fd_sc_hd__a22o_2
XFILLER_49_68 VGND VGND VPWR VPWR sky130_fd_sc_hd__decap_3
XFILLER_77_228 VGND VGND VPWR VPWR sky130_fd_sc_hd__decap_3
XFILLER_77_217 VGND VGND VPWR VPWR sky130_fd_sc_hd__decap_3
XFILLER_18_306 VGND VGND VPWR VPWR sky130_fd_sc_hd__fill_2
XTAP_TAPCELL_ROW_76_919 VGND VPWR sky130_fd_sc_hd__tapvpwrvgnd_1
XFILLER_18_339 VGND VGND VPWR VPWR sky130_fd_sc_hd__decap_3
XFILLER_58_486 VGND VGND VPWR VPWR sky130_fd_sc_hd__fill_1
XFILLER_73_434 VGND VGND VPWR VPWR sky130_fd_sc_hd__decap_3
XTAP_TAPCELL_ROW_86_1015 VGND VPWR sky130_fd_sc_hd__tapvpwrvgnd_1
XFILLER_85_294 VGND VGND VPWR VPWR sky130_fd_sc_hd__fill_1
XFILLER_73_478 VGND VGND VPWR VPWR sky130_fd_sc_hd__decap_3
XFILLER_14_523 VGND VGND VPWR VPWR sky130_fd_sc_hd__decap_3
XFILLER_60_106 VGND VGND VPWR VPWR sky130_fd_sc_hd__decap_3
XTAP_TAPCELL_ROW_84_996 VGND VPWR sky130_fd_sc_hd__tapvpwrvgnd_1
XFILLER_81_55 VGND VGND VPWR VPWR sky130_fd_sc_hd__fill_1
XFILLER_14_71 VGND VGND VPWR VPWR sky130_fd_sc_hd__decap_3
XFILLER_81_88 VGND VGND VPWR VPWR sky130_fd_sc_hd__decap_3
XFILLER_5_221 VGND VGND VPWR VPWR sky130_fd_sc_hd__decap_3
XFILLER_5_276 VGND VGND VPWR VPWR sky130_fd_sc_hd__decap_3
Xinput8 INSTR_STREAM[16] VGND VGND VPWR VPWR input8/X sky130_fd_sc_hd__clkdlybuf4s25_1
XFILLER_76_250 VGND VGND VPWR VPWR sky130_fd_sc_hd__fill_2
XFILLER_36_103 VGND VGND VPWR VPWR sky130_fd_sc_hd__decap_3
XFILLER_36_136 VGND VGND VPWR VPWR sky130_fd_sc_hd__decap_3
X_4950_ clkload8/A _4950_/D VGND VGND VPWR VPWR _4950_/Q sky130_fd_sc_hd__dfxtp_2
XTAP_TAPCELL_ROW_19_378 VGND VPWR sky130_fd_sc_hd__tapvpwrvgnd_1
XFILLER_91_297 VGND VGND VPWR VPWR sky130_fd_sc_hd__decap_3
X_4881_ _5105_/CLK _4881_/D VGND VGND VPWR VPWR _4881_/Q sky130_fd_sc_hd__dfxtp_2
X_3901_ _3867_/A _3905_/B _3956_/S _3900_/Y VGND VGND VPWR VPWR _3901_/X sky130_fd_sc_hd__a211o_2
XFILLER_20_515 VGND VGND VPWR VPWR sky130_fd_sc_hd__decap_3
XFILLER_32_342 VGND VGND VPWR VPWR sky130_fd_sc_hd__decap_3
X_3832_ _3824_/A _3779_/C _3824_/B _3831_/X VGND VGND VPWR VPWR _3832_/X sky130_fd_sc_hd__o31a_2
XFILLER_32_386 VGND VGND VPWR VPWR sky130_fd_sc_hd__decap_3
X_3763_ _5183_/Q _5181_/Q VGND VGND VPWR VPWR _3770_/B sky130_fd_sc_hd__nand2_2
X_3694_ _4896_/Q _4880_/Q _5104_/Q _5088_/Q _3706_/S0 _3706_/S1 VGND VGND VPWR VPWR
+ _3694_/X sky130_fd_sc_hd__mux4_2
X_2714_ _4887_/Q _4871_/Q _5095_/Q _5079_/Q _2851_/S0 _2854_/S1 VGND VGND VPWR VPWR
+ _2714_/X sky130_fd_sc_hd__mux4_2
X_2645_ _2645_/A _4602_/S VGND VGND VPWR VPWR _4125_/A sky130_fd_sc_hd__or2_2
X_4315_ _4314_/X _4313_/X _4486_/S VGND VGND VPWR VPWR _4316_/B sky130_fd_sc_hd__mux2_1
X_2576_ _2570_/X _2571_/X _2574_/X _2433_/Y VGND VGND VPWR VPWR _4318_/A sky130_fd_sc_hd__a22o_2
XFILLER_87_526 VGND VGND VPWR VPWR sky130_fd_sc_hd__decap_3
X_4246_ _4078_/B _4225_/A _3917_/X _4245_/X VGND VGND VPWR VPWR _4246_/X sky130_fd_sc_hd__o31a_2
X_4177_ _4166_/A _3885_/Y _4176_/X _4854_/B VGND VGND VPWR VPWR _4177_/X sky130_fd_sc_hd__a211o_2
XFILLER_27_103 VGND VGND VPWR VPWR sky130_fd_sc_hd__decap_3
XFILLER_67_272 VGND VGND VPWR VPWR sky130_fd_sc_hd__decap_3
X_3128_ _2921_/X _3121_/B _3121_/Y _5037_/Q VGND VGND VPWR VPWR _5037_/D sky130_fd_sc_hd__a22o_2
XTAP_TAPCELL_ROW_2_224 VGND VPWR sky130_fd_sc_hd__tapvpwrvgnd_1
XFILLER_27_147 VGND VGND VPWR VPWR sky130_fd_sc_hd__decap_3
XFILLER_55_445 VGND VGND VPWR VPWR sky130_fd_sc_hd__decap_3
XFILLER_82_253 VGND VGND VPWR VPWR sky130_fd_sc_hd__decap_3
XFILLER_82_231 VGND VGND VPWR VPWR sky130_fd_sc_hd__decap_3
XFILLER_35_26 VGND VGND VPWR VPWR sky130_fd_sc_hd__decap_3
XFILLER_55_478 VGND VGND VPWR VPWR sky130_fd_sc_hd__decap_3
XFILLER_70_415 VGND VGND VPWR VPWR sky130_fd_sc_hd__decap_3
X_3059_ _2934_/X _3048_/B _3048_/Y _4977_/Q VGND VGND VPWR VPWR _4977_/D sky130_fd_sc_hd__a22o_2
XFILLER_82_275 VGND VGND VPWR VPWR sky130_fd_sc_hd__decap_3
XFILLER_82_297 VGND VGND VPWR VPWR sky130_fd_sc_hd__decap_3
XFILLER_50_172 VGND VGND VPWR VPWR sky130_fd_sc_hd__decap_3
XFILLER_7_519 VGND VGND VPWR VPWR sky130_fd_sc_hd__decap_3
XTAP_TAPCELL_ROW_92_1074 VGND VPWR sky130_fd_sc_hd__tapvpwrvgnd_1
XFILLER_78_548 VGND VGND VPWR VPWR sky130_fd_sc_hd__decap_3
XFILLER_93_529 VGND VGND VPWR VPWR sky130_fd_sc_hd__decap_3
XFILLER_76_88 VGND VGND VPWR VPWR sky130_fd_sc_hd__decap_3
XFILLER_73_242 VGND VGND VPWR VPWR sky130_fd_sc_hd__decap_3
XFILLER_46_489 VGND VGND VPWR VPWR sky130_fd_sc_hd__decap_3
XFILLER_61_415 VGND VGND VPWR VPWR sky130_fd_sc_hd__decap_3
XFILLER_92_54 VGND VGND VPWR VPWR sky130_fd_sc_hd__decap_3
XFILLER_14_331 VGND VGND VPWR VPWR sky130_fd_sc_hd__decap_3
XFILLER_61_437 VGND VGND VPWR VPWR sky130_fd_sc_hd__decap_3
XTAP_TAPCELL_ROW_44_624 VGND VPWR sky130_fd_sc_hd__tapvpwrvgnd_1
XFILLER_25_81 VGND VGND VPWR VPWR sky130_fd_sc_hd__decap_3
XFILLER_6_530 VGND VGND VPWR VPWR sky130_fd_sc_hd__fill_2
X_2430_ _5134_/Q VGND VGND VPWR VPWR _2430_/Y sky130_fd_sc_hd__inv_2
X_4100_ _4099_/X _4047_/X _4266_/S VGND VGND VPWR VPWR _4101_/B sky130_fd_sc_hd__mux2_1
X_5080_ _5083_/CLK _5080_/D VGND VGND VPWR VPWR _5080_/Q sky130_fd_sc_hd__dfxtp_2
XFILLER_1_290 VGND VGND VPWR VPWR sky130_fd_sc_hd__fill_1
X_4031_ _4078_/B _4031_/B VGND VGND VPWR VPWR _4225_/B sky130_fd_sc_hd__or2_2
XFILLER_84_518 VGND VGND VPWR VPWR sky130_fd_sc_hd__decap_3
XFILLER_37_434 VGND VGND VPWR VPWR sky130_fd_sc_hd__decap_3
XFILLER_64_242 VGND VGND VPWR VPWR sky130_fd_sc_hd__decap_3
XFILLER_92_551 VGND VGND VPWR VPWR sky130_fd_sc_hd__decap_3
XFILLER_52_404 VGND VGND VPWR VPWR sky130_fd_sc_hd__decap_3
XFILLER_64_253 VGND VGND VPWR VPWR sky130_fd_sc_hd__decap_3
XFILLER_24_139 VGND VGND VPWR VPWR sky130_fd_sc_hd__fill_1
X_4933_ _5008_/CLK _4933_/D VGND VGND VPWR VPWR _4933_/Q sky130_fd_sc_hd__dfxtp_2
XFILLER_32_150 VGND VGND VPWR VPWR sky130_fd_sc_hd__decap_3
XFILLER_60_492 VGND VGND VPWR VPWR sky130_fd_sc_hd__decap_3
X_4864_ _5173_/Q _4868_/A2 _4870_/B1 _3233_/X VGND VGND VPWR VPWR _5173_/D sky130_fd_sc_hd__o22a_2
X_4795_ _4795_/A _4795_/B VGND VGND VPWR VPWR _4795_/Y sky130_fd_sc_hd__nor2_2
X_3815_ _3815_/A VGND VGND VPWR VPWR _3815_/Y sky130_fd_sc_hd__inv_2
X_3746_ _4062_/A _4090_/A VGND VGND VPWR VPWR _3746_/Y sky130_fd_sc_hd__nor2_2
X_3677_ _4631_/S _3677_/B VGND VGND VPWR VPWR _4166_/A sky130_fd_sc_hd__and2b_2
X_2628_ _2629_/A _2629_/B VGND VGND VPWR VPWR _3831_/A sky130_fd_sc_hd__and2_2
X_2559_ _5115_/Q _5003_/Q _4987_/Q _4971_/Q _5127_/Q _5128_/Q VGND VGND VPWR VPWR
+ _2559_/X sky130_fd_sc_hd__mux4_2
XFILLER_87_301 VGND VGND VPWR VPWR sky130_fd_sc_hd__decap_3
X_5278_ _5283_/CLK _5278_/D VGND VGND VPWR VPWR _5278_/Q sky130_fd_sc_hd__dfxtp_2
XFILLER_87_345 VGND VGND VPWR VPWR sky130_fd_sc_hd__decap_3
XFILLER_87_334 VGND VGND VPWR VPWR sky130_fd_sc_hd__fill_2
X_4229_ _3666_/A _4261_/C _4214_/Y _4228_/Y VGND VGND VPWR VPWR _4229_/Y sky130_fd_sc_hd__o31ai_2
XTAP_TAPCELL_ROW_58_749 VGND VPWR sky130_fd_sc_hd__tapvpwrvgnd_1
XFILLER_87_389 VGND VGND VPWR VPWR sky130_fd_sc_hd__decap_3
XFILLER_28_467 VGND VGND VPWR VPWR sky130_fd_sc_hd__fill_2
XFILLER_55_231 VGND VGND VPWR VPWR sky130_fd_sc_hd__decap_3
XFILLER_28_489 VGND VGND VPWR VPWR sky130_fd_sc_hd__fill_1
XFILLER_55_286 VGND VGND VPWR VPWR sky130_fd_sc_hd__decap_3
XFILLER_15_128 VGND VGND VPWR VPWR sky130_fd_sc_hd__decap_3
XFILLER_70_278 VGND VGND VPWR VPWR sky130_fd_sc_hd__decap_3
XFILLER_23_150 VGND VGND VPWR VPWR sky130_fd_sc_hd__fill_1
XFILLER_23_172 VGND VGND VPWR VPWR sky130_fd_sc_hd__decap_3
XTAP_TAPCELL_ROW_13_329 VGND VPWR sky130_fd_sc_hd__tapvpwrvgnd_1
XFILLER_23_194 VGND VGND VPWR VPWR sky130_fd_sc_hd__fill_1
XFILLER_7_316 VGND VGND VPWR VPWR sky130_fd_sc_hd__decap_3
XFILLER_3_511 VGND VGND VPWR VPWR sky130_fd_sc_hd__decap_3
XFILLER_11_94 VGND VGND VPWR VPWR sky130_fd_sc_hd__fill_1
XFILLER_3_544 VGND VGND VPWR VPWR sky130_fd_sc_hd__decap_3
XFILLER_78_312 VGND VGND VPWR VPWR sky130_fd_sc_hd__decap_3
XFILLER_66_529 VGND VGND VPWR VPWR sky130_fd_sc_hd__decap_3
XFILLER_78_389 VGND VGND VPWR VPWR sky130_fd_sc_hd__fill_1
XFILLER_19_489 VGND VGND VPWR VPWR sky130_fd_sc_hd__decap_3
XFILLER_34_404 VGND VGND VPWR VPWR sky130_fd_sc_hd__decap_3
XFILLER_34_448 VGND VGND VPWR VPWR sky130_fd_sc_hd__decap_3
XFILLER_36_91 VGND VGND VPWR VPWR sky130_fd_sc_hd__fill_1
XFILLER_61_234 VGND VGND VPWR VPWR sky130_fd_sc_hd__decap_3
XTAP_TAPCELL_ROW_29_473 VGND VPWR sky130_fd_sc_hd__tapvpwrvgnd_1
XFILLER_21_109 VGND VGND VPWR VPWR sky130_fd_sc_hd__decap_3
XFILLER_61_256 VGND VGND VPWR VPWR sky130_fd_sc_hd__decap_3
XFILLER_14_194 VGND VGND VPWR VPWR sky130_fd_sc_hd__fill_2
XFILLER_42_492 VGND VGND VPWR VPWR sky130_fd_sc_hd__decap_3
X_4580_ _3567_/S _2630_/B _3778_/D _2531_/Y _4579_/Y VGND VGND VPWR VPWR _4580_/X
+ sky130_fd_sc_hd__o221a_2
Xinput22 INSTR_STREAM[29] VGND VGND VPWR VPWR _3350_/C sky130_fd_sc_hd__clkdlybuf4s25_1
Xinput11 INSTR_STREAM[19] VGND VGND VPWR VPWR _3237_/C sky130_fd_sc_hd__clkdlybuf4s25_1
X_3600_ _3600_/A _3792_/B VGND VGND VPWR VPWR _3601_/B sky130_fd_sc_hd__and2_2
Xinput44 MEM_LD_DATA[5] VGND VGND VPWR VPWR input44/X sky130_fd_sc_hd__clkdlybuf4s25_1
Xinput33 MEM_LD_DATA[0] VGND VGND VPWR VPWR input33/X sky130_fd_sc_hd__clkdlybuf4s25_1
X_3531_ _3529_/X _3530_/X _5133_/Q VGND VGND VPWR VPWR _3531_/X sky130_fd_sc_hd__mux2_1
X_3462_ _3472_/A _3462_/B VGND VGND VPWR VPWR _3462_/Y sky130_fd_sc_hd__nand2b_2
X_5201_ _5251_/CLK _5201_/D VGND VGND VPWR VPWR _5201_/Q sky130_fd_sc_hd__dfxtp_2
X_3393_ _3393_/A _3393_/B _3393_/C VGND VGND VPWR VPWR _3394_/A sky130_fd_sc_hd__and3_2
X_5132_ clkload4/A _5132_/D VGND VGND VPWR VPWR _5132_/Q sky130_fd_sc_hd__dfxtp_4
X_5063_ _5105_/CLK _5063_/D VGND VGND VPWR VPWR _5063_/Q sky130_fd_sc_hd__dfxtp_2
XFILLER_37_242 VGND VGND VPWR VPWR sky130_fd_sc_hd__fill_2
XFILLER_65_551 VGND VGND VPWR VPWR sky130_fd_sc_hd__decap_3
X_4014_ _5214_/Q _4275_/B _4013_/X _3366_/A VGND VGND VPWR VPWR _5214_/D sky130_fd_sc_hd__o211a_2
XFILLER_84_348 VGND VGND VPWR VPWR sky130_fd_sc_hd__decap_3
XFILLER_37_275 VGND VGND VPWR VPWR sky130_fd_sc_hd__decap_3
XFILLER_80_510 VGND VGND VPWR VPWR sky130_fd_sc_hd__decap_3
XFILLER_25_437 VGND VGND VPWR VPWR sky130_fd_sc_hd__decap_3
XFILLER_52_234 VGND VGND VPWR VPWR sky130_fd_sc_hd__decap_3
XFILLER_40_418 VGND VGND VPWR VPWR sky130_fd_sc_hd__fill_2
XFILLER_80_554 VGND VGND VPWR VPWR sky130_fd_sc_hd__decap_3
XFILLER_40_429 VGND VGND VPWR VPWR sky130_fd_sc_hd__decap_3
X_4916_ _5008_/CLK _4916_/D VGND VGND VPWR VPWR _4916_/Q sky130_fd_sc_hd__dfxtp_2
XTAP_TAPCELL_ROW_63_796 VGND VPWR sky130_fd_sc_hd__tapvpwrvgnd_1
XFILLER_32_27 VGND VGND VPWR VPWR sky130_fd_sc_hd__fill_1
XFILLER_32_38 VGND VGND VPWR VPWR sky130_fd_sc_hd__decap_3
X_4847_ _4847_/A _4847_/B VGND VGND VPWR VPWR _4847_/Y sky130_fd_sc_hd__nand2_2
XFILLER_20_164 VGND VGND VPWR VPWR sky130_fd_sc_hd__decap_3
XFILLER_20_197 VGND VGND VPWR VPWR sky130_fd_sc_hd__decap_3
X_4778_ _4776_/X _4778_/B VGND VGND VPWR VPWR _4780_/A sky130_fd_sc_hd__and2b_2
X_3729_ _5133_/Q _3729_/B VGND VGND VPWR VPWR _3729_/X sky130_fd_sc_hd__or2_2
XFILLER_0_503 VGND VGND VPWR VPWR sky130_fd_sc_hd__fill_1
XFILLER_0_514 VGND VGND VPWR VPWR sky130_fd_sc_hd__decap_3
XFILLER_0_536 VGND VGND VPWR VPWR sky130_fd_sc_hd__decap_3
XFILLER_48_507 VGND VGND VPWR VPWR sky130_fd_sc_hd__decap_3
XFILLER_87_131 VGND VGND VPWR VPWR sky130_fd_sc_hd__decap_3
XFILLER_57_57 VGND VGND VPWR VPWR sky130_fd_sc_hd__decap_3
XFILLER_75_326 VGND VGND VPWR VPWR sky130_fd_sc_hd__decap_3
XFILLER_75_337 VGND VGND VPWR VPWR sky130_fd_sc_hd__decap_3
XFILLER_87_164 VGND VGND VPWR VPWR sky130_fd_sc_hd__decap_3
XFILLER_56_540 VGND VGND VPWR VPWR sky130_fd_sc_hd__decap_3
XFILLER_28_253 VGND VGND VPWR VPWR sky130_fd_sc_hd__decap_3
XFILLER_28_297 VGND VGND VPWR VPWR sky130_fd_sc_hd__decap_3
XFILLER_43_212 VGND VGND VPWR VPWR sky130_fd_sc_hd__decap_3
XFILLER_43_245 VGND VGND VPWR VPWR sky130_fd_sc_hd__fill_1
XFILLER_71_554 VGND VGND VPWR VPWR sky130_fd_sc_hd__decap_3
XFILLER_31_429 VGND VGND VPWR VPWR sky130_fd_sc_hd__fill_2
XFILLER_7_113 VGND VGND VPWR VPWR sky130_fd_sc_hd__decap_3
XFILLER_11_186 VGND VGND VPWR VPWR sky130_fd_sc_hd__decap_3
XFILLER_22_93 VGND VGND VPWR VPWR sky130_fd_sc_hd__fill_1
XFILLER_3_396 VGND VGND VPWR VPWR sky130_fd_sc_hd__fill_1
XFILLER_39_518 VGND VGND VPWR VPWR sky130_fd_sc_hd__decap_3
XFILLER_66_304 VGND VGND VPWR VPWR sky130_fd_sc_hd__decap_3
XFILLER_66_315 VGND VGND VPWR VPWR sky130_fd_sc_hd__decap_3
XFILLER_14_6 VGND VGND VPWR VPWR sky130_fd_sc_hd__decap_3
XFILLER_78_197 VGND VGND VPWR VPWR sky130_fd_sc_hd__decap_3
XFILLER_19_253 VGND VGND VPWR VPWR sky130_fd_sc_hd__fill_2
XFILLER_19_286 VGND VGND VPWR VPWR sky130_fd_sc_hd__fill_1
XFILLER_62_521 VGND VGND VPWR VPWR sky130_fd_sc_hd__decap_3
XFILLER_74_392 VGND VGND VPWR VPWR sky130_fd_sc_hd__decap_3
XFILLER_34_256 VGND VGND VPWR VPWR sky130_fd_sc_hd__decap_3
X_2962_ _2924_/X _2970_/A2 _2954_/Y _4894_/Q VGND VGND VPWR VPWR _4894_/D sky130_fd_sc_hd__a22o_2
X_4701_ _5245_/Q _4725_/B VGND VGND VPWR VPWR _4701_/X sky130_fd_sc_hd__or2_2
XFILLER_30_451 VGND VGND VPWR VPWR sky130_fd_sc_hd__decap_3
X_4632_ _3747_/A _3677_/B _3778_/D _2670_/A _4631_/X VGND VGND VPWR VPWR _4632_/X
+ sky130_fd_sc_hd__o221a_2
X_2893_ _2889_/C _3842_/A _2691_/Y _2495_/Y _2693_/B VGND VGND VPWR VPWR _4236_/C
+ sky130_fd_sc_hd__o2111ai_2
XFILLER_30_495 VGND VGND VPWR VPWR sky130_fd_sc_hd__decap_3
XFILLER_8_73 VGND VGND VPWR VPWR sky130_fd_sc_hd__decap_3
X_4563_ _4437_/X _4666_/C _4562_/X _4055_/C VGND VGND VPWR VPWR _4567_/B sky130_fd_sc_hd__o211a_2
X_4494_ _4458_/A _4458_/B _4459_/Y VGND VGND VPWR VPWR _4522_/B sky130_fd_sc_hd__o21a_2
X_3514_ _3509_/X _3510_/X _3513_/X _2430_/Y VGND VGND VPWR VPWR _4281_/A sky130_fd_sc_hd__a22o_2
XFILLER_6_190 VGND VGND VPWR VPWR sky130_fd_sc_hd__decap_3
X_3445_ _5165_/Q _5146_/Q VGND VGND VPWR VPWR _3446_/B sky130_fd_sc_hd__nand2_2
XFILLER_89_407 VGND VGND VPWR VPWR sky130_fd_sc_hd__decap_3
XFILLER_69_153 VGND VGND VPWR VPWR sky130_fd_sc_hd__decap_3
X_3376_ _5192_/Q _4275_/B _3375_/X _3366_/A VGND VGND VPWR VPWR _5192_/D sky130_fd_sc_hd__o211a_2
XFILLER_57_315 VGND VGND VPWR VPWR sky130_fd_sc_hd__decap_3
X_5115_ clkload9/A _5115_/D VGND VGND VPWR VPWR _5115_/Q sky130_fd_sc_hd__dfxtp_2
XFILLER_57_337 VGND VGND VPWR VPWR sky130_fd_sc_hd__decap_3
X_5046_ _5107_/CLK _5046_/D VGND VGND VPWR VPWR _5046_/Q sky130_fd_sc_hd__dfxtp_2
XTAP_TAPCELL_ROW_68_844 VGND VPWR sky130_fd_sc_hd__tapvpwrvgnd_1
XFILLER_53_521 VGND VGND VPWR VPWR sky130_fd_sc_hd__decap_3
XFILLER_65_370 VGND VGND VPWR VPWR sky130_fd_sc_hd__decap_3
XFILLER_13_407 VGND VGND VPWR VPWR sky130_fd_sc_hd__decap_3
XFILLER_53_554 VGND VGND VPWR VPWR sky130_fd_sc_hd__decap_3
XFILLER_80_351 VGND VGND VPWR VPWR sky130_fd_sc_hd__decap_3
XFILLER_80_395 VGND VGND VPWR VPWR sky130_fd_sc_hd__decap_3
XFILLER_80_373 VGND VGND VPWR VPWR sky130_fd_sc_hd__decap_3
XTAP_TAPCELL_ROW_23_424 VGND VPWR sky130_fd_sc_hd__tapvpwrvgnd_1
XFILLER_21_473 VGND VGND VPWR VPWR sky130_fd_sc_hd__decap_3
XFILLER_68_45 VGND VGND VPWR VPWR sky130_fd_sc_hd__fill_1
XFILLER_0_333 VGND VGND VPWR VPWR sky130_fd_sc_hd__decap_3
XFILLER_88_451 VGND VGND VPWR VPWR sky130_fd_sc_hd__decap_3
XFILLER_0_388 VGND VGND VPWR VPWR sky130_fd_sc_hd__decap_3
XFILLER_48_315 VGND VGND VPWR VPWR sky130_fd_sc_hd__decap_3
XFILLER_0_399 VGND VGND VPWR VPWR sky130_fd_sc_hd__decap_3
XFILLER_29_540 VGND VGND VPWR VPWR sky130_fd_sc_hd__fill_1
XTAP_TAPCELL_ROW_89_1046 VGND VPWR sky130_fd_sc_hd__tapvpwrvgnd_1
XFILLER_29_551 VGND VGND VPWR VPWR sky130_fd_sc_hd__decap_3
XFILLER_75_167 VGND VGND VPWR VPWR sky130_fd_sc_hd__fill_1
XFILLER_16_212 VGND VGND VPWR VPWR sky130_fd_sc_hd__decap_3
XFILLER_56_381 VGND VGND VPWR VPWR sky130_fd_sc_hd__decap_3
XFILLER_56_392 VGND VGND VPWR VPWR sky130_fd_sc_hd__decap_3
XFILLER_84_77 VGND VGND VPWR VPWR sky130_fd_sc_hd__decap_3
XFILLER_84_66 VGND VGND VPWR VPWR sky130_fd_sc_hd__fill_1
XFILLER_16_256 VGND VGND VPWR VPWR sky130_fd_sc_hd__decap_3
XFILLER_17_71 VGND VGND VPWR VPWR sky130_fd_sc_hd__decap_3
XFILLER_44_554 VGND VGND VPWR VPWR sky130_fd_sc_hd__decap_3
XFILLER_71_340 VGND VGND VPWR VPWR sky130_fd_sc_hd__decap_3
XFILLER_90_159 VGND VGND VPWR VPWR sky130_fd_sc_hd__fill_2
XFILLER_71_373 VGND VGND VPWR VPWR sky130_fd_sc_hd__decap_3
XFILLER_31_237 VGND VGND VPWR VPWR sky130_fd_sc_hd__decap_3
XFILLER_31_248 VGND VGND VPWR VPWR sky130_fd_sc_hd__decap_3
XFILLER_33_70 VGND VGND VPWR VPWR sky130_fd_sc_hd__decap_3
XFILLER_83_9 VGND VGND VPWR VPWR sky130_fd_sc_hd__decap_3
X_3230_ _3494_/A _3230_/B VGND VGND VPWR VPWR _3230_/Y sky130_fd_sc_hd__nor2_4
X_3161_ _2911_/X _3173_/A2 _3157_/Y _5066_/Q VGND VGND VPWR VPWR _5066_/D sky130_fd_sc_hd__a22o_2
XFILLER_12_3 VGND VGND VPWR VPWR sky130_fd_sc_hd__decap_3
XFILLER_39_337 VGND VGND VPWR VPWR sky130_fd_sc_hd__decap_3
XFILLER_54_307 VGND VGND VPWR VPWR sky130_fd_sc_hd__fill_1
X_3092_ _2924_/X _3100_/A2 _3084_/Y _5006_/Q VGND VGND VPWR VPWR _5006_/D sky130_fd_sc_hd__a22o_2
XFILLER_54_329 VGND VGND VPWR VPWR sky130_fd_sc_hd__decap_3
XFILLER_66_189 VGND VGND VPWR VPWR sky130_fd_sc_hd__decap_3
XTAP_TAPCELL_ROW_37_549 VGND VPWR sky130_fd_sc_hd__tapvpwrvgnd_1
XFILLER_81_159 VGND VGND VPWR VPWR sky130_fd_sc_hd__decap_3
XFILLER_22_215 VGND VGND VPWR VPWR sky130_fd_sc_hd__decap_3
XFILLER_50_502 VGND VGND VPWR VPWR sky130_fd_sc_hd__decap_3
XFILLER_62_362 VGND VGND VPWR VPWR sky130_fd_sc_hd__fill_2
XFILLER_62_384 VGND VGND VPWR VPWR sky130_fd_sc_hd__decap_3
XFILLER_22_248 VGND VGND VPWR VPWR sky130_fd_sc_hd__decap_3
XFILLER_22_259 VGND VGND VPWR VPWR sky130_fd_sc_hd__decap_3
XFILLER_50_546 VGND VGND VPWR VPWR sky130_fd_sc_hd__decap_3
X_3994_ _3993_/X _3762_/B _4267_/S VGND VGND VPWR VPWR _3994_/X sky130_fd_sc_hd__mux2_1
XTAP_TAPCELL_ROW_73_891 VGND VPWR sky130_fd_sc_hd__tapvpwrvgnd_1
XFILLER_13_29 VGND VGND VPWR VPWR sky130_fd_sc_hd__decap_3
X_2945_ _4884_/Q _2902_/Y _2944_/X _2902_/B VGND VGND VPWR VPWR _4884_/D sky130_fd_sc_hd__a22o_2
XFILLER_30_270 VGND VGND VPWR VPWR sky130_fd_sc_hd__fill_1
X_2876_ _2887_/A _2876_/B VGND VGND VPWR VPWR _2876_/Y sky130_fd_sc_hd__nor2_2
XFILLER_30_292 VGND VGND VPWR VPWR sky130_fd_sc_hd__decap_3
X_4615_ _4614_/X _4557_/X _4682_/S VGND VGND VPWR VPWR _4615_/X sky130_fd_sc_hd__mux2_1
X_4546_ _4191_/A _2624_/B _3778_/D _2624_/A VGND VGND VPWR VPWR _4546_/X sky130_fd_sc_hd__o22a_2
Xmax_cap152 _3828_/B VGND VGND VPWR VPWR _4346_/B sky130_fd_sc_hd__buf_4
Xmax_cap141 _3139_/B VGND VGND VPWR VPWR _3155_/A2 sky130_fd_sc_hd__buf_6
Xmax_cap130 _3047_/Y VGND VGND VPWR VPWR _3048_/B sky130_fd_sc_hd__clkbuf_8
X_4477_ _4327_/A _4326_/Y _4333_/B VGND VGND VPWR VPWR _4477_/Y sky130_fd_sc_hd__a21oi_2
Xmax_cap174 _5133_/Q VGND VGND VPWR VPWR _3705_/A sky130_fd_sc_hd__buf_6
Xmax_cap185 _3494_/A VGND VGND VPWR VPWR _4692_/A sky130_fd_sc_hd__buf_12
X_3428_ _5163_/Q _5144_/Q VGND VGND VPWR VPWR _3432_/A sky130_fd_sc_hd__nand2_2
XFILLER_89_259 VGND VGND VPWR VPWR sky130_fd_sc_hd__decap_3
X_3359_ _5178_/Q _5177_/Q _5176_/Q _3357_/X VGND VGND VPWR VPWR _3359_/X sky130_fd_sc_hd__o31a_2
XFILLER_72_115 VGND VGND VPWR VPWR sky130_fd_sc_hd__decap_3
X_5029_ _5233_/CLK _5029_/D VGND VGND VPWR VPWR _5029_/Q sky130_fd_sc_hd__dfxtp_2
XFILLER_26_554 VGND VGND VPWR VPWR sky130_fd_sc_hd__decap_3
XFILLER_38_392 VGND VGND VPWR VPWR sky130_fd_sc_hd__fill_1
XFILLER_54_25 VGND VGND VPWR VPWR sky130_fd_sc_hd__decap_3
XFILLER_53_384 VGND VGND VPWR VPWR sky130_fd_sc_hd__decap_3
XFILLER_54_69 VGND VGND VPWR VPWR sky130_fd_sc_hd__fill_1
XTAP_TAPCELL_ROW_0_196 VGND VPWR sky130_fd_sc_hd__tapvpwrvgnd_1
XFILLER_70_35 VGND VGND VPWR VPWR sky130_fd_sc_hd__decap_3
XFILLER_21_281 VGND VGND VPWR VPWR sky130_fd_sc_hd__decap_3
XFILLER_5_414 VGND VGND VPWR VPWR sky130_fd_sc_hd__decap_3
XFILLER_5_447 VGND VGND VPWR VPWR sky130_fd_sc_hd__fill_1
XFILLER_5_458 VGND VGND VPWR VPWR sky130_fd_sc_hd__decap_3
XFILLER_79_22 VGND VGND VPWR VPWR sky130_fd_sc_hd__decap_3
XFILLER_0_141 VGND VGND VPWR VPWR sky130_fd_sc_hd__decap_3
XTAP_TAPCELL_ROW_8_274 VGND VPWR sky130_fd_sc_hd__tapvpwrvgnd_1
XFILLER_76_410 VGND VGND VPWR VPWR sky130_fd_sc_hd__decap_3
XFILLER_48_112 VGND VGND VPWR VPWR sky130_fd_sc_hd__decap_3
XFILLER_76_421 VGND VGND VPWR VPWR sky130_fd_sc_hd__decap_3
XFILLER_48_156 VGND VGND VPWR VPWR sky130_fd_sc_hd__decap_3
XFILLER_76_465 VGND VGND VPWR VPWR sky130_fd_sc_hd__decap_3
XFILLER_17_521 VGND VGND VPWR VPWR sky130_fd_sc_hd__decap_3
XFILLER_29_381 VGND VGND VPWR VPWR sky130_fd_sc_hd__decap_3
XFILLER_76_498 VGND VGND VPWR VPWR sky130_fd_sc_hd__fill_2
XFILLER_32_513 VGND VGND VPWR VPWR sky130_fd_sc_hd__decap_3
X_2730_ _5138_/Q _2725_/X _2727_/X _2729_/X VGND VGND VPWR VPWR _4732_/B sky130_fd_sc_hd__a22o_2
XTAP_TAPCELL_ROW_42_596 VGND VPWR sky130_fd_sc_hd__tapvpwrvgnd_1
XFILLER_81_6 VGND VGND VPWR VPWR sky130_fd_sc_hd__decap_3
X_2661_ _2677_/S _2658_/X _5130_/Q VGND VGND VPWR VPWR _2661_/X sky130_fd_sc_hd__o21a_2
X_4400_ _4398_/X _4399_/X _4458_/B VGND VGND VPWR VPWR _4402_/B sky130_fd_sc_hd__o21ai_2
X_2592_ _5064_/Q _5048_/Q _5032_/Q _5016_/Q _2672_/S0 _2672_/S1 VGND VGND VPWR VPWR
+ _2592_/X sky130_fd_sc_hd__mux4_2
X_4331_ _4397_/A _4397_/B VGND VGND VPWR VPWR _4331_/Y sky130_fd_sc_hd__nor2_2
XFILLER_4_491 VGND VGND VPWR VPWR sky130_fd_sc_hd__decap_3
X_4262_ _3848_/A _3848_/B _4686_/B1 VGND VGND VPWR VPWR _4262_/X sky130_fd_sc_hd__a21o_2
X_3213_ _2905_/X _3227_/A2 _3211_/Y _5112_/Q VGND VGND VPWR VPWR _5112_/D sky130_fd_sc_hd__a22o_2
XFILLER_67_432 VGND VGND VPWR VPWR sky130_fd_sc_hd__decap_3
X_4193_ _3642_/A _4397_/C _4449_/S VGND VGND VPWR VPWR _4193_/X sky130_fd_sc_hd__mux2_1
XFILLER_79_281 VGND VGND VPWR VPWR sky130_fd_sc_hd__decap_3
X_3144_ _2914_/X _3155_/A2 _3139_/Y _5051_/Q VGND VGND VPWR VPWR _5051_/D sky130_fd_sc_hd__a22o_2
XPHY_EDGE_ROW_19_Left_113 VGND VGND VPWR VPWR sky130_fd_sc_hd__decap_3
XFILLER_54_115 VGND VGND VPWR VPWR sky130_fd_sc_hd__decap_3
X_3075_ _2927_/X _3065_/Y _3066_/Y _4991_/Q VGND VGND VPWR VPWR _4991_/D sky130_fd_sc_hd__a22o_2
XFILLER_82_424 VGND VGND VPWR VPWR sky130_fd_sc_hd__decap_3
XFILLER_35_340 VGND VGND VPWR VPWR sky130_fd_sc_hd__decap_3
XFILLER_23_535 VGND VGND VPWR VPWR sky130_fd_sc_hd__fill_2
XFILLER_23_557 VGND VGND VPWR VPWR sky130_fd_sc_hd__fill_1
XFILLER_62_181 VGND VGND VPWR VPWR sky130_fd_sc_hd__decap_3
XFILLER_10_207 VGND VGND VPWR VPWR sky130_fd_sc_hd__decap_3
XFILLER_50_354 VGND VGND VPWR VPWR sky130_fd_sc_hd__decap_3
X_3977_ _3977_/A _4021_/B VGND VGND VPWR VPWR _4509_/A sky130_fd_sc_hd__or2_2
XFILLER_50_398 VGND VGND VPWR VPWR sky130_fd_sc_hd__decap_3
X_2928_ _4879_/Q _2942_/A2 _2927_/X _2902_/B VGND VGND VPWR VPWR _4879_/D sky130_fd_sc_hd__a22o_2
XPHY_EDGE_ROW_28_Left_122 VGND VGND VPWR VPWR sky130_fd_sc_hd__decap_3
XFILLER_40_27 VGND VGND VPWR VPWR sky130_fd_sc_hd__fill_1
X_2859_ _2860_/A _2860_/B VGND VGND VPWR VPWR _3779_/B sky130_fd_sc_hd__nor2_2
X_4529_ _3363_/A _4213_/A _4529_/S VGND VGND VPWR VPWR _4529_/X sky130_fd_sc_hd__mux2_1
XFILLER_49_25 VGND VGND VPWR VPWR sky130_fd_sc_hd__fill_1
XFILLER_58_421 VGND VGND VPWR VPWR sky130_fd_sc_hd__decap_3
XPHY_EDGE_ROW_37_Left_131 VGND VGND VPWR VPWR sky130_fd_sc_hd__decap_3
XFILLER_73_402 VGND VGND VPWR VPWR sky130_fd_sc_hd__decap_3
XFILLER_58_498 VGND VGND VPWR VPWR sky130_fd_sc_hd__decap_3
XFILLER_65_57 VGND VGND VPWR VPWR sky130_fd_sc_hd__fill_1
XTAP_TAPCELL_ROW_86_1016 VGND VPWR sky130_fd_sc_hd__tapvpwrvgnd_1
XFILLER_73_446 VGND VGND VPWR VPWR sky130_fd_sc_hd__fill_2
XTAP_TAPCELL_ROW_84_997 VGND VPWR sky130_fd_sc_hd__tapvpwrvgnd_1
XPHY_EDGE_ROW_46_Left_140 VGND VGND VPWR VPWR sky130_fd_sc_hd__decap_3
XFILLER_14_50 VGND VGND VPWR VPWR sky130_fd_sc_hd__decap_3
XFILLER_14_83 VGND VGND VPWR VPWR sky130_fd_sc_hd__fill_1
XFILLER_14_94 VGND VGND VPWR VPWR sky130_fd_sc_hd__decap_3
XFILLER_5_255 VGND VGND VPWR VPWR sky130_fd_sc_hd__fill_1
XFILLER_5_299 VGND VGND VPWR VPWR sky130_fd_sc_hd__decap_3
XFILLER_1_494 VGND VGND VPWR VPWR sky130_fd_sc_hd__decap_3
XFILLER_64_413 VGND VGND VPWR VPWR sky130_fd_sc_hd__decap_3
XFILLER_64_424 VGND VGND VPWR VPWR sky130_fd_sc_hd__decap_3
XFILLER_64_435 VGND VGND VPWR VPWR sky130_fd_sc_hd__decap_3
Xinput9 INSTR_STREAM[17] VGND VGND VPWR VPWR input9/X sky130_fd_sc_hd__clkdlybuf4s25_1
XFILLER_17_340 VGND VGND VPWR VPWR sky130_fd_sc_hd__decap_3
XTAP_TAPCELL_ROW_47_644 VGND VPWR sky130_fd_sc_hd__tapvpwrvgnd_1
XTAP_TAPCELL_ROW_19_379 VGND VPWR sky130_fd_sc_hd__tapvpwrvgnd_1
X_4880_ _5109_/CLK _4880_/D VGND VGND VPWR VPWR _4880_/Q sky130_fd_sc_hd__dfxtp_2
X_3900_ _4320_/A _3905_/B VGND VGND VPWR VPWR _3900_/Y sky130_fd_sc_hd__nor2_2
XFILLER_32_365 VGND VGND VPWR VPWR sky130_fd_sc_hd__decap_3
X_3831_ _3831_/A _4086_/A _3830_/X VGND VGND VPWR VPWR _3831_/X sky130_fd_sc_hd__or3b_2
XFILLER_32_398 VGND VGND VPWR VPWR sky130_fd_sc_hd__decap_3
X_3762_ _4051_/A _3762_/B _4267_/S VGND VGND VPWR VPWR _4345_/A sky130_fd_sc_hd__or3_2
X_3693_ _3693_/A _3693_/B VGND VGND VPWR VPWR _3693_/X sky130_fd_sc_hd__or2_2
X_2713_ _3567_/S _4191_/A _2873_/A VGND VGND VPWR VPWR _2713_/Y sky130_fd_sc_hd__a21oi_2
X_2644_ _2645_/A _4602_/S VGND VGND VPWR VPWR _3776_/A sky130_fd_sc_hd__nor2_2
X_2575_ _2570_/X _2571_/X _2574_/X _2433_/Y VGND VGND VPWR VPWR _3741_/A sky130_fd_sc_hd__a22oi_2
X_4314_ _4320_/B _4313_/S _3938_/Y VGND VGND VPWR VPWR _4314_/X sky130_fd_sc_hd__o21a_2
XFILLER_87_505 VGND VGND VPWR VPWR sky130_fd_sc_hd__decap_3
X_4245_ _3755_/Y _4244_/X _4224_/B _4051_/B VGND VGND VPWR VPWR _4245_/X sky130_fd_sc_hd__o2bb2a_2
XFILLER_67_240 VGND VGND VPWR VPWR sky130_fd_sc_hd__decap_3
X_4176_ _2670_/A _3764_/X _3767_/Y _3677_/B VGND VGND VPWR VPWR _4176_/X sky130_fd_sc_hd__a22o_2
XFILLER_55_402 VGND VGND VPWR VPWR sky130_fd_sc_hd__fill_1
XFILLER_55_413 VGND VGND VPWR VPWR sky130_fd_sc_hd__decap_3
XFILLER_67_284 VGND VGND VPWR VPWR sky130_fd_sc_hd__decap_3
X_3127_ _2918_/X _3121_/B _3121_/Y _5036_/Q VGND VGND VPWR VPWR _5036_/D sky130_fd_sc_hd__a22o_2
XTAP_TAPCELL_ROW_2_225 VGND VPWR sky130_fd_sc_hd__tapvpwrvgnd_1
XFILLER_42_118 VGND VGND VPWR VPWR sky130_fd_sc_hd__decap_3
XFILLER_70_405 VGND VGND VPWR VPWR sky130_fd_sc_hd__fill_2
XFILLER_70_427 VGND VGND VPWR VPWR sky130_fd_sc_hd__decap_3
X_3058_ _2931_/X _3048_/B _3048_/Y _4976_/Q VGND VGND VPWR VPWR _4976_/D sky130_fd_sc_hd__a22o_2
XTAP_TAPCELL_ROW_81_967 VGND VPWR sky130_fd_sc_hd__tapvpwrvgnd_1
XFILLER_11_516 VGND VGND VPWR VPWR sky130_fd_sc_hd__fill_2
XFILLER_50_184 VGND VGND VPWR VPWR sky130_fd_sc_hd__decap_3
XFILLER_51_37 VGND VGND VPWR VPWR sky130_fd_sc_hd__decap_3
XFILLER_2_203 VGND VGND VPWR VPWR sky130_fd_sc_hd__fill_1
XFILLER_2_247 VGND VGND VPWR VPWR sky130_fd_sc_hd__decap_3
XTAP_TAPCELL_ROW_92_1075 VGND VPWR sky130_fd_sc_hd__tapvpwrvgnd_1
XFILLER_78_516 VGND VGND VPWR VPWR sky130_fd_sc_hd__decap_3
XFILLER_76_12 VGND VGND VPWR VPWR sky130_fd_sc_hd__decap_3
XFILLER_93_508 VGND VGND VPWR VPWR sky130_fd_sc_hd__decap_3
XFILLER_76_45 VGND VGND VPWR VPWR sky130_fd_sc_hd__decap_3
XFILLER_46_424 VGND VGND VPWR VPWR sky130_fd_sc_hd__decap_3
XFILLER_58_262 VGND VGND VPWR VPWR sky130_fd_sc_hd__decap_3
XFILLER_18_159 VGND VGND VPWR VPWR sky130_fd_sc_hd__fill_2
XFILLER_61_405 VGND VGND VPWR VPWR sky130_fd_sc_hd__decap_3
XFILLER_61_449 VGND VGND VPWR VPWR sky130_fd_sc_hd__decap_3
XFILLER_92_88 VGND VGND VPWR VPWR sky130_fd_sc_hd__decap_3
XFILLER_92_66 VGND VGND VPWR VPWR sky130_fd_sc_hd__fill_1
XFILLER_25_60 VGND VGND VPWR VPWR sky130_fd_sc_hd__decap_3
XTAP_TAPCELL_ROW_16_349 VGND VPWR sky130_fd_sc_hd__tapvpwrvgnd_1
XFILLER_14_387 VGND VGND VPWR VPWR sky130_fd_sc_hd__decap_3
XFILLER_25_93 VGND VGND VPWR VPWR sky130_fd_sc_hd__fill_2
XTAP_TAPCELL_ROW_52_691 VGND VPWR sky130_fd_sc_hd__tapvpwrvgnd_1
XFILLER_44_6 VGND VGND VPWR VPWR sky130_fd_sc_hd__decap_3
XFILLER_69_505 VGND VGND VPWR VPWR sky130_fd_sc_hd__decap_3
XFILLER_49_251 VGND VGND VPWR VPWR sky130_fd_sc_hd__decap_3
X_4030_ _4029_/X _4132_/B _4267_/S VGND VGND VPWR VPWR _4224_/A sky130_fd_sc_hd__mux2_1
XPHY_EDGE_ROW_10_Right_10 VGND VGND VPWR VPWR sky130_fd_sc_hd__decap_3
XFILLER_37_402 VGND VGND VPWR VPWR sky130_fd_sc_hd__decap_3
XFILLER_49_284 VGND VGND VPWR VPWR sky130_fd_sc_hd__decap_3
XFILLER_92_530 VGND VGND VPWR VPWR sky130_fd_sc_hd__fill_2
XFILLER_37_468 VGND VGND VPWR VPWR sky130_fd_sc_hd__decap_3
XFILLER_52_416 VGND VGND VPWR VPWR sky130_fd_sc_hd__decap_3
XFILLER_24_118 VGND VGND VPWR VPWR sky130_fd_sc_hd__decap_3
XFILLER_52_438 VGND VGND VPWR VPWR sky130_fd_sc_hd__decap_3
XFILLER_64_298 VGND VGND VPWR VPWR sky130_fd_sc_hd__fill_1
X_4932_ _5008_/CLK _4932_/D VGND VGND VPWR VPWR _4932_/Q sky130_fd_sc_hd__dfxtp_2
XFILLER_32_162 VGND VGND VPWR VPWR sky130_fd_sc_hd__decap_3
X_4863_ _5172_/Q _4868_/A2 _4870_/B1 _3231_/X VGND VGND VPWR VPWR _5172_/D sky130_fd_sc_hd__o22a_2
XFILLER_20_335 VGND VGND VPWR VPWR sky130_fd_sc_hd__decap_3
X_4794_ _4786_/A _4788_/B _4785_/A VGND VGND VPWR VPWR _4795_/B sky130_fd_sc_hd__a21oi_2
X_3814_ _5169_/Q _4241_/A VGND VGND VPWR VPWR _3815_/A sky130_fd_sc_hd__or2_2
X_3745_ _3745_/A _4503_/B VGND VGND VPWR VPWR _3977_/A sky130_fd_sc_hd__nor2_2
X_3676_ _4397_/C _3676_/B VGND VGND VPWR VPWR _3677_/B sky130_fd_sc_hd__nand2_2
X_2627_ _5162_/Q _3600_/A VGND VGND VPWR VPWR _2629_/B sky130_fd_sc_hd__or2_2
X_2558_ _2660_/A _2555_/X _5130_/Q VGND VGND VPWR VPWR _2558_/X sky130_fd_sc_hd__o21a_2
X_5277_ _5285_/CLK _5277_/D VGND VGND VPWR VPWR _5277_/Q sky130_fd_sc_hd__dfxtp_2
X_2489_ _2487_/X _2488_/X _2660_/A VGND VGND VPWR VPWR _2489_/X sky130_fd_sc_hd__mux2_1
XFILLER_87_313 VGND VGND VPWR VPWR sky130_fd_sc_hd__decap_3
X_4228_ _3844_/Y _4215_/X _4227_/X VGND VGND VPWR VPWR _4228_/Y sky130_fd_sc_hd__a21oi_2
XFILLER_87_357 VGND VGND VPWR VPWR sky130_fd_sc_hd__decap_3
XFILLER_75_508 VGND VGND VPWR VPWR sky130_fd_sc_hd__decap_3
XFILLER_28_424 VGND VGND VPWR VPWR sky130_fd_sc_hd__decap_3
XFILLER_55_221 VGND VGND VPWR VPWR sky130_fd_sc_hd__decap_3
X_4159_ _2683_/A _3764_/X _3767_/Y _3689_/X _4168_/A VGND VGND VPWR VPWR _4159_/X
+ sky130_fd_sc_hd__a221o_2
XFILLER_55_276 VGND VGND VPWR VPWR sky130_fd_sc_hd__decap_3
XFILLER_43_427 VGND VGND VPWR VPWR sky130_fd_sc_hd__fill_2
XFILLER_43_449 VGND VGND VPWR VPWR sky130_fd_sc_hd__decap_3
XFILLER_55_298 VGND VGND VPWR VPWR sky130_fd_sc_hd__decap_3
XFILLER_70_213 VGND VGND VPWR VPWR sky130_fd_sc_hd__decap_3
XFILLER_62_25 VGND VGND VPWR VPWR sky130_fd_sc_hd__decap_3
XFILLER_51_471 VGND VGND VPWR VPWR sky130_fd_sc_hd__decap_3
XFILLER_11_335 VGND VGND VPWR VPWR sky130_fd_sc_hd__fill_1
XFILLER_11_357 VGND VGND VPWR VPWR sky130_fd_sc_hd__decap_3
XFILLER_3_501 VGND VGND VPWR VPWR sky130_fd_sc_hd__decap_3
XFILLER_3_523 VGND VGND VPWR VPWR sky130_fd_sc_hd__decap_3
XFILLER_3_556 VGND VGND VPWR VPWR sky130_fd_sc_hd__fill_2
XFILLER_87_77 VGND VGND VPWR VPWR sky130_fd_sc_hd__decap_3
XFILLER_87_66 VGND VGND VPWR VPWR sky130_fd_sc_hd__fill_2
XFILLER_78_324 VGND VGND VPWR VPWR sky130_fd_sc_hd__decap_3
XFILLER_66_508 VGND VGND VPWR VPWR sky130_fd_sc_hd__decap_3
XFILLER_93_305 VGND VGND VPWR VPWR sky130_fd_sc_hd__decap_3
XFILLER_46_243 VGND VGND VPWR VPWR sky130_fd_sc_hd__fill_1
XFILLER_27_490 VGND VGND VPWR VPWR sky130_fd_sc_hd__decap_3
XFILLER_34_427 VGND VGND VPWR VPWR sky130_fd_sc_hd__decap_3
XFILLER_36_70 VGND VGND VPWR VPWR sky130_fd_sc_hd__decap_3
XFILLER_46_287 VGND VGND VPWR VPWR sky130_fd_sc_hd__decap_3
XFILLER_61_213 VGND VGND VPWR VPWR sky130_fd_sc_hd__decap_3
XTAP_TAPCELL_ROW_29_474 VGND VPWR sky130_fd_sc_hd__tapvpwrvgnd_1
XFILLER_61_268 VGND VGND VPWR VPWR sky130_fd_sc_hd__decap_3
XFILLER_42_471 VGND VGND VPWR VPWR sky130_fd_sc_hd__decap_3
Xinput12 INSTR_STREAM[1] VGND VGND VPWR VPWR input12/X sky130_fd_sc_hd__clkdlybuf4s25_1
Xinput45 MEM_LD_DATA[6] VGND VGND VPWR VPWR input45/X sky130_fd_sc_hd__clkdlybuf4s25_1
Xinput34 MEM_LD_DATA[10] VGND VGND VPWR VPWR input34/X sky130_fd_sc_hd__clkdlybuf4s25_1
Xinput23 INSTR_STREAM[2] VGND VGND VPWR VPWR input23/X sky130_fd_sc_hd__clkdlybuf4s25_1
X_3530_ _4951_/Q _4935_/Q _4919_/Q _4903_/Q _3732_/S0 _3732_/S1 VGND VGND VPWR VPWR
+ _3530_/X sky130_fd_sc_hd__mux4_2
X_3461_ _5167_/Q _5148_/Q VGND VGND VPWR VPWR _3462_/B sky130_fd_sc_hd__nand2_2
XFILLER_42_3 VGND VGND VPWR VPWR sky130_fd_sc_hd__decap_3
X_5200_ _5283_/CLK _5200_/D VGND VGND VPWR VPWR _5200_/Q sky130_fd_sc_hd__dfxtp_2
X_3392_ _3393_/A _3393_/B _3393_/C VGND VGND VPWR VPWR _3392_/X sky130_fd_sc_hd__a21o_2
XFILLER_69_313 VGND VGND VPWR VPWR sky130_fd_sc_hd__decap_3
XFILLER_69_335 VGND VGND VPWR VPWR sky130_fd_sc_hd__fill_1
X_5131_ _5176_/CLK _5131_/D VGND VGND VPWR VPWR _5131_/Q sky130_fd_sc_hd__dfxtp_4
X_5062_ _5102_/CLK _5062_/D VGND VGND VPWR VPWR _5062_/Q sky130_fd_sc_hd__dfxtp_2
X_4013_ _4007_/Y _4012_/X _4854_/B VGND VGND VPWR VPWR _4013_/X sky130_fd_sc_hd__a21o_2
XFILLER_84_327 VGND VGND VPWR VPWR sky130_fd_sc_hd__fill_2
XFILLER_25_405 VGND VGND VPWR VPWR sky130_fd_sc_hd__decap_3
XFILLER_92_360 VGND VGND VPWR VPWR sky130_fd_sc_hd__decap_3
XFILLER_25_449 VGND VGND VPWR VPWR sky130_fd_sc_hd__fill_2
XFILLER_37_287 VGND VGND VPWR VPWR sky130_fd_sc_hd__fill_1
XFILLER_80_533 VGND VGND VPWR VPWR sky130_fd_sc_hd__decap_3
XFILLER_80_522 VGND VGND VPWR VPWR sky130_fd_sc_hd__fill_2
XFILLER_33_471 VGND VGND VPWR VPWR sky130_fd_sc_hd__decap_3
X_4915_ clkload5/A _4915_/D VGND VGND VPWR VPWR _4915_/Q sky130_fd_sc_hd__dfxtp_2
XTAP_TAPCELL_ROW_63_797 VGND VPWR sky130_fd_sc_hd__tapvpwrvgnd_1
X_4846_ _5274_/Q _4275_/B _3364_/A _3366_/A VGND VGND VPWR VPWR _5274_/D sky130_fd_sc_hd__o211a_2
X_4777_ _5163_/Q _4777_/B VGND VGND VPWR VPWR _4778_/B sky130_fd_sc_hd__or2_2
XFILLER_4_309 VGND VGND VPWR VPWR sky130_fd_sc_hd__decap_3
X_3728_ _4892_/Q _4876_/Q _5100_/Q _5084_/Q _5131_/Q _5132_/Q VGND VGND VPWR VPWR
+ _3729_/B sky130_fd_sc_hd__mux4_2
X_3659_ _4965_/Q _4949_/Q _4933_/Q _4917_/Q _5131_/Q _5132_/Q VGND VGND VPWR VPWR
+ _3659_/X sky130_fd_sc_hd__mux4_2
XFILLER_0_526 VGND VGND VPWR VPWR sky130_fd_sc_hd__decap_3
XFILLER_0_548 VGND VGND VPWR VPWR sky130_fd_sc_hd__decap_3
XFILLER_48_519 VGND VGND VPWR VPWR sky130_fd_sc_hd__decap_3
XFILLER_57_36 VGND VGND VPWR VPWR sky130_fd_sc_hd__fill_2
XFILLER_57_47 VGND VGND VPWR VPWR sky130_fd_sc_hd__decap_3
XFILLER_28_232 VGND VGND VPWR VPWR sky130_fd_sc_hd__decap_3
XFILLER_75_349 VGND VGND VPWR VPWR sky130_fd_sc_hd__decap_3
XFILLER_28_265 VGND VGND VPWR VPWR sky130_fd_sc_hd__decap_3
XFILLER_56_552 VGND VGND VPWR VPWR sky130_fd_sc_hd__decap_3
XFILLER_71_511 VGND VGND VPWR VPWR sky130_fd_sc_hd__decap_3
XFILLER_71_533 VGND VGND VPWR VPWR sky130_fd_sc_hd__decap_3
XFILLER_73_35 VGND VGND VPWR VPWR sky130_fd_sc_hd__decap_3
XFILLER_83_393 VGND VGND VPWR VPWR sky130_fd_sc_hd__decap_3
XFILLER_83_382 VGND VGND VPWR VPWR sky130_fd_sc_hd__decap_3
XFILLER_73_68 VGND VGND VPWR VPWR sky130_fd_sc_hd__decap_3
XTAP_TAPCELL_ROW_26_444 VGND VPWR sky130_fd_sc_hd__tapvpwrvgnd_1
XFILLER_51_290 VGND VGND VPWR VPWR sky130_fd_sc_hd__decap_3
XFILLER_7_125 VGND VGND VPWR VPWR sky130_fd_sc_hd__decap_3
XFILLER_3_375 VGND VGND VPWR VPWR sky130_fd_sc_hd__decap_3
XFILLER_93_113 VGND VGND VPWR VPWR sky130_fd_sc_hd__decap_3
XFILLER_19_210 VGND VGND VPWR VPWR sky130_fd_sc_hd__decap_3
XFILLER_59_390 VGND VGND VPWR VPWR sky130_fd_sc_hd__fill_2
XFILLER_47_552 VGND VGND VPWR VPWR sky130_fd_sc_hd__decap_3
XFILLER_81_319 VGND VGND VPWR VPWR sky130_fd_sc_hd__decap_3
XFILLER_62_511 VGND VGND VPWR VPWR sky130_fd_sc_hd__fill_2
XFILLER_74_371 VGND VGND VPWR VPWR sky130_fd_sc_hd__fill_1
XFILLER_62_544 VGND VGND VPWR VPWR sky130_fd_sc_hd__decap_3
XFILLER_34_279 VGND VGND VPWR VPWR sky130_fd_sc_hd__decap_3
X_2961_ _2921_/X _2970_/A2 _2954_/Y _4893_/Q VGND VGND VPWR VPWR _4893_/D sky130_fd_sc_hd__a22o_2
XFILLER_30_430 VGND VGND VPWR VPWR sky130_fd_sc_hd__decap_3
XFILLER_42_290 VGND VGND VPWR VPWR sky130_fd_sc_hd__decap_3
X_4700_ input41/X _4694_/Y _4699_/X _3366_/A VGND VGND VPWR VPWR _5244_/D sky130_fd_sc_hd__o211a_2
XFILLER_30_474 VGND VGND VPWR VPWR sky130_fd_sc_hd__fill_2
X_4631_ _3363_/A _4213_/A _4631_/S VGND VGND VPWR VPWR _4631_/X sky130_fd_sc_hd__mux2_1
X_2892_ _2894_/A _2892_/B _2892_/C VGND VGND VPWR VPWR _2892_/X sky130_fd_sc_hd__and3_2
XTAP_TAPCELL_ROW_60_767 VGND VPWR sky130_fd_sc_hd__tapvpwrvgnd_1
XFILLER_8_85 VGND VGND VPWR VPWR sky130_fd_sc_hd__decap_3
X_4562_ _4062_/A _4261_/C _4686_/B1 _3831_/A _4561_/Y VGND VGND VPWR VPWR _4562_/X
+ sky130_fd_sc_hd__o221a_2
X_4493_ _5229_/Q _4854_/B VGND VGND VPWR VPWR _4493_/Y sky130_fd_sc_hd__nand2_2
X_3513_ _3511_/X _3512_/X _5133_/Q VGND VGND VPWR VPWR _3513_/X sky130_fd_sc_hd__mux2_1
X_3444_ _5165_/Q _5146_/Q VGND VGND VPWR VPWR _3457_/A sky130_fd_sc_hd__nor2_2
X_3375_ _5178_/Q _3357_/X _4854_/B VGND VGND VPWR VPWR _3375_/X sky130_fd_sc_hd__a21o_2
XFILLER_57_327 VGND VGND VPWR VPWR sky130_fd_sc_hd__decap_3
X_5114_ _5114_/CLK _5114_/D VGND VGND VPWR VPWR _5114_/Q sky130_fd_sc_hd__dfxtp_2
XFILLER_84_102 VGND VGND VPWR VPWR sky130_fd_sc_hd__fill_1
XFILLER_38_530 VGND VGND VPWR VPWR sky130_fd_sc_hd__fill_2
XFILLER_69_187 VGND VGND VPWR VPWR sky130_fd_sc_hd__fill_2
X_5045_ _5109_/CLK _5045_/D VGND VGND VPWR VPWR _5045_/Q sky130_fd_sc_hd__dfxtp_2
XTAP_TAPCELL_ROW_68_845 VGND VPWR sky130_fd_sc_hd__tapvpwrvgnd_1
XFILLER_72_319 VGND VGND VPWR VPWR sky130_fd_sc_hd__fill_2
XFILLER_25_202 VGND VGND VPWR VPWR sky130_fd_sc_hd__decap_3
XFILLER_65_382 VGND VGND VPWR VPWR sky130_fd_sc_hd__decap_3
XFILLER_65_393 VGND VGND VPWR VPWR sky130_fd_sc_hd__decap_3
XFILLER_80_330 VGND VGND VPWR VPWR sky130_fd_sc_hd__decap_3
XFILLER_13_419 VGND VGND VPWR VPWR sky130_fd_sc_hd__decap_3
XFILLER_80_363 VGND VGND VPWR VPWR sky130_fd_sc_hd__fill_1
XFILLER_43_49 VGND VGND VPWR VPWR sky130_fd_sc_hd__decap_3
XFILLER_21_441 VGND VGND VPWR VPWR sky130_fd_sc_hd__decap_3
XFILLER_21_452 VGND VGND VPWR VPWR sky130_fd_sc_hd__decap_3
XFILLER_21_485 VGND VGND VPWR VPWR sky130_fd_sc_hd__decap_3
X_4829_ _4829_/A _4829_/B VGND VGND VPWR VPWR _4829_/Y sky130_fd_sc_hd__nor2_2
XFILLER_0_301 VGND VGND VPWR VPWR sky130_fd_sc_hd__decap_3
XFILLER_0_312 VGND VGND VPWR VPWR sky130_fd_sc_hd__decap_3
XFILLER_0_345 VGND VGND VPWR VPWR sky130_fd_sc_hd__decap_3
XFILLER_68_57 VGND VGND VPWR VPWR sky130_fd_sc_hd__fill_1
XFILLER_68_68 VGND VGND VPWR VPWR sky130_fd_sc_hd__decap_3
XFILLER_48_305 VGND VGND VPWR VPWR sky130_fd_sc_hd__decap_3
XFILLER_88_485 VGND VGND VPWR VPWR sky130_fd_sc_hd__decap_3
XFILLER_48_327 VGND VGND VPWR VPWR sky130_fd_sc_hd__decap_3
XFILLER_75_113 VGND VGND VPWR VPWR sky130_fd_sc_hd__decap_3
XFILLER_84_12 VGND VGND VPWR VPWR sky130_fd_sc_hd__fill_1
XFILLER_63_319 VGND VGND VPWR VPWR sky130_fd_sc_hd__decap_3
XTAP_TAPCELL_ROW_89_1047 VGND VPWR sky130_fd_sc_hd__tapvpwrvgnd_1
XFILLER_84_45 VGND VGND VPWR VPWR sky130_fd_sc_hd__decap_3
XFILLER_16_224 VGND VGND VPWR VPWR sky130_fd_sc_hd__decap_3
XFILLER_83_190 VGND VGND VPWR VPWR sky130_fd_sc_hd__decap_3
XFILLER_16_268 VGND VGND VPWR VPWR sky130_fd_sc_hd__fill_1
XFILLER_31_205 VGND VGND VPWR VPWR sky130_fd_sc_hd__fill_1
XFILLER_71_385 VGND VGND VPWR VPWR sky130_fd_sc_hd__decap_3
XFILLER_12_430 VGND VGND VPWR VPWR sky130_fd_sc_hd__decap_3
XFILLER_71_396 VGND VGND VPWR VPWR sky130_fd_sc_hd__decap_3
XFILLER_33_60 VGND VGND VPWR VPWR sky130_fd_sc_hd__fill_2
XFILLER_76_9 VGND VGND VPWR VPWR sky130_fd_sc_hd__decap_3
XFILLER_79_452 VGND VGND VPWR VPWR sky130_fd_sc_hd__decap_3
XFILLER_79_441 VGND VGND VPWR VPWR sky130_fd_sc_hd__decap_3
XFILLER_39_316 VGND VGND VPWR VPWR sky130_fd_sc_hd__decap_3
X_3160_ _2908_/X _3173_/A2 _3157_/Y _5065_/Q VGND VGND VPWR VPWR _5065_/D sky130_fd_sc_hd__a22o_2
XFILLER_39_349 VGND VGND VPWR VPWR sky130_fd_sc_hd__decap_3
X_3091_ _2921_/X _3100_/A2 _3084_/Y _5005_/Q VGND VGND VPWR VPWR _5005_/D sky130_fd_sc_hd__a22o_2
XFILLER_66_168 VGND VGND VPWR VPWR sky130_fd_sc_hd__decap_3
XTAP_TAPCELL_ROW_65_815 VGND VPWR sky130_fd_sc_hd__tapvpwrvgnd_1
XFILLER_35_500 VGND VGND VPWR VPWR sky130_fd_sc_hd__decap_3
XFILLER_47_371 VGND VGND VPWR VPWR sky130_fd_sc_hd__decap_3
XFILLER_66_179 VGND VGND VPWR VPWR sky130_fd_sc_hd__decap_3
XFILLER_81_127 VGND VGND VPWR VPWR sky130_fd_sc_hd__decap_3
XFILLER_35_555 VGND VGND VPWR VPWR sky130_fd_sc_hd__decap_3
XFILLER_62_341 VGND VGND VPWR VPWR sky130_fd_sc_hd__decap_3
XPHY_EDGE_ROW_8_Right_8 VGND VGND VPWR VPWR sky130_fd_sc_hd__decap_3
XFILLER_22_227 VGND VGND VPWR VPWR sky130_fd_sc_hd__decap_3
XFILLER_50_536 VGND VGND VPWR VPWR sky130_fd_sc_hd__decap_3
XFILLER_62_396 VGND VGND VPWR VPWR sky130_fd_sc_hd__decap_3
X_3993_ _3992_/A _3939_/Y _4266_/S VGND VGND VPWR VPWR _3993_/X sky130_fd_sc_hd__mux2_1
XTAP_TAPCELL_ROW_73_892 VGND VPWR sky130_fd_sc_hd__tapvpwrvgnd_1
X_2944_ _5275_/Q _5207_/Q _2947_/B1 _5239_/Q _2943_/X VGND VGND VPWR VPWR _2944_/X
+ sky130_fd_sc_hd__a221o_2
X_2875_ _4086_/A _2875_/B VGND VGND VPWR VPWR _2876_/B sky130_fd_sc_hd__xnor2_2
X_4614_ _4613_/X _4587_/Y _4681_/S VGND VGND VPWR VPWR _4614_/X sky130_fd_sc_hd__mux2_1
X_4545_ _4544_/X _4426_/A _4682_/S VGND VGND VPWR VPWR _4545_/X sky130_fd_sc_hd__mux2_1
Xmax_cap153 _3829_/B VGND VGND VPWR VPWR _4393_/C sky130_fd_sc_hd__buf_12
Xmax_cap142 _3120_/Y VGND VGND VPWR VPWR _3121_/B sky130_fd_sc_hd__buf_6
Xmax_cap131 _3028_/Y VGND VGND VPWR VPWR _3029_/B sky130_fd_sc_hd__buf_6
Xmax_cap120 _4313_/S VGND VGND VPWR VPWR _4449_/S sky130_fd_sc_hd__buf_12
X_4476_ _4326_/Y _4475_/X _4434_/A _4327_/A VGND VGND VPWR VPWR _4481_/A sky130_fd_sc_hd__a211o_2
Xmax_cap164 _2463_/B VGND VGND VPWR VPWR _2947_/B1 sky130_fd_sc_hd__clkbuf_2
Xmax_cap175 _5132_/Q VGND VGND VPWR VPWR _3706_/S1 sky130_fd_sc_hd__buf_12
XFILLER_89_205 VGND VGND VPWR VPWR sky130_fd_sc_hd__decap_3
X_3427_ _5201_/Q _4854_/B VGND VGND VPWR VPWR _3427_/Y sky130_fd_sc_hd__nand2_2
XPHY_EDGE_ROW_39_Right_39 VGND VGND VPWR VPWR sky130_fd_sc_hd__decap_3
X_3358_ _5179_/Q _3357_/X _4854_/B VGND VGND VPWR VPWR _3358_/X sky130_fd_sc_hd__a21o_2
XFILLER_85_444 VGND VGND VPWR VPWR sky130_fd_sc_hd__decap_3
XFILLER_85_433 VGND VGND VPWR VPWR sky130_fd_sc_hd__fill_2
X_3289_ _3287_/Y _3288_/X _3305_/B VGND VGND VPWR VPWR _3289_/Y sky130_fd_sc_hd__o21ai_2
XFILLER_85_455 VGND VGND VPWR VPWR sky130_fd_sc_hd__decap_3
XFILLER_38_360 VGND VGND VPWR VPWR sky130_fd_sc_hd__decap_3
XFILLER_38_371 VGND VGND VPWR VPWR sky130_fd_sc_hd__decap_3
XFILLER_45_319 VGND VGND VPWR VPWR sky130_fd_sc_hd__decap_3
X_5028_ clkload6/A _5028_/D VGND VGND VPWR VPWR _5028_/Q sky130_fd_sc_hd__dfxtp_2
XFILLER_85_488 VGND VGND VPWR VPWR sky130_fd_sc_hd__decap_3
XFILLER_72_149 VGND VGND VPWR VPWR sky130_fd_sc_hd__decap_3
XFILLER_53_352 VGND VGND VPWR VPWR sky130_fd_sc_hd__decap_3
XTAP_TAPCELL_ROW_0_197 VGND VPWR sky130_fd_sc_hd__tapvpwrvgnd_1
XFILLER_80_160 VGND VGND VPWR VPWR sky130_fd_sc_hd__decap_3
XFILLER_13_249 VGND VGND VPWR VPWR sky130_fd_sc_hd__decap_3
XPHY_EDGE_ROW_48_Right_48 VGND VGND VPWR VPWR sky130_fd_sc_hd__decap_3
XFILLER_21_260 VGND VGND VPWR VPWR sky130_fd_sc_hd__fill_2
XFILLER_70_47 VGND VGND VPWR VPWR sky130_fd_sc_hd__decap_3
XFILLER_70_69 VGND VGND VPWR VPWR sky130_fd_sc_hd__decap_3
XFILLER_21_293 VGND VGND VPWR VPWR sky130_fd_sc_hd__decap_3
XFILLER_79_34 VGND VGND VPWR VPWR sky130_fd_sc_hd__decap_3
XPHY_EDGE_ROW_57_Right_57 VGND VGND VPWR VPWR sky130_fd_sc_hd__decap_3
XFILLER_0_131 VGND VGND VPWR VPWR sky130_fd_sc_hd__decap_3
XTAP_TAPCELL_ROW_8_275 VGND VPWR sky130_fd_sc_hd__tapvpwrvgnd_1
XFILLER_0_175 VGND VGND VPWR VPWR sky130_fd_sc_hd__decap_3
XFILLER_0_197 VGND VGND VPWR VPWR sky130_fd_sc_hd__decap_3
XFILLER_48_124 VGND VGND VPWR VPWR sky130_fd_sc_hd__decap_3
XFILLER_88_271 VGND VGND VPWR VPWR sky130_fd_sc_hd__fill_1
XFILLER_76_433 VGND VGND VPWR VPWR sky130_fd_sc_hd__decap_3
XFILLER_76_477 VGND VGND VPWR VPWR sky130_fd_sc_hd__decap_3
XFILLER_63_105 VGND VGND VPWR VPWR sky130_fd_sc_hd__decap_3
XFILLER_63_116 VGND VGND VPWR VPWR sky130_fd_sc_hd__decap_3
XFILLER_17_555 VGND VGND VPWR VPWR sky130_fd_sc_hd__decap_3
XFILLER_29_393 VGND VGND VPWR VPWR sky130_fd_sc_hd__decap_3
XFILLER_63_138 VGND VGND VPWR VPWR sky130_fd_sc_hd__fill_1
XFILLER_91_447 VGND VGND VPWR VPWR sky130_fd_sc_hd__fill_1
XFILLER_44_374 VGND VGND VPWR VPWR sky130_fd_sc_hd__decap_3
XFILLER_71_160 VGND VGND VPWR VPWR sky130_fd_sc_hd__decap_3
XPHY_EDGE_ROW_66_Right_66 VGND VGND VPWR VPWR sky130_fd_sc_hd__decap_3
XFILLER_32_536 VGND VGND VPWR VPWR sky130_fd_sc_hd__decap_3
XFILLER_71_182 VGND VGND VPWR VPWR sky130_fd_sc_hd__decap_3
XTAP_TAPCELL_ROW_70_862 VGND VPWR sky130_fd_sc_hd__tapvpwrvgnd_1
XTAP_TAPCELL_ROW_42_597 VGND VPWR sky130_fd_sc_hd__tapvpwrvgnd_1
X_2660_ _2660_/A _2660_/B VGND VGND VPWR VPWR _2660_/X sky130_fd_sc_hd__or2_2
XFILLER_8_253 VGND VGND VPWR VPWR sky130_fd_sc_hd__decap_3
XFILLER_60_91 VGND VGND VPWR VPWR sky130_fd_sc_hd__fill_2
X_2591_ _2660_/A _2591_/B VGND VGND VPWR VPWR _2591_/X sky130_fd_sc_hd__or2_2
XPHY_EDGE_ROW_75_Right_75 VGND VGND VPWR VPWR sky130_fd_sc_hd__decap_3
X_4330_ _4350_/B _4329_/X _4397_/A VGND VGND VPWR VPWR _4334_/C sky130_fd_sc_hd__a21oi_2
X_4261_ _4261_/A _4261_/B _4261_/C _4261_/D VGND VGND VPWR VPWR _4261_/X sky130_fd_sc_hd__or4_2
X_3212_ _2897_/X _3227_/A2 _3211_/Y _5111_/Q VGND VGND VPWR VPWR _5111_/D sky130_fd_sc_hd__a22o_2
XFILLER_39_113 VGND VGND VPWR VPWR sky130_fd_sc_hd__decap_3
XFILLER_67_411 VGND VGND VPWR VPWR sky130_fd_sc_hd__decap_3
X_4192_ _4192_/A _4192_/B _4192_/C _4192_/D VGND VGND VPWR VPWR _4192_/Y sky130_fd_sc_hd__nor4_2
XFILLER_79_293 VGND VGND VPWR VPWR sky130_fd_sc_hd__decap_3
XFILLER_67_444 VGND VGND VPWR VPWR sky130_fd_sc_hd__decap_3
XFILLER_67_455 VGND VGND VPWR VPWR sky130_fd_sc_hd__decap_3
XFILLER_67_477 VGND VGND VPWR VPWR sky130_fd_sc_hd__decap_3
X_3143_ _2911_/X _3155_/A2 _3139_/Y _5050_/Q VGND VGND VPWR VPWR _5050_/D sky130_fd_sc_hd__a22o_2
XTAP_TAPCELL_ROW_78_940 VGND VPWR sky130_fd_sc_hd__tapvpwrvgnd_1
XFILLER_54_127 VGND VGND VPWR VPWR sky130_fd_sc_hd__decap_3
XFILLER_67_499 VGND VGND VPWR VPWR sky130_fd_sc_hd__decap_3
X_3074_ _2924_/X _3066_/B _3066_/Y _4990_/Q VGND VGND VPWR VPWR _4990_/D sky130_fd_sc_hd__a22o_2
XPHY_EDGE_ROW_84_Right_84 VGND VGND VPWR VPWR sky130_fd_sc_hd__decap_3
XFILLER_82_458 VGND VGND VPWR VPWR sky130_fd_sc_hd__decap_3
XFILLER_35_374 VGND VGND VPWR VPWR sky130_fd_sc_hd__fill_1
XFILLER_50_300 VGND VGND VPWR VPWR sky130_fd_sc_hd__decap_3
XFILLER_62_160 VGND VGND VPWR VPWR sky130_fd_sc_hd__fill_2
XFILLER_50_333 VGND VGND VPWR VPWR sky130_fd_sc_hd__decap_3
XFILLER_90_491 VGND VGND VPWR VPWR sky130_fd_sc_hd__decap_3
X_3976_ _4051_/A _4267_/S _3976_/C VGND VGND VPWR VPWR _4518_/A sky130_fd_sc_hd__or3_2
XFILLER_10_219 VGND VGND VPWR VPWR sky130_fd_sc_hd__decap_3
X_2927_ _5277_/Q _5250_/Q _5234_/Q _2947_/B1 _2926_/X VGND VGND VPWR VPWR _2927_/X
+ sky130_fd_sc_hd__a221o_2
X_2858_ _5156_/Q _4320_/B VGND VGND VPWR VPWR _2860_/B sky130_fd_sc_hd__nor2_2
XPHY_EDGE_ROW_93_Right_93 VGND VGND VPWR VPWR sky130_fd_sc_hd__decap_3
X_2789_ _5119_/Q _5007_/Q _4991_/Q _4975_/Q _2818_/S0 _5136_/Q VGND VGND VPWR VPWR
+ _2790_/B sky130_fd_sc_hd__mux4_2
XFILLER_2_407 VGND VGND VPWR VPWR sky130_fd_sc_hd__decap_3
X_4528_ _3567_/S _2443_/X _4528_/S VGND VGND VPWR VPWR _4531_/B sky130_fd_sc_hd__mux2_1
X_4459_ _4460_/A _4460_/B VGND VGND VPWR VPWR _4459_/Y sky130_fd_sc_hd__nand2b_2
XFILLER_58_433 VGND VGND VPWR VPWR sky130_fd_sc_hd__decap_3
XTAP_TAPCELL_ROW_5_245 VGND VPWR sky130_fd_sc_hd__tapvpwrvgnd_1
XFILLER_45_105 VGND VGND VPWR VPWR sky130_fd_sc_hd__decap_3
XFILLER_58_477 VGND VGND VPWR VPWR sky130_fd_sc_hd__decap_3
XTAP_TAPCELL_ROW_86_1017 VGND VPWR sky130_fd_sc_hd__tapvpwrvgnd_1
XFILLER_73_458 VGND VGND VPWR VPWR sky130_fd_sc_hd__decap_3
XFILLER_14_514 VGND VGND VPWR VPWR sky130_fd_sc_hd__decap_3
XTAP_TAPCELL_ROW_84_998 VGND VPWR sky130_fd_sc_hd__tapvpwrvgnd_1
XFILLER_53_193 VGND VGND VPWR VPWR sky130_fd_sc_hd__decap_3
XFILLER_14_62 VGND VGND VPWR VPWR sky130_fd_sc_hd__decap_3
XFILLER_5_212 VGND VGND VPWR VPWR sky130_fd_sc_hd__decap_3
XFILLER_30_83 VGND VGND VPWR VPWR sky130_fd_sc_hd__fill_1
XFILLER_5_267 VGND VGND VPWR VPWR sky130_fd_sc_hd__decap_3
XFILLER_30_94 VGND VGND VPWR VPWR sky130_fd_sc_hd__decap_3
XFILLER_39_9 VGND VGND VPWR VPWR sky130_fd_sc_hd__fill_2
XFILLER_1_473 VGND VGND VPWR VPWR sky130_fd_sc_hd__fill_1
XFILLER_49_433 VGND VGND VPWR VPWR sky130_fd_sc_hd__fill_1
XFILLER_76_230 VGND VGND VPWR VPWR sky130_fd_sc_hd__decap_3
XFILLER_49_477 VGND VGND VPWR VPWR sky130_fd_sc_hd__decap_3
XTAP_TAPCELL_ROW_75_910 VGND VPWR sky130_fd_sc_hd__tapvpwrvgnd_1
XFILLER_17_330 VGND VGND VPWR VPWR sky130_fd_sc_hd__decap_3
XTAP_TAPCELL_ROW_47_645 VGND VPWR sky130_fd_sc_hd__tapvpwrvgnd_1
XFILLER_17_352 VGND VGND VPWR VPWR sky130_fd_sc_hd__fill_2
XFILLER_51_108 VGND VGND VPWR VPWR sky130_fd_sc_hd__decap_3
XFILLER_17_396 VGND VGND VPWR VPWR sky130_fd_sc_hd__fill_2
XFILLER_72_480 VGND VGND VPWR VPWR sky130_fd_sc_hd__decap_3
XFILLER_32_333 VGND VGND VPWR VPWR sky130_fd_sc_hd__decap_3
X_3830_ _4015_/A _3828_/Y _3829_/X VGND VGND VPWR VPWR _3830_/X sky130_fd_sc_hd__a21o_2
XFILLER_32_377 VGND VGND VPWR VPWR sky130_fd_sc_hd__decap_3
X_3761_ _5158_/Q _4281_/A _4309_/S VGND VGND VPWR VPWR _4267_/S sky130_fd_sc_hd__mux2_2
X_2712_ _3494_/A _2712_/B VGND VGND VPWR VPWR _5284_/D sky130_fd_sc_hd__nor2_2
XFILLER_9_551 VGND VGND VPWR VPWR sky130_fd_sc_hd__decap_3
XFILLER_9_540 VGND VGND VPWR VPWR sky130_fd_sc_hd__decap_3
X_3692_ _5072_/Q _5056_/Q _5040_/Q _5024_/Q _3706_/S0 _3706_/S1 VGND VGND VPWR VPWR
+ _3693_/B sky130_fd_sc_hd__mux4_2
X_2643_ _5165_/Q _3701_/A VGND VGND VPWR VPWR _4602_/S sky130_fd_sc_hd__nor2_2
X_2574_ _2572_/X _2573_/X _5129_/Q VGND VGND VPWR VPWR _2574_/X sky130_fd_sc_hd__mux2_1
X_4313_ _4357_/A _4318_/A _4313_/S VGND VGND VPWR VPWR _4313_/X sky130_fd_sc_hd__mux2_1
XFILLER_87_517 VGND VGND VPWR VPWR sky130_fd_sc_hd__decap_3
XFILLER_19_18 VGND VGND VPWR VPWR sky130_fd_sc_hd__decap_3
X_4244_ _4243_/X _4149_/X _4267_/S VGND VGND VPWR VPWR _4244_/X sky130_fd_sc_hd__mux2_1
XFILLER_67_252 VGND VGND VPWR VPWR sky130_fd_sc_hd__decap_3
X_4175_ _4175_/A _4175_/B VGND VGND VPWR VPWR _4175_/X sky130_fd_sc_hd__or2_2
XFILLER_27_116 VGND VGND VPWR VPWR sky130_fd_sc_hd__decap_3
XFILLER_67_263 VGND VGND VPWR VPWR sky130_fd_sc_hd__decap_3
X_3126_ _2914_/X _3121_/B _3121_/Y _5035_/Q VGND VGND VPWR VPWR _5035_/D sky130_fd_sc_hd__a22o_2
XFILLER_82_222 VGND VGND VPWR VPWR sky130_fd_sc_hd__decap_3
X_3057_ _2927_/X _3047_/Y _3048_/Y _4975_/Q VGND VGND VPWR VPWR _4975_/D sky130_fd_sc_hd__a22o_2
XFILLER_70_439 VGND VGND VPWR VPWR sky130_fd_sc_hd__decap_3
XFILLER_23_366 VGND VGND VPWR VPWR sky130_fd_sc_hd__decap_3
XFILLER_50_141 VGND VGND VPWR VPWR sky130_fd_sc_hd__decap_3
XTAP_TAPCELL_ROW_81_968 VGND VPWR sky130_fd_sc_hd__tapvpwrvgnd_1
XFILLER_51_49 VGND VGND VPWR VPWR sky130_fd_sc_hd__fill_1
X_3959_ _3569_/X _3957_/X _3958_/Y _3894_/X VGND VGND VPWR VPWR _3959_/X sky130_fd_sc_hd__o22a_2
XFILLER_4_6 VGND VGND VPWR VPWR sky130_fd_sc_hd__decap_3
XTAP_TAPCELL_ROW_92_1076 VGND VPWR sky130_fd_sc_hd__tapvpwrvgnd_1
XFILLER_46_436 VGND VGND VPWR VPWR sky130_fd_sc_hd__decap_3
XFILLER_46_458 VGND VGND VPWR VPWR sky130_fd_sc_hd__decap_3
XFILLER_26_160 VGND VGND VPWR VPWR sky130_fd_sc_hd__decap_3
XFILLER_33_119 VGND VGND VPWR VPWR sky130_fd_sc_hd__decap_3
XFILLER_54_480 VGND VGND VPWR VPWR sky130_fd_sc_hd__decap_3
XTAP_TAPCELL_ROW_44_615 VGND VPWR sky130_fd_sc_hd__tapvpwrvgnd_1
XFILLER_92_78 VGND VGND VPWR VPWR sky130_fd_sc_hd__decap_3
XTAP_TAPCELL_ROW_52_692 VGND VPWR sky130_fd_sc_hd__tapvpwrvgnd_1
XFILLER_10_550 VGND VGND VPWR VPWR sky130_fd_sc_hd__decap_3
XFILLER_6_510 VGND VGND VPWR VPWR sky130_fd_sc_hd__fill_1
XFILLER_69_517 VGND VGND VPWR VPWR sky130_fd_sc_hd__decap_3
XFILLER_37_6 VGND VGND VPWR VPWR sky130_fd_sc_hd__fill_1
XFILLER_1_281 VGND VGND VPWR VPWR sky130_fd_sc_hd__fill_1
XFILLER_2_32 VGND VGND VPWR VPWR sky130_fd_sc_hd__decap_3
XFILLER_84_509 VGND VGND VPWR VPWR sky130_fd_sc_hd__decap_3
XFILLER_2_65 VGND VGND VPWR VPWR sky130_fd_sc_hd__fill_2
XFILLER_37_414 VGND VGND VPWR VPWR sky130_fd_sc_hd__decap_3
XFILLER_49_296 VGND VGND VPWR VPWR sky130_fd_sc_hd__decap_3
XFILLER_66_90 VGND VGND VPWR VPWR sky130_fd_sc_hd__decap_3
XFILLER_92_542 VGND VGND VPWR VPWR sky130_fd_sc_hd__decap_3
XFILLER_64_266 VGND VGND VPWR VPWR sky130_fd_sc_hd__decap_3
X_4931_ clkload5/A _4931_/D VGND VGND VPWR VPWR _4931_/Q sky130_fd_sc_hd__dfxtp_2
XFILLER_32_141 VGND VGND VPWR VPWR sky130_fd_sc_hd__decap_3
X_4862_ _5171_/Q _3229_/Y _4870_/B1 _3245_/X VGND VGND VPWR VPWR _5171_/D sky130_fd_sc_hd__o22a_2
XFILLER_20_303 VGND VGND VPWR VPWR sky130_fd_sc_hd__decap_3
XFILLER_32_174 VGND VGND VPWR VPWR sky130_fd_sc_hd__decap_3
XFILLER_60_483 VGND VGND VPWR VPWR sky130_fd_sc_hd__decap_3
X_3813_ _3748_/B _4188_/B _3812_/X _4261_/A _3784_/X VGND VGND VPWR VPWR _3915_/B
+ sky130_fd_sc_hd__o221a_2
X_4793_ _4793_/A _4793_/B VGND VGND VPWR VPWR _4795_/A sky130_fd_sc_hd__and2_2
X_3744_ _4318_/A _4298_/A VGND VGND VPWR VPWR _4503_/B sky130_fd_sc_hd__nor2_2
X_3675_ _4397_/C _3676_/B VGND VGND VPWR VPWR _4631_/S sky130_fd_sc_hd__nor2_2
Xoutput100 _2740_/X VGND VGND VPWR VPWR MEM_STR_DATA[2] sky130_fd_sc_hd__clkdlybuf4s25_1
X_2626_ _3986_/A _2868_/B _3775_/B _2623_/X VGND VGND VPWR VPWR _2872_/A sky130_fd_sc_hd__a31o_2
XPHY_EDGE_ROW_65_Left_159 VGND VGND VPWR VPWR sky130_fd_sc_hd__decap_3
Xclkbuf_leaf_33_CLK clkload0/A VGND VGND VPWR VPWR _5109_/CLK sky130_fd_sc_hd__clkbuf_8
X_2557_ _2677_/S _2557_/B VGND VGND VPWR VPWR _2557_/X sky130_fd_sc_hd__or2_2
X_5276_ _5285_/CLK _5276_/D VGND VGND VPWR VPWR _5276_/Q sky130_fd_sc_hd__dfxtp_2
X_2488_ _4965_/Q _4949_/Q _4933_/Q _4917_/Q _2676_/S0 _2676_/S1 VGND VGND VPWR VPWR
+ _2488_/X sky130_fd_sc_hd__mux4_2
XFILLER_87_325 VGND VGND VPWR VPWR sky130_fd_sc_hd__decap_3
X_4227_ _4227_/A _4227_/B _4227_/C _4227_/D VGND VGND VPWR VPWR _4227_/X sky130_fd_sc_hd__or4_2
XFILLER_87_369 VGND VGND VPWR VPWR sky130_fd_sc_hd__decap_3
XFILLER_28_436 VGND VGND VPWR VPWR sky130_fd_sc_hd__decap_3
XFILLER_28_447 VGND VGND VPWR VPWR sky130_fd_sc_hd__decap_3
XFILLER_28_458 VGND VGND VPWR VPWR sky130_fd_sc_hd__decap_3
X_4158_ _4200_/B _4158_/B VGND VGND VPWR VPWR _4158_/Y sky130_fd_sc_hd__xnor2_2
XPHY_EDGE_ROW_74_Left_168 VGND VGND VPWR VPWR sky130_fd_sc_hd__decap_3
XFILLER_43_417 VGND VGND VPWR VPWR sky130_fd_sc_hd__decap_3
X_4089_ _4062_/A _4062_/B _4062_/C _3601_/B VGND VGND VPWR VPWR _4090_/B sky130_fd_sc_hd__a31o_2
X_3109_ _2918_/X _3119_/A2 _3103_/Y _5020_/Q VGND VGND VPWR VPWR _5020_/D sky130_fd_sc_hd__a22o_2
XFILLER_83_553 VGND VGND VPWR VPWR sky130_fd_sc_hd__decap_3
XFILLER_15_119 VGND VGND VPWR VPWR sky130_fd_sc_hd__decap_3
XFILLER_70_225 VGND VGND VPWR VPWR sky130_fd_sc_hd__fill_1
XFILLER_62_37 VGND VGND VPWR VPWR sky130_fd_sc_hd__decap_3
XFILLER_23_141 VGND VGND VPWR VPWR sky130_fd_sc_hd__decap_3
XFILLER_11_369 VGND VGND VPWR VPWR sky130_fd_sc_hd__decap_3
XFILLER_7_307 VGND VGND VPWR VPWR sky130_fd_sc_hd__decap_3
XTAP_TAPCELL_ROW_21_397 VGND VPWR sky130_fd_sc_hd__tapvpwrvgnd_1
XPHY_EDGE_ROW_83_Left_177 VGND VGND VPWR VPWR sky130_fd_sc_hd__decap_3
XFILLER_11_63 VGND VGND VPWR VPWR sky130_fd_sc_hd__fill_2
XFILLER_3_535 VGND VGND VPWR VPWR sky130_fd_sc_hd__decap_3
Xclkbuf_leaf_24_CLK clkload0/A VGND VGND VPWR VPWR _5105_/CLK sky130_fd_sc_hd__clkbuf_8
XFILLER_2_3 VGND VGND VPWR VPWR sky130_fd_sc_hd__decap_3
XFILLER_87_23 VGND VGND VPWR VPWR sky130_fd_sc_hd__decap_3
XFILLER_87_12 VGND VGND VPWR VPWR sky130_fd_sc_hd__decap_3
XFILLER_87_89 VGND VGND VPWR VPWR sky130_fd_sc_hd__decap_3
XPHY_EDGE_ROW_92_Left_186 VGND VGND VPWR VPWR sky130_fd_sc_hd__decap_3
XFILLER_86_380 VGND VGND VPWR VPWR sky130_fd_sc_hd__decap_3
XTAP_TAPCELL_ROW_57_740 VGND VPWR sky130_fd_sc_hd__tapvpwrvgnd_1
XFILLER_34_439 VGND VGND VPWR VPWR sky130_fd_sc_hd__decap_3
XFILLER_61_203 VGND VGND VPWR VPWR sky130_fd_sc_hd__fill_2
XFILLER_61_225 VGND VGND VPWR VPWR sky130_fd_sc_hd__decap_3
XTAP_TAPCELL_ROW_29_475 VGND VPWR sky130_fd_sc_hd__tapvpwrvgnd_1
XPHY_EDGE_ROW_1_Left_95 VGND VGND VPWR VPWR sky130_fd_sc_hd__decap_3
XFILLER_42_483 VGND VGND VPWR VPWR sky130_fd_sc_hd__decap_3
XTAP_TAPCELL_ROW_12_320 VGND VPWR sky130_fd_sc_hd__tapvpwrvgnd_1
Xinput13 INSTR_STREAM[20] VGND VGND VPWR VPWR _3247_/C sky130_fd_sc_hd__clkdlybuf4s25_1
Xinput46 MEM_LD_DATA[7] VGND VGND VPWR VPWR input46/X sky130_fd_sc_hd__clkdlybuf4s25_1
Xinput35 MEM_LD_DATA[11] VGND VGND VPWR VPWR input35/X sky130_fd_sc_hd__clkdlybuf4s25_1
Xinput24 INSTR_STREAM[30] VGND VGND VPWR VPWR _3352_/C sky130_fd_sc_hd__clkdlybuf4s25_1
XFILLER_6_351 VGND VGND VPWR VPWR sky130_fd_sc_hd__decap_3
Xclkbuf_leaf_15_CLK clkload2/A VGND VGND VPWR VPWR _5251_/CLK sky130_fd_sc_hd__clkbuf_8
X_3460_ _5167_/Q _5148_/Q VGND VGND VPWR VPWR _3472_/A sky130_fd_sc_hd__nor2_2
X_3391_ _5156_/Q _5153_/Q _3384_/C _3382_/X VGND VGND VPWR VPWR _3393_/C sky130_fd_sc_hd__a31o_2
XFILLER_35_3 VGND VGND VPWR VPWR sky130_fd_sc_hd__decap_3
XFILLER_69_325 VGND VGND VPWR VPWR sky130_fd_sc_hd__decap_3
X_5130_ _5216_/CLK _5130_/D VGND VGND VPWR VPWR _5130_/Q sky130_fd_sc_hd__dfxtp_2
XFILLER_69_347 VGND VGND VPWR VPWR sky130_fd_sc_hd__fill_1
X_5061_ _5233_/CLK _5061_/D VGND VGND VPWR VPWR _5061_/Q sky130_fd_sc_hd__dfxtp_2
X_4012_ _4010_/Y _4011_/X _4213_/A VGND VGND VPWR VPWR _4012_/X sky130_fd_sc_hd__a21o_2
XFILLER_84_306 VGND VGND VPWR VPWR sky130_fd_sc_hd__fill_2
XFILLER_37_222 VGND VGND VPWR VPWR sky130_fd_sc_hd__fill_2
XFILLER_84_339 VGND VGND VPWR VPWR sky130_fd_sc_hd__decap_3
XFILLER_37_255 VGND VGND VPWR VPWR sky130_fd_sc_hd__decap_3
XFILLER_37_266 VGND VGND VPWR VPWR sky130_fd_sc_hd__decap_3
XFILLER_80_501 VGND VGND VPWR VPWR sky130_fd_sc_hd__decap_3
XFILLER_18_480 VGND VGND VPWR VPWR sky130_fd_sc_hd__decap_3
XFILLER_25_417 VGND VGND VPWR VPWR sky130_fd_sc_hd__decap_3
XFILLER_52_203 VGND VGND VPWR VPWR sky130_fd_sc_hd__decap_3
XFILLER_92_383 VGND VGND VPWR VPWR sky130_fd_sc_hd__decap_3
XFILLER_40_409 VGND VGND VPWR VPWR sky130_fd_sc_hd__decap_3
XFILLER_52_258 VGND VGND VPWR VPWR sky130_fd_sc_hd__decap_3
X_4914_ _5010_/CLK _4914_/D VGND VGND VPWR VPWR _4914_/Q sky130_fd_sc_hd__dfxtp_2
XFILLER_33_461 VGND VGND VPWR VPWR sky130_fd_sc_hd__fill_1
XTAP_TAPCELL_ROW_63_798 VGND VPWR sky130_fd_sc_hd__tapvpwrvgnd_1
XFILLER_20_111 VGND VGND VPWR VPWR sky130_fd_sc_hd__decap_3
XFILLER_32_29 VGND VGND VPWR VPWR sky130_fd_sc_hd__decap_3
XFILLER_33_494 VGND VGND VPWR VPWR sky130_fd_sc_hd__decap_3
X_4845_ _5273_/Q _4847_/B _4843_/Y _4844_/X _3338_/B VGND VGND VPWR VPWR _5273_/D
+ sky130_fd_sc_hd__o221a_2
X_4776_ _5163_/Q _4777_/B VGND VGND VPWR VPWR _4776_/X sky130_fd_sc_hd__and2_2
XFILLER_20_177 VGND VGND VPWR VPWR sky130_fd_sc_hd__fill_1
X_3727_ _5068_/Q _5052_/Q _5036_/Q _5020_/Q _5131_/Q _5132_/Q VGND VGND VPWR VPWR
+ _3727_/X sky130_fd_sc_hd__mux4_2
X_3658_ _3693_/A _3657_/X _5134_/Q VGND VGND VPWR VPWR _3658_/X sky130_fd_sc_hd__o21a_2
X_3589_ _3884_/D _3590_/B VGND VGND VPWR VPWR _3589_/Y sky130_fd_sc_hd__nor2_4
X_2609_ _2607_/X _2608_/X _5129_/Q VGND VGND VPWR VPWR _2609_/X sky130_fd_sc_hd__mux2_1
XFILLER_0_505 VGND VGND VPWR VPWR sky130_fd_sc_hd__decap_3
XFILLER_87_122 VGND VGND VPWR VPWR sky130_fd_sc_hd__decap_3
XFILLER_75_317 VGND VGND VPWR VPWR sky130_fd_sc_hd__decap_3
X_5259_ _5260_/CLK _5259_/D VGND VGND VPWR VPWR _5259_/Q sky130_fd_sc_hd__dfxtp_2
XFILLER_28_200 VGND VGND VPWR VPWR sky130_fd_sc_hd__decap_3
XFILLER_28_222 VGND VGND VPWR VPWR sky130_fd_sc_hd__fill_2
XFILLER_83_350 VGND VGND VPWR VPWR sky130_fd_sc_hd__decap_3
XFILLER_28_288 VGND VGND VPWR VPWR sky130_fd_sc_hd__decap_3
XFILLER_43_225 VGND VGND VPWR VPWR sky130_fd_sc_hd__fill_2
XTAP_TAPCELL_ROW_54_710 VGND VPWR sky130_fd_sc_hd__tapvpwrvgnd_1
XFILLER_71_545 VGND VGND VPWR VPWR sky130_fd_sc_hd__decap_3
XTAP_TAPCELL_ROW_26_445 VGND VPWR sky130_fd_sc_hd__tapvpwrvgnd_1
XFILLER_24_450 VGND VGND VPWR VPWR sky130_fd_sc_hd__decap_3
XFILLER_24_483 VGND VGND VPWR VPWR sky130_fd_sc_hd__decap_3
XFILLER_7_104 VGND VGND VPWR VPWR sky130_fd_sc_hd__decap_3
XFILLER_11_166 VGND VGND VPWR VPWR sky130_fd_sc_hd__fill_2
XFILLER_7_148 VGND VGND VPWR VPWR sky130_fd_sc_hd__decap_3
XFILLER_3_354 VGND VGND VPWR VPWR sky130_fd_sc_hd__decap_3
XFILLER_78_133 VGND VGND VPWR VPWR sky130_fd_sc_hd__decap_3
XFILLER_78_155 VGND VGND VPWR VPWR sky130_fd_sc_hd__decap_3
XFILLER_47_520 VGND VGND VPWR VPWR sky130_fd_sc_hd__decap_3
XFILLER_78_188 VGND VGND VPWR VPWR sky130_fd_sc_hd__decap_3
XFILLER_47_81 VGND VGND VPWR VPWR sky130_fd_sc_hd__decap_3
XFILLER_74_350 VGND VGND VPWR VPWR sky130_fd_sc_hd__decap_3
XFILLER_74_361 VGND VGND VPWR VPWR sky130_fd_sc_hd__decap_3
Xclkbuf_leaf_4_CLK clkbuf_leaf_5_CLK/A VGND VGND VPWR VPWR clkload5/A sky130_fd_sc_hd__clkbuf_8
XFILLER_62_556 VGND VGND VPWR VPWR sky130_fd_sc_hd__fill_2
XFILLER_15_461 VGND VGND VPWR VPWR sky130_fd_sc_hd__fill_2
X_2960_ _2918_/X _2970_/A2 _2954_/Y _4892_/Q VGND VGND VPWR VPWR _4892_/D sky130_fd_sc_hd__a22o_2
XFILLER_15_483 VGND VGND VPWR VPWR sky130_fd_sc_hd__fill_2
X_2891_ _2518_/Y _2889_/C _3842_/A VGND VGND VPWR VPWR _2892_/C sky130_fd_sc_hd__a21o_2
X_4630_ _4666_/A _4628_/X _4629_/Y _4437_/X _4501_/X VGND VGND VPWR VPWR _4630_/X
+ sky130_fd_sc_hd__a32o_2
XTAP_TAPCELL_ROW_60_768 VGND VPWR sky130_fd_sc_hd__tapvpwrvgnd_1
XFILLER_30_486 VGND VGND VPWR VPWR sky130_fd_sc_hd__decap_3
XFILLER_8_64 VGND VGND VPWR VPWR sky130_fd_sc_hd__decap_3
X_4561_ _2703_/A _2629_/B _4684_/B1 _3601_/B VGND VGND VPWR VPWR _4561_/Y sky130_fd_sc_hd__a22oi_2
X_4492_ _4457_/Y _4491_/X _4692_/A VGND VGND VPWR VPWR _5228_/D sky130_fd_sc_hd__a21oi_2
X_3512_ _4953_/Q _4937_/Q _4921_/Q _4905_/Q _3732_/S0 _3732_/S1 VGND VGND VPWR VPWR
+ _3512_/X sky130_fd_sc_hd__mux4_2
XFILLER_6_181 VGND VGND VPWR VPWR sky130_fd_sc_hd__decap_3
X_3443_ _3437_/Y _3440_/B _3438_/A VGND VGND VPWR VPWR _3447_/A sky130_fd_sc_hd__o21a_2
XFILLER_69_122 VGND VGND VPWR VPWR sky130_fd_sc_hd__fill_2
XFILLER_69_144 VGND VGND VPWR VPWR sky130_fd_sc_hd__decap_3
X_5113_ clkload5/A _5113_/D VGND VGND VPWR VPWR _5113_/Q sky130_fd_sc_hd__dfxtp_2
X_3374_ _5191_/Q _4275_/B _3360_/X _3366_/A VGND VGND VPWR VPWR _5191_/D sky130_fd_sc_hd__o211a_2
XFILLER_69_177 VGND VGND VPWR VPWR sky130_fd_sc_hd__decap_3
X_5044_ clkload6/A _5044_/D VGND VGND VPWR VPWR _5044_/Q sky130_fd_sc_hd__dfxtp_2
XTAP_TAPCELL_ROW_68_846 VGND VPWR sky130_fd_sc_hd__tapvpwrvgnd_1
XFILLER_38_553 VGND VGND VPWR VPWR sky130_fd_sc_hd__decap_3
XFILLER_65_361 VGND VGND VPWR VPWR sky130_fd_sc_hd__decap_3
XFILLER_80_342 VGND VGND VPWR VPWR sky130_fd_sc_hd__decap_3
XFILLER_43_28 VGND VGND VPWR VPWR sky130_fd_sc_hd__decap_3
XFILLER_21_464 VGND VGND VPWR VPWR sky130_fd_sc_hd__decap_3
X_4828_ _5169_/Q _4828_/B VGND VGND VPWR VPWR _4829_/B sky130_fd_sc_hd__nor2_2
X_4759_ _5262_/Q _4847_/B VGND VGND VPWR VPWR _4759_/X sky130_fd_sc_hd__or2_2
XTAP_TAPCELL_ROW_31_492 VGND VPWR sky130_fd_sc_hd__tapvpwrvgnd_1
XFILLER_0_324 VGND VGND VPWR VPWR sky130_fd_sc_hd__fill_1
XFILLER_68_36 VGND VGND VPWR VPWR sky130_fd_sc_hd__decap_3
XFILLER_88_442 VGND VGND VPWR VPWR sky130_fd_sc_hd__decap_3
XFILLER_88_431 VGND VGND VPWR VPWR sky130_fd_sc_hd__fill_1
XFILLER_0_357 VGND VGND VPWR VPWR sky130_fd_sc_hd__decap_3
XFILLER_0_379 VGND VGND VPWR VPWR sky130_fd_sc_hd__decap_3
XFILLER_29_531 VGND VGND VPWR VPWR sky130_fd_sc_hd__fill_2
XFILLER_75_125 VGND VGND VPWR VPWR sky130_fd_sc_hd__fill_1
XFILLER_88_497 VGND VGND VPWR VPWR sky130_fd_sc_hd__fill_1
XFILLER_75_158 VGND VGND VPWR VPWR sky130_fd_sc_hd__decap_3
XTAP_TAPCELL_ROW_89_1048 VGND VPWR sky130_fd_sc_hd__tapvpwrvgnd_1
XFILLER_16_203 VGND VGND VPWR VPWR sky130_fd_sc_hd__decap_3
XFILLER_56_372 VGND VGND VPWR VPWR sky130_fd_sc_hd__decap_3
XTAP_TAPCELL_ROW_39_570 VGND VPWR sky130_fd_sc_hd__tapvpwrvgnd_1
XFILLER_84_57 VGND VGND VPWR VPWR sky130_fd_sc_hd__decap_3
XFILLER_44_545 VGND VGND VPWR VPWR sky130_fd_sc_hd__fill_1
XFILLER_31_217 VGND VGND VPWR VPWR sky130_fd_sc_hd__decap_3
XFILLER_71_364 VGND VGND VPWR VPWR sky130_fd_sc_hd__fill_1
XFILLER_31_228 VGND VGND VPWR VPWR sky130_fd_sc_hd__decap_3
XFILLER_12_442 VGND VGND VPWR VPWR sky130_fd_sc_hd__fill_1
XFILLER_12_475 VGND VGND VPWR VPWR sky130_fd_sc_hd__fill_1
XFILLER_12_486 VGND VGND VPWR VPWR sky130_fd_sc_hd__decap_3
XFILLER_79_464 VGND VGND VPWR VPWR sky130_fd_sc_hd__decap_3
XFILLER_58_80 VGND VGND VPWR VPWR sky130_fd_sc_hd__decap_3
XFILLER_58_91 VGND VGND VPWR VPWR sky130_fd_sc_hd__decap_3
X_3090_ _2918_/X _3100_/A2 _3084_/Y _5004_/Q VGND VGND VPWR VPWR _5004_/D sky130_fd_sc_hd__a22o_2
XFILLER_35_523 VGND VGND VPWR VPWR sky130_fd_sc_hd__decap_3
XFILLER_47_383 VGND VGND VPWR VPWR sky130_fd_sc_hd__fill_1
XTAP_TAPCELL_ROW_65_816 VGND VPWR sky130_fd_sc_hd__tapvpwrvgnd_1
XFILLER_81_139 VGND VGND VPWR VPWR sky130_fd_sc_hd__decap_3
XFILLER_22_206 VGND VGND VPWR VPWR sky130_fd_sc_hd__decap_3
XFILLER_62_353 VGND VGND VPWR VPWR sky130_fd_sc_hd__decap_3
X_3992_ _3992_/A VGND VGND VPWR VPWR _3992_/Y sky130_fd_sc_hd__inv_2
XFILLER_50_526 VGND VGND VPWR VPWR sky130_fd_sc_hd__decap_3
X_2943_ _5277_/Q _5255_/Q _5223_/Q _5276_/Q VGND VGND VPWR VPWR _2943_/X sky130_fd_sc_hd__a22o_2
XTAP_TAPCELL_ROW_73_893 VGND VPWR sky130_fd_sc_hd__tapvpwrvgnd_1
X_2874_ _2872_/A _3831_/A _2629_/A VGND VGND VPWR VPWR _2875_/B sky130_fd_sc_hd__a21bo_2
X_4613_ _3834_/B _4147_/A _4638_/S VGND VGND VPWR VPWR _4613_/X sky130_fd_sc_hd__mux2_1
X_4544_ _4543_/Y _4498_/Y _4681_/S VGND VGND VPWR VPWR _4544_/X sky130_fd_sc_hd__mux2_1
Xmax_cap110 _3229_/Y VGND VGND VPWR VPWR _3230_/B sky130_fd_sc_hd__buf_6
Xmax_cap143 _3103_/B VGND VGND VPWR VPWR _3119_/A2 sky130_fd_sc_hd__buf_6
Xmax_cap132 _2992_/Y VGND VGND VPWR VPWR _2993_/B sky130_fd_sc_hd__buf_6
Xmax_cap121 _3874_/S VGND VGND VPWR VPWR _3905_/B sky130_fd_sc_hd__buf_6
XFILLER_7_490 VGND VGND VPWR VPWR sky130_fd_sc_hd__decap_3
X_4475_ _4378_/A _3852_/A _4364_/Y _4333_/B VGND VGND VPWR VPWR _4475_/X sky130_fd_sc_hd__a31o_2
Xmax_cap154 _4393_/B VGND VGND VPWR VPWR _3600_/A sky130_fd_sc_hd__buf_6
Xmax_cap165 _2887_/A VGND VGND VPWR VPWR _2873_/A sky130_fd_sc_hd__buf_8
Xmax_cap176 _5132_/Q VGND VGND VPWR VPWR _3732_/S1 sky130_fd_sc_hd__buf_12
X_3426_ _3494_/A _3426_/B VGND VGND VPWR VPWR _5200_/D sky130_fd_sc_hd__nor2_2
X_3357_ _5278_/Q _3357_/B _3361_/B VGND VGND VPWR VPWR _3357_/X sky130_fd_sc_hd__or3_2
XFILLER_57_169 VGND VGND VPWR VPWR sky130_fd_sc_hd__decap_3
X_5027_ _5110_/CLK _5027_/D VGND VGND VPWR VPWR _5027_/Q sky130_fd_sc_hd__dfxtp_2
X_3288_ _5147_/Q _5146_/Q _3297_/B VGND VGND VPWR VPWR _3288_/X sky130_fd_sc_hd__and3_2
XFILLER_38_383 VGND VGND VPWR VPWR sky130_fd_sc_hd__decap_3
XFILLER_53_320 VGND VGND VPWR VPWR sky130_fd_sc_hd__fill_2
XFILLER_53_342 VGND VGND VPWR VPWR sky130_fd_sc_hd__fill_1
XFILLER_72_139 VGND VGND VPWR VPWR sky130_fd_sc_hd__fill_1
XFILLER_41_515 VGND VGND VPWR VPWR sky130_fd_sc_hd__decap_3
XFILLER_53_375 VGND VGND VPWR VPWR sky130_fd_sc_hd__decap_3
XFILLER_54_49 VGND VGND VPWR VPWR sky130_fd_sc_hd__decap_3
XTAP_TAPCELL_ROW_36_540 VGND VPWR sky130_fd_sc_hd__tapvpwrvgnd_1
XFILLER_13_228 VGND VGND VPWR VPWR sky130_fd_sc_hd__fill_1
XTAP_TAPCELL_ROW_0_198 VGND VPWR sky130_fd_sc_hd__tapvpwrvgnd_1
XFILLER_5_449 VGND VGND VPWR VPWR sky130_fd_sc_hd__decap_3
XFILLER_79_79 VGND VGND VPWR VPWR sky130_fd_sc_hd__decap_3
XFILLER_79_46 VGND VGND VPWR VPWR sky130_fd_sc_hd__fill_1
XTAP_TAPCELL_ROW_8_276 VGND VPWR sky130_fd_sc_hd__tapvpwrvgnd_1
XFILLER_76_401 VGND VGND VPWR VPWR sky130_fd_sc_hd__decap_3
XFILLER_0_165 VGND VGND VPWR VPWR sky130_fd_sc_hd__decap_3
XFILLER_36_309 VGND VGND VPWR VPWR sky130_fd_sc_hd__decap_3
XFILLER_48_147 VGND VGND VPWR VPWR sky130_fd_sc_hd__decap_3
XFILLER_76_456 VGND VGND VPWR VPWR sky130_fd_sc_hd__fill_1
XFILLER_29_372 VGND VGND VPWR VPWR sky130_fd_sc_hd__fill_2
XFILLER_91_404 VGND VGND VPWR VPWR sky130_fd_sc_hd__fill_1
XFILLER_76_489 VGND VGND VPWR VPWR sky130_fd_sc_hd__decap_3
XFILLER_56_180 VGND VGND VPWR VPWR sky130_fd_sc_hd__decap_3
XFILLER_32_504 VGND VGND VPWR VPWR sky130_fd_sc_hd__decap_3
XFILLER_71_172 VGND VGND VPWR VPWR sky130_fd_sc_hd__fill_1
XTAP_TAPCELL_ROW_70_863 VGND VPWR sky130_fd_sc_hd__tapvpwrvgnd_1
XTAP_TAPCELL_ROW_42_598 VGND VPWR sky130_fd_sc_hd__tapvpwrvgnd_1
XFILLER_12_294 VGND VGND VPWR VPWR sky130_fd_sc_hd__decap_3
XFILLER_60_81 VGND VGND VPWR VPWR sky130_fd_sc_hd__decap_3
X_2590_ _4888_/Q _4872_/Q _5096_/Q _5080_/Q _2672_/S0 _2672_/S1 VGND VGND VPWR VPWR
+ _2591_/B sky130_fd_sc_hd__mux4_2
XFILLER_5_65 VGND VGND VPWR VPWR sky130_fd_sc_hd__decap_3
XFILLER_5_98 VGND VGND VPWR VPWR sky130_fd_sc_hd__decap_3
X_4260_ _4261_/B _4261_/D _4189_/A _4261_/A VGND VGND VPWR VPWR _4274_/B sky130_fd_sc_hd__o211a_2
X_4191_ _4191_/A _4191_/B _4191_/C VGND VGND VPWR VPWR _4191_/X sky130_fd_sc_hd__or3_2
X_3211_ _3494_/A _3211_/B VGND VGND VPWR VPWR _3211_/Y sky130_fd_sc_hd__nor2_4
XFILLER_67_423 VGND VGND VPWR VPWR sky130_fd_sc_hd__decap_3
X_3142_ _2908_/X _3155_/A2 _3139_/Y _5049_/Q VGND VGND VPWR VPWR _5049_/D sky130_fd_sc_hd__a22o_2
XFILLER_39_158 VGND VGND VPWR VPWR sky130_fd_sc_hd__fill_1
XTAP_TAPCELL_ROW_78_941 VGND VPWR sky130_fd_sc_hd__tapvpwrvgnd_1
XFILLER_39_169 VGND VGND VPWR VPWR sky130_fd_sc_hd__decap_3
XFILLER_54_106 VGND VGND VPWR VPWR sky130_fd_sc_hd__decap_3
XFILLER_67_489 VGND VGND VPWR VPWR sky130_fd_sc_hd__fill_1
X_3073_ _2921_/X _3066_/B _3066_/Y _4989_/Q VGND VGND VPWR VPWR _4989_/D sky130_fd_sc_hd__a22o_2
XFILLER_82_404 VGND VGND VPWR VPWR sky130_fd_sc_hd__decap_3
XFILLER_35_331 VGND VGND VPWR VPWR sky130_fd_sc_hd__decap_3
XFILLER_54_139 VGND VGND VPWR VPWR sky130_fd_sc_hd__fill_1
XFILLER_23_515 VGND VGND VPWR VPWR sky130_fd_sc_hd__fill_1
XFILLER_23_526 VGND VGND VPWR VPWR sky130_fd_sc_hd__decap_3
XFILLER_23_548 VGND VGND VPWR VPWR sky130_fd_sc_hd__decap_3
XFILLER_50_323 VGND VGND VPWR VPWR sky130_fd_sc_hd__decap_3
XFILLER_50_345 VGND VGND VPWR VPWR sky130_fd_sc_hd__decap_3
X_3975_ _3974_/X _3881_/B _3975_/S VGND VGND VPWR VPWR _3976_/C sky130_fd_sc_hd__mux2_1
XFILLER_50_378 VGND VGND VPWR VPWR sky130_fd_sc_hd__decap_3
X_2926_ _5276_/Q _5218_/Q _5202_/Q _5275_/Q VGND VGND VPWR VPWR _2926_/X sky130_fd_sc_hd__a22o_2
X_2857_ _2857_/A _4842_/B VGND VGND VPWR VPWR _2857_/X sky130_fd_sc_hd__and2_2
X_2788_ _2786_/X _2787_/X _2832_/A VGND VGND VPWR VPWR _2788_/X sky130_fd_sc_hd__mux2_1
X_4527_ _4684_/B1 _3615_/B _3778_/D _2565_/Y VGND VGND VPWR VPWR _4531_/A sky130_fd_sc_hd__o2bb2a_2
X_4458_ _4458_/A _4458_/B VGND VGND VPWR VPWR _4460_/B sky130_fd_sc_hd__xor2_2
X_3409_ _5198_/Q _4854_/B _3458_/A _3408_/Y VGND VGND VPWR VPWR _3410_/B sky130_fd_sc_hd__o2bb2a_2
X_4389_ _4389_/A _4389_/B VGND VGND VPWR VPWR _4408_/A sky130_fd_sc_hd__nor2_2
XTAP_TAPCELL_ROW_5_246 VGND VPWR sky130_fd_sc_hd__tapvpwrvgnd_1
XFILLER_85_242 VGND VGND VPWR VPWR sky130_fd_sc_hd__decap_3
XTAP_TAPCELL_ROW_86_1018 VGND VPWR sky130_fd_sc_hd__tapvpwrvgnd_1
XFILLER_73_437 VGND VGND VPWR VPWR sky130_fd_sc_hd__decap_3
XFILLER_60_109 VGND VGND VPWR VPWR sky130_fd_sc_hd__decap_3
XTAP_TAPCELL_ROW_84_999 VGND VPWR sky130_fd_sc_hd__tapvpwrvgnd_1
XFILLER_14_526 VGND VGND VPWR VPWR sky130_fd_sc_hd__decap_3
XFILLER_53_172 VGND VGND VPWR VPWR sky130_fd_sc_hd__decap_3
XFILLER_81_492 VGND VGND VPWR VPWR sky130_fd_sc_hd__decap_3
XFILLER_81_481 VGND VGND VPWR VPWR sky130_fd_sc_hd__decap_3
XFILLER_41_345 VGND VGND VPWR VPWR sky130_fd_sc_hd__fill_1
XFILLER_41_356 VGND VGND VPWR VPWR sky130_fd_sc_hd__decap_3
XFILLER_41_367 VGND VGND VPWR VPWR sky130_fd_sc_hd__fill_2
XFILLER_14_41 VGND VGND VPWR VPWR sky130_fd_sc_hd__decap_3
XFILLER_14_74 VGND VGND VPWR VPWR sky130_fd_sc_hd__decap_3
XFILLER_14_85 VGND VGND VPWR VPWR sky130_fd_sc_hd__decap_3
XFILLER_5_246 VGND VGND VPWR VPWR sky130_fd_sc_hd__decap_3
XFILLER_5_279 VGND VGND VPWR VPWR sky130_fd_sc_hd__fill_1
XFILLER_1_430 VGND VGND VPWR VPWR sky130_fd_sc_hd__fill_1
XFILLER_1_452 VGND VGND VPWR VPWR sky130_fd_sc_hd__fill_1
XFILLER_36_106 VGND VGND VPWR VPWR sky130_fd_sc_hd__fill_1
XTAP_TAPCELL_ROW_75_911 VGND VPWR sky130_fd_sc_hd__tapvpwrvgnd_1
XFILLER_76_253 VGND VGND VPWR VPWR sky130_fd_sc_hd__fill_2
XFILLER_36_139 VGND VGND VPWR VPWR sky130_fd_sc_hd__fill_1
XTAP_TAPCELL_ROW_47_646 VGND VPWR sky130_fd_sc_hd__tapvpwrvgnd_1
XFILLER_32_312 VGND VGND VPWR VPWR sky130_fd_sc_hd__decap_3
XFILLER_72_492 VGND VGND VPWR VPWR sky130_fd_sc_hd__decap_3
XFILLER_32_345 VGND VGND VPWR VPWR sky130_fd_sc_hd__decap_3
XFILLER_20_518 VGND VGND VPWR VPWR sky130_fd_sc_hd__decap_3
XFILLER_32_389 VGND VGND VPWR VPWR sky130_fd_sc_hd__fill_1
X_3760_ _3760_/A _3975_/S VGND VGND VPWR VPWR _3762_/B sky130_fd_sc_hd__or2_2
X_2711_ _5286_/Q _2465_/X _5284_/Q VGND VGND VPWR VPWR _2712_/B sky130_fd_sc_hd__a21oi_2
X_3691_ _4166_/A _4200_/B VGND VGND VPWR VPWR _3715_/A sky130_fd_sc_hd__nand2b_2
X_2642_ _5165_/Q _3701_/A VGND VGND VPWR VPWR _2642_/Y sky130_fd_sc_hd__nand2_2
X_2573_ _4954_/Q _4938_/Q _4922_/Q _4906_/Q _2676_/S0 _2676_/S1 VGND VGND VPWR VPWR
+ _2573_/X sky130_fd_sc_hd__mux4_2
XTAP_TAPCELL_ROW_10_292 VGND VPWR sky130_fd_sc_hd__tapvpwrvgnd_1
X_4312_ _4312_/A _4312_/B VGND VGND VPWR VPWR _4312_/Y sky130_fd_sc_hd__nand2_2
X_4243_ _4266_/S _4193_/X _4241_/Y _4242_/Y VGND VGND VPWR VPWR _4243_/X sky130_fd_sc_hd__a22o_2
XFILLER_87_529 VGND VGND VPWR VPWR sky130_fd_sc_hd__decap_3
XFILLER_67_220 VGND VGND VPWR VPWR sky130_fd_sc_hd__decap_3
XFILLER_67_231 VGND VGND VPWR VPWR sky130_fd_sc_hd__decap_3
X_4174_ _4173_/C _4174_/B _4174_/C VGND VGND VPWR VPWR _4185_/B sky130_fd_sc_hd__and3b_2
XFILLER_27_106 VGND VGND VPWR VPWR sky130_fd_sc_hd__decap_3
XFILLER_67_275 VGND VGND VPWR VPWR sky130_fd_sc_hd__decap_3
X_3125_ _2911_/X _3121_/B _3121_/Y _5034_/Q VGND VGND VPWR VPWR _5034_/D sky130_fd_sc_hd__a22o_2
XTAP_TAPCELL_ROW_2_216 VGND VPWR sky130_fd_sc_hd__tapvpwrvgnd_1
X_3056_ _2924_/X _3048_/B _3048_/Y _4974_/Q VGND VGND VPWR VPWR _4974_/D sky130_fd_sc_hd__a22o_2
XFILLER_82_234 VGND VGND VPWR VPWR sky130_fd_sc_hd__fill_1
XFILLER_35_29 VGND VGND VPWR VPWR sky130_fd_sc_hd__decap_3
XFILLER_70_418 VGND VGND VPWR VPWR sky130_fd_sc_hd__fill_2
XFILLER_82_278 VGND VGND VPWR VPWR sky130_fd_sc_hd__decap_3
XFILLER_82_256 VGND VGND VPWR VPWR sky130_fd_sc_hd__decap_3
XTAP_TAPCELL_ROW_18_370 VGND VPWR sky130_fd_sc_hd__tapvpwrvgnd_1
XFILLER_23_345 VGND VGND VPWR VPWR sky130_fd_sc_hd__fill_1
XFILLER_50_131 VGND VGND VPWR VPWR sky130_fd_sc_hd__decap_3
XTAP_TAPCELL_ROW_81_969 VGND VPWR sky130_fd_sc_hd__tapvpwrvgnd_1
XFILLER_50_175 VGND VGND VPWR VPWR sky130_fd_sc_hd__decap_3
XFILLER_51_17 VGND VGND VPWR VPWR sky130_fd_sc_hd__fill_1
XFILLER_50_197 VGND VGND VPWR VPWR sky130_fd_sc_hd__decap_3
X_3958_ _3958_/A _3958_/B VGND VGND VPWR VPWR _3958_/Y sky130_fd_sc_hd__xnor2_2
X_3889_ _3889_/A _3889_/B VGND VGND VPWR VPWR _3889_/Y sky130_fd_sc_hd__nor2_2
X_2909_ _4873_/Q _2942_/A2 _2908_/X _2951_/B2 VGND VGND VPWR VPWR _4873_/D sky130_fd_sc_hd__a22o_2
XTAP_TAPCELL_ROW_92_1077 VGND VPWR sky130_fd_sc_hd__tapvpwrvgnd_1
XFILLER_78_507 VGND VGND VPWR VPWR sky130_fd_sc_hd__decap_3
XFILLER_58_242 VGND VGND VPWR VPWR sky130_fd_sc_hd__decap_3
XFILLER_58_253 VGND VGND VPWR VPWR sky130_fd_sc_hd__decap_3
XFILLER_61_418 VGND VGND VPWR VPWR sky130_fd_sc_hd__decap_3
XFILLER_14_312 VGND VGND VPWR VPWR sky130_fd_sc_hd__decap_3
XFILLER_26_150 VGND VGND VPWR VPWR sky130_fd_sc_hd__fill_2
XFILLER_26_172 VGND VGND VPWR VPWR sky130_fd_sc_hd__decap_3
XFILLER_54_470 VGND VGND VPWR VPWR sky130_fd_sc_hd__decap_3
XTAP_TAPCELL_ROW_44_616 VGND VPWR sky130_fd_sc_hd__tapvpwrvgnd_1
XFILLER_92_57 VGND VGND VPWR VPWR sky130_fd_sc_hd__decap_3
XFILLER_14_334 VGND VGND VPWR VPWR sky130_fd_sc_hd__decap_3
XFILLER_25_51 VGND VGND VPWR VPWR sky130_fd_sc_hd__decap_3
XFILLER_25_84 VGND VGND VPWR VPWR sky130_fd_sc_hd__decap_3
XTAP_TAPCELL_ROW_52_693 VGND VPWR sky130_fd_sc_hd__tapvpwrvgnd_1
XFILLER_6_533 VGND VGND VPWR VPWR sky130_fd_sc_hd__decap_3
XFILLER_6_555 VGND VGND VPWR VPWR sky130_fd_sc_hd__decap_3
Xclkbuf_0_CLK CLK VGND VGND VPWR VPWR clkbuf_0_CLK/X sky130_fd_sc_hd__clkbuf_16
XFILLER_1_260 VGND VGND VPWR VPWR sky130_fd_sc_hd__decap_3
XFILLER_49_242 VGND VGND VPWR VPWR sky130_fd_sc_hd__decap_3
XFILLER_37_437 VGND VGND VPWR VPWR sky130_fd_sc_hd__fill_2
XFILLER_92_521 VGND VGND VPWR VPWR sky130_fd_sc_hd__decap_3
XFILLER_52_407 VGND VGND VPWR VPWR sky130_fd_sc_hd__decap_3
XFILLER_64_245 VGND VGND VPWR VPWR sky130_fd_sc_hd__fill_2
XFILLER_64_256 VGND VGND VPWR VPWR sky130_fd_sc_hd__fill_1
XFILLER_92_554 VGND VGND VPWR VPWR sky130_fd_sc_hd__decap_3
XFILLER_17_161 VGND VGND VPWR VPWR sky130_fd_sc_hd__decap_3
XFILLER_45_470 VGND VGND VPWR VPWR sky130_fd_sc_hd__decap_3
X_4930_ _4994_/CLK _4930_/D VGND VGND VPWR VPWR _4930_/Q sky130_fd_sc_hd__dfxtp_2
X_4861_ _5170_/Q _4868_/A2 _4870_/B1 _3243_/X VGND VGND VPWR VPWR _5170_/D sky130_fd_sc_hd__o22a_2
XFILLER_32_153 VGND VGND VPWR VPWR sky130_fd_sc_hd__decap_3
XFILLER_60_451 VGND VGND VPWR VPWR sky130_fd_sc_hd__decap_3
X_3812_ _4239_/A _3811_/X _4261_/B VGND VGND VPWR VPWR _3812_/X sky130_fd_sc_hd__o21ba_2
XTAP_TAPCELL_ROW_15_340 VGND VPWR sky130_fd_sc_hd__tapvpwrvgnd_1
XFILLER_82_90 VGND VGND VPWR VPWR sky130_fd_sc_hd__decap_3
XFILLER_32_197 VGND VGND VPWR VPWR sky130_fd_sc_hd__decap_3
XFILLER_60_495 VGND VGND VPWR VPWR sky130_fd_sc_hd__fill_2
X_4792_ _5165_/Q _4792_/B VGND VGND VPWR VPWR _4793_/B sky130_fd_sc_hd__nand2_2
XFILLER_20_359 VGND VGND VPWR VPWR sky130_fd_sc_hd__decap_3
X_3743_ _4318_/A _4298_/A VGND VGND VPWR VPWR _3743_/Y sky130_fd_sc_hd__nand2_2
X_3674_ _3668_/X _3670_/X _3673_/X _2430_/Y VGND VGND VPWR VPWR _3676_/B sky130_fd_sc_hd__a22o_2
Xoutput101 _2749_/X VGND VGND VPWR VPWR MEM_STR_DATA[3] sky130_fd_sc_hd__clkdlybuf4s25_1
X_2625_ _5161_/Q _3829_/B VGND VGND VPWR VPWR _4015_/A sky130_fd_sc_hd__xnor2_2
X_2556_ _5067_/Q _5051_/Q _5035_/Q _5019_/Q _2676_/S0 _2676_/S1 VGND VGND VPWR VPWR
+ _2557_/B sky130_fd_sc_hd__mux4_2
X_5275_ _5285_/CLK _5275_/D VGND VGND VPWR VPWR _5275_/Q sky130_fd_sc_hd__dfxtp_2
X_2487_ _5125_/Q _5013_/Q _4997_/Q _4981_/Q _2676_/S0 _2676_/S1 VGND VGND VPWR VPWR
+ _2487_/X sky130_fd_sc_hd__mux4_2
XFILLER_87_304 VGND VGND VPWR VPWR sky130_fd_sc_hd__decap_3
X_4226_ _4227_/B _4227_/C VGND VGND VPWR VPWR _4226_/Y sky130_fd_sc_hd__nor2_2
XFILLER_87_348 VGND VGND VPWR VPWR sky130_fd_sc_hd__decap_3
X_4157_ _4114_/Y _4200_/D _4200_/B _4200_/C VGND VGND VPWR VPWR _4157_/X sky130_fd_sc_hd__a211o_2
XFILLER_55_234 VGND VGND VPWR VPWR sky130_fd_sc_hd__decap_3
X_3108_ _2914_/X _3119_/A2 _3103_/Y _5019_/Q VGND VGND VPWR VPWR _5019_/D sky130_fd_sc_hd__a22o_2
XFILLER_55_267 VGND VGND VPWR VPWR sky130_fd_sc_hd__decap_3
X_4088_ _4191_/A _2876_/B _4686_/B1 _4086_/Y _4087_/X VGND VGND VPWR VPWR _4088_/X
+ sky130_fd_sc_hd__o221a_2
XFILLER_55_289 VGND VGND VPWR VPWR sky130_fd_sc_hd__decap_3
XFILLER_70_204 VGND VGND VPWR VPWR sky130_fd_sc_hd__decap_3
X_3039_ _2931_/X _3029_/B _3029_/Y _4960_/Q VGND VGND VPWR VPWR _4960_/D sky130_fd_sc_hd__a22o_2
XFILLER_23_131 VGND VGND VPWR VPWR sky130_fd_sc_hd__fill_2
XFILLER_36_492 VGND VGND VPWR VPWR sky130_fd_sc_hd__decap_3
XFILLER_70_248 VGND VGND VPWR VPWR sky130_fd_sc_hd__decap_3
XFILLER_51_462 VGND VGND VPWR VPWR sky130_fd_sc_hd__decap_3
XFILLER_23_175 VGND VGND VPWR VPWR sky130_fd_sc_hd__fill_1
XFILLER_7_319 VGND VGND VPWR VPWR sky130_fd_sc_hd__decap_3
XFILLER_11_42 VGND VGND VPWR VPWR sky130_fd_sc_hd__fill_1
XTAP_TAPCELL_ROW_21_398 VGND VPWR sky130_fd_sc_hd__tapvpwrvgnd_1
XFILLER_3_514 VGND VGND VPWR VPWR sky130_fd_sc_hd__decap_3
XFILLER_3_547 VGND VGND VPWR VPWR sky130_fd_sc_hd__decap_3
XFILLER_87_57 VGND VGND VPWR VPWR sky130_fd_sc_hd__decap_3
XFILLER_78_315 VGND VGND VPWR VPWR sky130_fd_sc_hd__decap_3
XFILLER_86_392 VGND VGND VPWR VPWR sky130_fd_sc_hd__decap_3
XFILLER_34_407 VGND VGND VPWR VPWR sky130_fd_sc_hd__decap_3
XTAP_TAPCELL_ROW_57_741 VGND VPWR sky130_fd_sc_hd__tapvpwrvgnd_1
XFILLER_27_481 VGND VGND VPWR VPWR sky130_fd_sc_hd__decap_3
XFILLER_36_50 VGND VGND VPWR VPWR sky130_fd_sc_hd__decap_3
XTAP_TAPCELL_ROW_29_476 VGND VPWR sky130_fd_sc_hd__tapvpwrvgnd_1
XFILLER_61_237 VGND VGND VPWR VPWR sky130_fd_sc_hd__fill_2
XFILLER_61_259 VGND VGND VPWR VPWR sky130_fd_sc_hd__decap_3
XFILLER_42_451 VGND VGND VPWR VPWR sky130_fd_sc_hd__fill_2
XFILLER_42_495 VGND VGND VPWR VPWR sky130_fd_sc_hd__decap_3
XFILLER_52_82 VGND VGND VPWR VPWR sky130_fd_sc_hd__fill_2
Xinput36 MEM_LD_DATA[12] VGND VGND VPWR VPWR input36/X sky130_fd_sc_hd__clkdlybuf4s25_1
Xinput25 INSTR_STREAM[31] VGND VGND VPWR VPWR _3354_/C sky130_fd_sc_hd__clkdlybuf4s25_1
Xinput14 INSTR_STREAM[21] VGND VGND VPWR VPWR _3249_/C sky130_fd_sc_hd__clkdlybuf4s25_1
Xinput47 MEM_LD_DATA[8] VGND VGND VPWR VPWR input47/X sky130_fd_sc_hd__clkdlybuf4s25_1
X_3390_ _5158_/Q _5139_/Q VGND VGND VPWR VPWR _3393_/B sky130_fd_sc_hd__or2_2
XFILLER_69_337 VGND VGND VPWR VPWR sky130_fd_sc_hd__fill_2
X_5060_ _5241_/CLK _5060_/D VGND VGND VPWR VPWR _5060_/Q sky130_fd_sc_hd__dfxtp_2
X_4011_ _4011_/A _4011_/B VGND VGND VPWR VPWR _4011_/X sky130_fd_sc_hd__or2_2
XFILLER_84_318 VGND VGND VPWR VPWR sky130_fd_sc_hd__decap_3
XFILLER_65_510 VGND VGND VPWR VPWR sky130_fd_sc_hd__decap_3
XFILLER_65_532 VGND VGND VPWR VPWR sky130_fd_sc_hd__fill_1
XFILLER_65_554 VGND VGND VPWR VPWR sky130_fd_sc_hd__decap_3
XFILLER_37_278 VGND VGND VPWR VPWR sky130_fd_sc_hd__fill_2
XFILLER_80_513 VGND VGND VPWR VPWR sky130_fd_sc_hd__decap_3
XFILLER_18_492 VGND VGND VPWR VPWR sky130_fd_sc_hd__decap_3
XFILLER_52_237 VGND VGND VPWR VPWR sky130_fd_sc_hd__decap_3
XFILLER_52_248 VGND VGND VPWR VPWR sky130_fd_sc_hd__decap_3
X_4913_ clkload3/A _4913_/D VGND VGND VPWR VPWR _4913_/Q sky130_fd_sc_hd__dfxtp_2
XFILLER_92_395 VGND VGND VPWR VPWR sky130_fd_sc_hd__decap_3
XFILLER_80_557 VGND VGND VPWR VPWR sky130_fd_sc_hd__fill_1
X_4844_ _4835_/A _4838_/X _4842_/X _4854_/B VGND VGND VPWR VPWR _4844_/X sky130_fd_sc_hd__a31o_2
XTAP_TAPCELL_ROW_63_799 VGND VPWR sky130_fd_sc_hd__tapvpwrvgnd_1
X_4775_ _5264_/Q _4847_/B _4774_/Y _3338_/B VGND VGND VPWR VPWR _5264_/D sky130_fd_sc_hd__o211a_2
XFILLER_20_167 VGND VGND VPWR VPWR sky130_fd_sc_hd__fill_2
X_3726_ _3726_/A _4581_/S VGND VGND VPWR VPWR _4090_/A sky130_fd_sc_hd__nor2_2
XFILLER_9_190 VGND VGND VPWR VPWR sky130_fd_sc_hd__decap_3
X_3657_ _5077_/Q _5061_/Q _5045_/Q _5029_/Q _3706_/S0 _3706_/S1 VGND VGND VPWR VPWR
+ _3657_/X sky130_fd_sc_hd__mux4_2
X_3588_ _3889_/A _4340_/S VGND VGND VPWR VPWR _3749_/A sky130_fd_sc_hd__nor2_2
X_2608_ _4951_/Q _4935_/Q _4919_/Q _4903_/Q _2676_/S0 _2676_/S1 VGND VGND VPWR VPWR
+ _2608_/X sky130_fd_sc_hd__mux4_2
XFILLER_0_517 VGND VGND VPWR VPWR sky130_fd_sc_hd__decap_3
X_2539_ _2537_/X _2538_/X _5129_/Q VGND VGND VPWR VPWR _2539_/X sky130_fd_sc_hd__mux2_1
XFILLER_0_539 VGND VGND VPWR VPWR sky130_fd_sc_hd__decap_3
XFILLER_87_134 VGND VGND VPWR VPWR sky130_fd_sc_hd__decap_3
X_5258_ _5260_/CLK _5258_/D VGND VGND VPWR VPWR _5258_/Q sky130_fd_sc_hd__dfxtp_2
XFILLER_87_167 VGND VGND VPWR VPWR sky130_fd_sc_hd__fill_1
XFILLER_75_329 VGND VGND VPWR VPWR sky130_fd_sc_hd__fill_2
X_4209_ _4847_/B _4209_/B VGND VGND VPWR VPWR _4209_/Y sky130_fd_sc_hd__nand2_2
X_5189_ _5208_/CLK _5189_/D VGND VGND VPWR VPWR _5189_/Q sky130_fd_sc_hd__dfxtp_2
XFILLER_28_256 VGND VGND VPWR VPWR sky130_fd_sc_hd__decap_3
XFILLER_16_418 VGND VGND VPWR VPWR sky130_fd_sc_hd__fill_2
XFILLER_16_429 VGND VGND VPWR VPWR sky130_fd_sc_hd__decap_3
XFILLER_43_215 VGND VGND VPWR VPWR sky130_fd_sc_hd__decap_3
XFILLER_71_502 VGND VGND VPWR VPWR sky130_fd_sc_hd__fill_2
XFILLER_73_26 VGND VGND VPWR VPWR sky130_fd_sc_hd__decap_3
XTAP_TAPCELL_ROW_54_711 VGND VPWR sky130_fd_sc_hd__tapvpwrvgnd_1
XFILLER_71_557 VGND VGND VPWR VPWR sky130_fd_sc_hd__fill_1
XTAP_TAPCELL_ROW_26_446 VGND VPWR sky130_fd_sc_hd__tapvpwrvgnd_1
XFILLER_24_462 VGND VGND VPWR VPWR sky130_fd_sc_hd__decap_3
XFILLER_51_281 VGND VGND VPWR VPWR sky130_fd_sc_hd__decap_3
XFILLER_7_116 VGND VGND VPWR VPWR sky130_fd_sc_hd__decap_3
XFILLER_66_307 VGND VGND VPWR VPWR sky130_fd_sc_hd__fill_1
XFILLER_66_318 VGND VGND VPWR VPWR sky130_fd_sc_hd__fill_1
XFILLER_14_9 VGND VGND VPWR VPWR sky130_fd_sc_hd__decap_3
XFILLER_59_370 VGND VGND VPWR VPWR sky130_fd_sc_hd__decap_3
XFILLER_59_381 VGND VGND VPWR VPWR sky130_fd_sc_hd__decap_3
XFILLER_62_502 VGND VGND VPWR VPWR sky130_fd_sc_hd__decap_3
XFILLER_62_524 VGND VGND VPWR VPWR sky130_fd_sc_hd__decap_3
XFILLER_34_248 VGND VGND VPWR VPWR sky130_fd_sc_hd__decap_3
XFILLER_74_395 VGND VGND VPWR VPWR sky130_fd_sc_hd__decap_3
XFILLER_34_259 VGND VGND VPWR VPWR sky130_fd_sc_hd__decap_3
XFILLER_30_410 VGND VGND VPWR VPWR sky130_fd_sc_hd__decap_3
XFILLER_30_421 VGND VGND VPWR VPWR sky130_fd_sc_hd__decap_3
XFILLER_63_81 VGND VGND VPWR VPWR sky130_fd_sc_hd__decap_3
X_2890_ _2890_/A _4191_/B _3779_/A VGND VGND VPWR VPWR _2892_/B sky130_fd_sc_hd__or3_2
XFILLER_30_454 VGND VGND VPWR VPWR sky130_fd_sc_hd__decap_3
XTAP_TAPCELL_ROW_60_769 VGND VPWR sky130_fd_sc_hd__tapvpwrvgnd_1
XFILLER_8_21 VGND VGND VPWR VPWR sky130_fd_sc_hd__decap_3
XFILLER_30_498 VGND VGND VPWR VPWR sky130_fd_sc_hd__fill_1
X_4560_ _4191_/A _2629_/B _3778_/D _2629_/A _4559_/X VGND VGND VPWR VPWR _4567_/A
+ sky130_fd_sc_hd__o221a_2
XFILLER_8_76 VGND VGND VPWR VPWR sky130_fd_sc_hd__decap_3
X_4491_ _3924_/X _4469_/Y _4490_/X _4278_/X VGND VGND VPWR VPWR _4491_/X sky130_fd_sc_hd__a31o_2
X_3511_ _5113_/Q _5001_/Q _4985_/Q _4969_/Q _3732_/S0 _3732_/S1 VGND VGND VPWR VPWR
+ _3511_/X sky130_fd_sc_hd__mux4_2
XFILLER_6_193 VGND VGND VPWR VPWR sky130_fd_sc_hd__decap_3
X_3442_ _4692_/A _3442_/B VGND VGND VPWR VPWR _5202_/D sky130_fd_sc_hd__nor2_2
X_3373_ _5190_/Q _4275_/B _3372_/X _3366_/A VGND VGND VPWR VPWR _5190_/D sky130_fd_sc_hd__o211a_2
X_5112_ _5117_/CLK _5112_/D VGND VGND VPWR VPWR _5112_/Q sky130_fd_sc_hd__dfxtp_2
XFILLER_57_318 VGND VGND VPWR VPWR sky130_fd_sc_hd__decap_3
XFILLER_69_156 VGND VGND VPWR VPWR sky130_fd_sc_hd__decap_3
XFILLER_38_521 VGND VGND VPWR VPWR sky130_fd_sc_hd__decap_3
X_5043_ _5110_/CLK _5043_/D VGND VGND VPWR VPWR _5043_/Q sky130_fd_sc_hd__dfxtp_2
XTAP_TAPCELL_ROW_68_847 VGND VPWR sky130_fd_sc_hd__tapvpwrvgnd_1
XFILLER_65_340 VGND VGND VPWR VPWR sky130_fd_sc_hd__decap_3
XFILLER_65_373 VGND VGND VPWR VPWR sky130_fd_sc_hd__decap_3
XFILLER_53_557 VGND VGND VPWR VPWR sky130_fd_sc_hd__fill_1
XFILLER_80_376 VGND VGND VPWR VPWR sky130_fd_sc_hd__decap_3
XFILLER_80_354 VGND VGND VPWR VPWR sky130_fd_sc_hd__decap_3
XFILLER_33_281 VGND VGND VPWR VPWR sky130_fd_sc_hd__decap_3
XTAP_TAPCELL_ROW_23_416 VGND VPWR sky130_fd_sc_hd__tapvpwrvgnd_1
X_4827_ _4827_/A VGND VGND VPWR VPWR _4829_/A sky130_fd_sc_hd__inv_2
XFILLER_21_476 VGND VGND VPWR VPWR sky130_fd_sc_hd__decap_3
X_4758_ _4758_/A _4758_/B VGND VGND VPWR VPWR _4758_/X sky130_fd_sc_hd__xor2_2
XTAP_TAPCELL_ROW_31_493 VGND VPWR sky130_fd_sc_hd__tapvpwrvgnd_1
X_4689_ _3515_/X _4225_/A _4078_/C _4685_/X _4688_/X VGND VGND VPWR VPWR _4689_/X
+ sky130_fd_sc_hd__o311a_2
X_3709_ _5119_/Q _5007_/Q _4991_/Q _4975_/Q _3732_/S0 _3732_/S1 VGND VGND VPWR VPWR
+ _3709_/X sky130_fd_sc_hd__mux4_2
XFILLER_88_410 VGND VGND VPWR VPWR sky130_fd_sc_hd__decap_3
XFILLER_88_454 VGND VGND VPWR VPWR sky130_fd_sc_hd__decap_3
XFILLER_29_510 VGND VGND VPWR VPWR sky130_fd_sc_hd__decap_3
XFILLER_48_318 VGND VGND VPWR VPWR sky130_fd_sc_hd__decap_3
XFILLER_29_554 VGND VGND VPWR VPWR sky130_fd_sc_hd__decap_3
XTAP_TAPCELL_ROW_89_1049 VGND VPWR sky130_fd_sc_hd__tapvpwrvgnd_1
XFILLER_84_36 VGND VGND VPWR VPWR sky130_fd_sc_hd__decap_3
XFILLER_16_215 VGND VGND VPWR VPWR sky130_fd_sc_hd__decap_3
XFILLER_56_351 VGND VGND VPWR VPWR sky130_fd_sc_hd__decap_3
XTAP_TAPCELL_ROW_39_571 VGND VPWR sky130_fd_sc_hd__tapvpwrvgnd_1
XFILLER_17_74 VGND VGND VPWR VPWR sky130_fd_sc_hd__decap_3
XFILLER_44_557 VGND VGND VPWR VPWR sky130_fd_sc_hd__fill_1
XFILLER_56_384 VGND VGND VPWR VPWR sky130_fd_sc_hd__fill_1
XFILLER_56_395 VGND VGND VPWR VPWR sky130_fd_sc_hd__decap_3
XFILLER_71_321 VGND VGND VPWR VPWR sky130_fd_sc_hd__decap_3
XFILLER_71_343 VGND VGND VPWR VPWR sky130_fd_sc_hd__decap_3
XFILLER_83_181 VGND VGND VPWR VPWR sky130_fd_sc_hd__decap_3
XFILLER_16_259 VGND VGND VPWR VPWR sky130_fd_sc_hd__decap_3
XFILLER_71_376 VGND VGND VPWR VPWR sky130_fd_sc_hd__decap_3
XFILLER_12_421 VGND VGND VPWR VPWR sky130_fd_sc_hd__decap_3
XFILLER_24_292 VGND VGND VPWR VPWR sky130_fd_sc_hd__decap_3
XFILLER_33_73 VGND VGND VPWR VPWR sky130_fd_sc_hd__decap_3
XFILLER_8_414 VGND VGND VPWR VPWR sky130_fd_sc_hd__decap_3
XFILLER_3_130 VGND VGND VPWR VPWR sky130_fd_sc_hd__fill_1
XFILLER_79_432 VGND VGND VPWR VPWR sky130_fd_sc_hd__decap_3
XFILLER_12_6 VGND VGND VPWR VPWR sky130_fd_sc_hd__decap_3
XFILLER_66_159 VGND VGND VPWR VPWR sky130_fd_sc_hd__decap_3
XTAP_TAPCELL_ROW_65_817 VGND VPWR sky130_fd_sc_hd__tapvpwrvgnd_1
XFILLER_62_321 VGND VGND VPWR VPWR sky130_fd_sc_hd__decap_3
XFILLER_50_505 VGND VGND VPWR VPWR sky130_fd_sc_hd__fill_2
XFILLER_62_365 VGND VGND VPWR VPWR sky130_fd_sc_hd__decap_3
XFILLER_74_80 VGND VGND VPWR VPWR sky130_fd_sc_hd__decap_3
XFILLER_74_91 VGND VGND VPWR VPWR sky130_fd_sc_hd__decap_3
X_3991_ _4346_/B _4390_/A _4449_/S VGND VGND VPWR VPWR _3992_/A sky130_fd_sc_hd__mux2_1
XFILLER_22_218 VGND VGND VPWR VPWR sky130_fd_sc_hd__decap_3
XFILLER_50_549 VGND VGND VPWR VPWR sky130_fd_sc_hd__fill_1
XFILLER_62_387 VGND VGND VPWR VPWR sky130_fd_sc_hd__decap_3
X_2942_ _4883_/Q _2942_/A2 _2941_/X _2951_/B2 VGND VGND VPWR VPWR _4883_/D sky130_fd_sc_hd__a22o_2
XTAP_TAPCELL_ROW_73_894 VGND VPWR sky130_fd_sc_hd__tapvpwrvgnd_1
XFILLER_15_292 VGND VGND VPWR VPWR sky130_fd_sc_hd__decap_3
XFILLER_30_251 VGND VGND VPWR VPWR sky130_fd_sc_hd__fill_1
X_2873_ _2873_/A _2873_/B VGND VGND VPWR VPWR _2873_/Y sky130_fd_sc_hd__nor2_2
XFILLER_30_295 VGND VGND VPWR VPWR sky130_fd_sc_hd__decap_3
X_4612_ _4610_/X _4611_/Y _4692_/A VGND VGND VPWR VPWR _5235_/D sky130_fd_sc_hd__a21oi_2
X_4543_ _4543_/A VGND VGND VPWR VPWR _4543_/Y sky130_fd_sc_hd__inv_2
Xmax_cap122 _4638_/S VGND VGND VPWR VPWR _3866_/B sky130_fd_sc_hd__buf_12
Xmax_cap111 _4275_/B VGND VGND VPWR VPWR _4847_/B sky130_fd_sc_hd__buf_12
X_4474_ _3363_/A _4213_/A _4474_/S VGND VGND VPWR VPWR _4474_/X sky130_fd_sc_hd__mux2_1
Xmax_cap155 _4393_/A VGND VGND VPWR VPWR _3825_/B sky130_fd_sc_hd__buf_8
Xmax_cap166 _3693_/A VGND VGND VPWR VPWR _3733_/S sky130_fd_sc_hd__buf_8
Xmax_cap177 _5131_/Q VGND VGND VPWR VPWR _3706_/S0 sky130_fd_sc_hd__buf_12
X_3425_ _3458_/A _3423_/Y _3424_/X _4275_/B _2424_/Y VGND VGND VPWR VPWR _3426_/B
+ sky130_fd_sc_hd__o32a_2
X_3356_ _3363_/A _4213_/A _2873_/A VGND VGND VPWR VPWR _3361_/B sky130_fd_sc_hd__a21oi_2
X_3287_ _5146_/Q _3297_/B _5147_/Q VGND VGND VPWR VPWR _3287_/Y sky130_fd_sc_hd__a21oi_2
X_5026_ clkload8/A _5026_/D VGND VGND VPWR VPWR _5026_/Q sky130_fd_sc_hd__dfxtp_2
XFILLER_26_502 VGND VGND VPWR VPWR sky130_fd_sc_hd__decap_3
XFILLER_38_351 VGND VGND VPWR VPWR sky130_fd_sc_hd__decap_3
XFILLER_72_118 VGND VGND VPWR VPWR sky130_fd_sc_hd__decap_3
XFILLER_53_332 VGND VGND VPWR VPWR sky130_fd_sc_hd__decap_3
XFILLER_65_181 VGND VGND VPWR VPWR sky130_fd_sc_hd__decap_3
XFILLER_13_207 VGND VGND VPWR VPWR sky130_fd_sc_hd__decap_3
XFILLER_26_557 VGND VGND VPWR VPWR sky130_fd_sc_hd__fill_1
XFILLER_41_505 VGND VGND VPWR VPWR sky130_fd_sc_hd__fill_1
XTAP_TAPCELL_ROW_36_541 VGND VPWR sky130_fd_sc_hd__tapvpwrvgnd_1
XTAP_TAPCELL_ROW_0_188 VGND VPWR sky130_fd_sc_hd__tapvpwrvgnd_1
XFILLER_53_398 VGND VGND VPWR VPWR sky130_fd_sc_hd__fill_1
XTAP_TAPCELL_ROW_0_199 VGND VPWR sky130_fd_sc_hd__tapvpwrvgnd_1
XFILLER_80_184 VGND VGND VPWR VPWR sky130_fd_sc_hd__decap_3
XFILLER_21_251 VGND VGND VPWR VPWR sky130_fd_sc_hd__decap_3
XFILLER_70_27 VGND VGND VPWR VPWR sky130_fd_sc_hd__fill_1
XFILLER_70_38 VGND VGND VPWR VPWR sky130_fd_sc_hd__decap_3
XFILLER_21_284 VGND VGND VPWR VPWR sky130_fd_sc_hd__decap_3
XFILLER_5_417 VGND VGND VPWR VPWR sky130_fd_sc_hd__decap_3
XFILLER_79_25 VGND VGND VPWR VPWR sky130_fd_sc_hd__decap_3
XFILLER_0_100 VGND VGND VPWR VPWR sky130_fd_sc_hd__decap_3
XFILLER_0_122 VGND VGND VPWR VPWR sky130_fd_sc_hd__decap_3
XFILLER_0_144 VGND VGND VPWR VPWR sky130_fd_sc_hd__decap_3
XTAP_TAPCELL_ROW_8_277 VGND VPWR sky130_fd_sc_hd__tapvpwrvgnd_1
XFILLER_88_251 VGND VGND VPWR VPWR sky130_fd_sc_hd__fill_1
XFILLER_48_115 VGND VGND VPWR VPWR sky130_fd_sc_hd__decap_3
XFILLER_76_424 VGND VGND VPWR VPWR sky130_fd_sc_hd__decap_3
XFILLER_76_413 VGND VGND VPWR VPWR sky130_fd_sc_hd__decap_3
XFILLER_48_159 VGND VGND VPWR VPWR sky130_fd_sc_hd__decap_3
XFILLER_76_468 VGND VGND VPWR VPWR sky130_fd_sc_hd__decap_3
XFILLER_17_502 VGND VGND VPWR VPWR sky130_fd_sc_hd__fill_2
XFILLER_29_340 VGND VGND VPWR VPWR sky130_fd_sc_hd__fill_2
XFILLER_17_524 VGND VGND VPWR VPWR sky130_fd_sc_hd__decap_3
XFILLER_29_384 VGND VGND VPWR VPWR sky130_fd_sc_hd__fill_2
XFILLER_56_170 VGND VGND VPWR VPWR sky130_fd_sc_hd__fill_1
XFILLER_56_192 VGND VGND VPWR VPWR sky130_fd_sc_hd__decap_3
XFILLER_91_449 VGND VGND VPWR VPWR sky130_fd_sc_hd__fill_2
XFILLER_44_343 VGND VGND VPWR VPWR sky130_fd_sc_hd__decap_3
XFILLER_44_354 VGND VGND VPWR VPWR sky130_fd_sc_hd__fill_2
XFILLER_44_365 VGND VGND VPWR VPWR sky130_fd_sc_hd__decap_3
XFILLER_71_151 VGND VGND VPWR VPWR sky130_fd_sc_hd__decap_3
XFILLER_32_516 VGND VGND VPWR VPWR sky130_fd_sc_hd__decap_3
XFILLER_44_83 VGND VGND VPWR VPWR sky130_fd_sc_hd__fill_1
XTAP_TAPCELL_ROW_70_864 VGND VPWR sky130_fd_sc_hd__tapvpwrvgnd_1
XFILLER_12_240 VGND VGND VPWR VPWR sky130_fd_sc_hd__decap_3
XFILLER_81_9 VGND VGND VPWR VPWR sky130_fd_sc_hd__decap_3
XTAP_TAPCELL_ROW_42_599 VGND VPWR sky130_fd_sc_hd__tapvpwrvgnd_1
XFILLER_5_22 VGND VGND VPWR VPWR sky130_fd_sc_hd__fill_2
XFILLER_4_472 VGND VGND VPWR VPWR sky130_fd_sc_hd__decap_3
XFILLER_4_494 VGND VGND VPWR VPWR sky130_fd_sc_hd__decap_3
XFILLER_69_91 VGND VGND VPWR VPWR sky130_fd_sc_hd__decap_3
X_4190_ _4207_/A _4188_/B _4189_/Y VGND VGND VPWR VPWR _4190_/X sky130_fd_sc_hd__a21o_2
X_3210_ _3210_/A _3210_/B VGND VGND VPWR VPWR _3211_/B sky130_fd_sc_hd__nor2_4
XFILLER_79_240 VGND VGND VPWR VPWR sky130_fd_sc_hd__decap_3
XFILLER_67_402 VGND VGND VPWR VPWR sky130_fd_sc_hd__decap_3
X_3141_ _2905_/X _3155_/A2 _3139_/Y _5048_/Q VGND VGND VPWR VPWR _5048_/D sky130_fd_sc_hd__a22o_2
XFILLER_79_284 VGND VGND VPWR VPWR sky130_fd_sc_hd__decap_3
XFILLER_79_273 VGND VGND VPWR VPWR sky130_fd_sc_hd__decap_3
XFILLER_10_3 VGND VGND VPWR VPWR sky130_fd_sc_hd__fill_2
XFILLER_67_435 VGND VGND VPWR VPWR sky130_fd_sc_hd__decap_3
XTAP_TAPCELL_ROW_78_942 VGND VPWR sky130_fd_sc_hd__tapvpwrvgnd_1
XFILLER_54_118 VGND VGND VPWR VPWR sky130_fd_sc_hd__fill_1
X_3072_ _2918_/X _3066_/B _3066_/Y _4988_/Q VGND VGND VPWR VPWR _4988_/D sky130_fd_sc_hd__a22o_2
XFILLER_82_427 VGND VGND VPWR VPWR sky130_fd_sc_hd__decap_3
XFILLER_82_449 VGND VGND VPWR VPWR sky130_fd_sc_hd__fill_1
XFILLER_35_343 VGND VGND VPWR VPWR sky130_fd_sc_hd__fill_2
XFILLER_62_184 VGND VGND VPWR VPWR sky130_fd_sc_hd__decap_3
XTAP_TAPCELL_ROW_33_511 VGND VPWR sky130_fd_sc_hd__tapvpwrvgnd_1
XFILLER_90_482 VGND VGND VPWR VPWR sky130_fd_sc_hd__decap_3
XFILLER_50_357 VGND VGND VPWR VPWR sky130_fd_sc_hd__decap_3
XFILLER_62_195 VGND VGND VPWR VPWR sky130_fd_sc_hd__fill_1
X_3974_ _4390_/A _3867_/A _4449_/S VGND VGND VPWR VPWR _3974_/X sky130_fd_sc_hd__mux2_1
X_2925_ _4878_/Q _2942_/A2 _2924_/X _2951_/B2 VGND VGND VPWR VPWR _4878_/D sky130_fd_sc_hd__a22o_2
X_2856_ _2850_/X _2852_/X _2855_/X _2435_/Y VGND VGND VPWR VPWR _4842_/B sky130_fd_sc_hd__a22o_2
X_2787_ _4895_/Q _4879_/Q _5103_/Q _5087_/Q _2854_/S0 _5136_/Q VGND VGND VPWR VPWR
+ _2787_/X sky130_fd_sc_hd__mux4_2
X_4526_ _4312_/Y _4524_/X _4525_/X _4312_/A VGND VGND VPWR VPWR _4526_/X sky130_fd_sc_hd__a22o_2
X_4457_ _5228_/Q _4854_/B VGND VGND VPWR VPWR _4457_/Y sky130_fd_sc_hd__nand2_2
X_3408_ _3408_/A _3408_/B VGND VGND VPWR VPWR _3408_/Y sky130_fd_sc_hd__xnor2_2
XFILLER_58_424 VGND VGND VPWR VPWR sky130_fd_sc_hd__decap_3
X_4388_ _4361_/Y _4364_/Y _4386_/B _4386_/A VGND VGND VPWR VPWR _4389_/B sky130_fd_sc_hd__o211a_2
X_3339_ _5167_/Q _3230_/B _3230_/Y _3338_/X VGND VGND VPWR VPWR _5167_/D sky130_fd_sc_hd__o22a_2
XTAP_TAPCELL_ROW_5_247 VGND VPWR sky130_fd_sc_hd__tapvpwrvgnd_1
XFILLER_73_405 VGND VGND VPWR VPWR sky130_fd_sc_hd__decap_3
XFILLER_85_276 VGND VGND VPWR VPWR sky130_fd_sc_hd__decap_3
XFILLER_73_449 VGND VGND VPWR VPWR sky130_fd_sc_hd__decap_3
X_5009_ clkload5/A _5009_/D VGND VGND VPWR VPWR _5009_/Q sky130_fd_sc_hd__dfxtp_2
XTAP_TAPCELL_ROW_86_1019 VGND VPWR sky130_fd_sc_hd__tapvpwrvgnd_1
XFILLER_26_332 VGND VGND VPWR VPWR sky130_fd_sc_hd__decap_3
XFILLER_26_365 VGND VGND VPWR VPWR sky130_fd_sc_hd__decap_3
XFILLER_81_460 VGND VGND VPWR VPWR sky130_fd_sc_hd__decap_3
XFILLER_14_549 VGND VGND VPWR VPWR sky130_fd_sc_hd__decap_3
XFILLER_14_53 VGND VGND VPWR VPWR sky130_fd_sc_hd__decap_3
XFILLER_14_97 VGND VGND VPWR VPWR sky130_fd_sc_hd__decap_3
XFILLER_30_41 VGND VGND VPWR VPWR sky130_fd_sc_hd__decap_3
XFILLER_5_225 VGND VGND VPWR VPWR sky130_fd_sc_hd__decap_3
XFILLER_30_85 VGND VGND VPWR VPWR sky130_fd_sc_hd__fill_1
XFILLER_49_413 VGND VGND VPWR VPWR sky130_fd_sc_hd__decap_3
XFILLER_1_497 VGND VGND VPWR VPWR sky130_fd_sc_hd__decap_3
XFILLER_64_416 VGND VGND VPWR VPWR sky130_fd_sc_hd__decap_3
XTAP_TAPCELL_ROW_75_912 VGND VPWR sky130_fd_sc_hd__tapvpwrvgnd_1
XFILLER_76_265 VGND VGND VPWR VPWR sky130_fd_sc_hd__decap_3
XFILLER_64_438 VGND VGND VPWR VPWR sky130_fd_sc_hd__decap_3
XTAP_TAPCELL_ROW_47_647 VGND VPWR sky130_fd_sc_hd__tapvpwrvgnd_1
XFILLER_17_343 VGND VGND VPWR VPWR sky130_fd_sc_hd__decap_3
XFILLER_17_387 VGND VGND VPWR VPWR sky130_fd_sc_hd__decap_3
XFILLER_32_302 VGND VGND VPWR VPWR sky130_fd_sc_hd__decap_3
XFILLER_55_93 VGND VGND VPWR VPWR sky130_fd_sc_hd__fill_2
XFILLER_72_460 VGND VGND VPWR VPWR sky130_fd_sc_hd__fill_2
XFILLER_72_471 VGND VGND VPWR VPWR sky130_fd_sc_hd__decap_3
XFILLER_32_324 VGND VGND VPWR VPWR sky130_fd_sc_hd__decap_3
XFILLER_44_184 VGND VGND VPWR VPWR sky130_fd_sc_hd__decap_3
XFILLER_32_368 VGND VGND VPWR VPWR sky130_fd_sc_hd__decap_3
X_2710_ _3494_/A _5281_/Q VGND VGND VPWR VPWR _5280_/D sky130_fd_sc_hd__or2_2
XFILLER_9_531 VGND VGND VPWR VPWR sky130_fd_sc_hd__decap_3
X_3690_ _4619_/S _4166_/B VGND VGND VPWR VPWR _4200_/B sky130_fd_sc_hd__or2_2
X_2641_ _5165_/Q _3701_/A VGND VGND VPWR VPWR _2645_/A sky130_fd_sc_hd__and2_2
X_2572_ _5114_/Q _5002_/Q _4986_/Q _4970_/Q _2676_/S0 _2676_/S1 VGND VGND VPWR VPWR
+ _2572_/X sky130_fd_sc_hd__mux4_2
XTAP_TAPCELL_ROW_10_293 VGND VPWR sky130_fd_sc_hd__tapvpwrvgnd_1
X_4311_ _4523_/B VGND VGND VPWR VPWR _4312_/B sky130_fd_sc_hd__inv_2
X_4242_ _4266_/S _4242_/B VGND VGND VPWR VPWR _4242_/Y sky130_fd_sc_hd__nor2_2
XFILLER_87_508 VGND VGND VPWR VPWR sky130_fd_sc_hd__decap_3
XFILLER_67_243 VGND VGND VPWR VPWR sky130_fd_sc_hd__decap_3
X_4173_ _4173_/A _4174_/C _4173_/C VGND VGND VPWR VPWR _4185_/A sky130_fd_sc_hd__and3_2
XFILLER_55_416 VGND VGND VPWR VPWR sky130_fd_sc_hd__fill_2
X_3124_ _2908_/X _3121_/B _3121_/Y _5033_/Q VGND VGND VPWR VPWR _5033_/D sky130_fd_sc_hd__a22o_2
XTAP_TAPCELL_ROW_2_217 VGND VPWR sky130_fd_sc_hd__tapvpwrvgnd_1
XFILLER_55_449 VGND VGND VPWR VPWR sky130_fd_sc_hd__fill_1
XFILLER_67_287 VGND VGND VPWR VPWR sky130_fd_sc_hd__fill_2
X_3055_ _2921_/X _3048_/B _3048_/Y _4973_/Q VGND VGND VPWR VPWR _4973_/D sky130_fd_sc_hd__a22o_2
XFILLER_23_302 VGND VGND VPWR VPWR sky130_fd_sc_hd__decap_3
XFILLER_63_482 VGND VGND VPWR VPWR sky130_fd_sc_hd__fill_1
XFILLER_35_195 VGND VGND VPWR VPWR sky130_fd_sc_hd__decap_3
XTAP_TAPCELL_ROW_18_371 VGND VPWR sky130_fd_sc_hd__tapvpwrvgnd_1
X_3957_ _4071_/B _3956_/X _4016_/A VGND VGND VPWR VPWR _3957_/X sky130_fd_sc_hd__mux2_1
XFILLER_50_187 VGND VGND VPWR VPWR sky130_fd_sc_hd__decap_3
X_2908_ _5276_/Q _5212_/Q _4854_/A _5228_/Q _2907_/X VGND VGND VPWR VPWR _2908_/X
+ sky130_fd_sc_hd__a221o_2
XFILLER_31_390 VGND VGND VPWR VPWR sky130_fd_sc_hd__fill_2
X_3888_ _3888_/A _3892_/A VGND VGND VPWR VPWR _3888_/Y sky130_fd_sc_hd__nor2_2
X_2839_ _2857_/A _4828_/B VGND VGND VPWR VPWR _2839_/X sky130_fd_sc_hd__and2_2
X_4509_ _4509_/A _4509_/B _4509_/C VGND VGND VPWR VPWR _4509_/X sky130_fd_sc_hd__and3_2
XTAP_TAPCELL_ROW_92_1078 VGND VPWR sky130_fd_sc_hd__tapvpwrvgnd_1
XFILLER_78_519 VGND VGND VPWR VPWR sky130_fd_sc_hd__decap_3
XFILLER_76_15 VGND VGND VPWR VPWR sky130_fd_sc_hd__decap_3
XFILLER_76_48 VGND VGND VPWR VPWR sky130_fd_sc_hd__decap_3
XFILLER_58_265 VGND VGND VPWR VPWR sky130_fd_sc_hd__fill_1
XFILLER_46_427 VGND VGND VPWR VPWR sky130_fd_sc_hd__decap_3
XFILLER_58_298 VGND VGND VPWR VPWR sky130_fd_sc_hd__decap_3
XFILLER_61_408 VGND VGND VPWR VPWR sky130_fd_sc_hd__decap_3
XFILLER_14_302 VGND VGND VPWR VPWR sky130_fd_sc_hd__decap_3
XFILLER_25_30 VGND VGND VPWR VPWR sky130_fd_sc_hd__decap_3
XTAP_TAPCELL_ROW_44_617 VGND VPWR sky130_fd_sc_hd__tapvpwrvgnd_1
XFILLER_25_63 VGND VGND VPWR VPWR sky130_fd_sc_hd__decap_3
XFILLER_41_187 VGND VGND VPWR VPWR sky130_fd_sc_hd__fill_2
XTAP_TAPCELL_ROW_52_694 VGND VPWR sky130_fd_sc_hd__tapvpwrvgnd_1
XFILLER_6_501 VGND VGND VPWR VPWR sky130_fd_sc_hd__decap_3
XFILLER_44_9 VGND VGND VPWR VPWR sky130_fd_sc_hd__fill_2
XFILLER_69_508 VGND VGND VPWR VPWR sky130_fd_sc_hd__decap_3
XFILLER_49_210 VGND VGND VPWR VPWR sky130_fd_sc_hd__decap_3
XFILLER_89_390 VGND VGND VPWR VPWR sky130_fd_sc_hd__fill_2
XFILLER_37_405 VGND VGND VPWR VPWR sky130_fd_sc_hd__decap_3
XFILLER_49_254 VGND VGND VPWR VPWR sky130_fd_sc_hd__decap_3
XFILLER_92_500 VGND VGND VPWR VPWR sky130_fd_sc_hd__decap_3
XFILLER_49_287 VGND VGND VPWR VPWR sky130_fd_sc_hd__decap_3
XFILLER_92_533 VGND VGND VPWR VPWR sky130_fd_sc_hd__decap_3
XFILLER_45_482 VGND VGND VPWR VPWR sky130_fd_sc_hd__fill_2
XFILLER_52_419 VGND VGND VPWR VPWR sky130_fd_sc_hd__fill_1
XFILLER_60_430 VGND VGND VPWR VPWR sky130_fd_sc_hd__decap_3
X_4860_ _5169_/Q _4868_/A2 _3230_/Y _3241_/X VGND VGND VPWR VPWR _5169_/D sky130_fd_sc_hd__o22a_2
XFILLER_32_165 VGND VGND VPWR VPWR sky130_fd_sc_hd__decap_3
X_3811_ _4241_/A _3630_/B _3810_/Y VGND VGND VPWR VPWR _3811_/X sky130_fd_sc_hd__o21a_2
XTAP_TAPCELL_ROW_15_341 VGND VPWR sky130_fd_sc_hd__tapvpwrvgnd_1
XFILLER_20_338 VGND VGND VPWR VPWR sky130_fd_sc_hd__decap_3
X_4791_ _5165_/Q _4792_/B VGND VGND VPWR VPWR _4793_/A sky130_fd_sc_hd__or2_2
X_3742_ _4318_/A _4298_/A VGND VGND VPWR VPWR _3745_/A sky130_fd_sc_hd__and2_2
XFILLER_9_350 VGND VGND VPWR VPWR sky130_fd_sc_hd__fill_2
X_3673_ _3671_/X _3672_/X _3733_/S VGND VGND VPWR VPWR _3673_/X sky130_fd_sc_hd__mux2_1
XFILLER_9_372 VGND VGND VPWR VPWR sky130_fd_sc_hd__decap_3
X_2624_ _2624_/A _2624_/B VGND VGND VPWR VPWR _3775_/B sky130_fd_sc_hd__and2_2
Xoutput102 _2758_/X VGND VGND VPWR VPWR MEM_STR_DATA[4] sky130_fd_sc_hd__clkdlybuf4s25_1
X_2555_ _4891_/Q _4875_/Q _5099_/Q _5083_/Q _2672_/S0 _2672_/S1 VGND VGND VPWR VPWR
+ _2555_/X sky130_fd_sc_hd__mux4_2
X_5274_ _5283_/CLK _5274_/D VGND VGND VPWR VPWR _5274_/Q sky130_fd_sc_hd__dfxtp_2
X_2486_ _2677_/S _2483_/X _5130_/Q VGND VGND VPWR VPWR _2486_/X sky130_fd_sc_hd__o21a_2
XFILLER_87_316 VGND VGND VPWR VPWR sky130_fd_sc_hd__decap_3
X_4225_ _4225_/A _4225_/B VGND VGND VPWR VPWR _4227_/D sky130_fd_sc_hd__nor2_2
XFILLER_68_552 VGND VGND VPWR VPWR sky130_fd_sc_hd__decap_3
X_4156_ _4114_/Y _4200_/D _4200_/C VGND VGND VPWR VPWR _4158_/B sky130_fd_sc_hd__a21oi_2
XFILLER_28_427 VGND VGND VPWR VPWR sky130_fd_sc_hd__decap_3
XFILLER_46_29 VGND VGND VPWR VPWR sky130_fd_sc_hd__decap_3
X_3107_ _2911_/X _3119_/A2 _3103_/Y _5018_/Q VGND VGND VPWR VPWR _5018_/D sky130_fd_sc_hd__a22o_2
XFILLER_83_511 VGND VGND VPWR VPWR sky130_fd_sc_hd__decap_3
XFILLER_43_408 VGND VGND VPWR VPWR sky130_fd_sc_hd__decap_3
XFILLER_55_246 VGND VGND VPWR VPWR sky130_fd_sc_hd__decap_3
X_4087_ _4075_/X _4085_/X _4087_/C _4087_/D VGND VGND VPWR VPWR _4087_/X sky130_fd_sc_hd__and4bb_2
XFILLER_36_460 VGND VGND VPWR VPWR sky130_fd_sc_hd__fill_1
XFILLER_55_279 VGND VGND VPWR VPWR sky130_fd_sc_hd__fill_1
XFILLER_70_216 VGND VGND VPWR VPWR sky130_fd_sc_hd__decap_3
X_3038_ _2927_/X _3029_/B _3029_/Y _4959_/Q VGND VGND VPWR VPWR _4959_/D sky130_fd_sc_hd__a22o_2
XFILLER_51_430 VGND VGND VPWR VPWR sky130_fd_sc_hd__decap_3
X_4989_ _5117_/CLK _4989_/D VGND VGND VPWR VPWR _4989_/Q sky130_fd_sc_hd__dfxtp_2
XTAP_TAPCELL_ROW_21_399 VGND VPWR sky130_fd_sc_hd__tapvpwrvgnd_1
XFILLER_3_526 VGND VGND VPWR VPWR sky130_fd_sc_hd__decap_3
XFILLER_87_47 VGND VGND VPWR VPWR sky130_fd_sc_hd__decap_3
XFILLER_78_327 VGND VGND VPWR VPWR sky130_fd_sc_hd__fill_1
XFILLER_86_371 VGND VGND VPWR VPWR sky130_fd_sc_hd__decap_3
XFILLER_86_360 VGND VGND VPWR VPWR sky130_fd_sc_hd__decap_3
XTAP_TAPCELL_ROW_57_742 VGND VPWR sky130_fd_sc_hd__tapvpwrvgnd_1
XFILLER_36_73 VGND VGND VPWR VPWR sky130_fd_sc_hd__decap_3
XFILLER_61_216 VGND VGND VPWR VPWR sky130_fd_sc_hd__decap_3
XTAP_TAPCELL_ROW_29_477 VGND VPWR sky130_fd_sc_hd__tapvpwrvgnd_1
XFILLER_27_493 VGND VGND VPWR VPWR sky130_fd_sc_hd__decap_3
XFILLER_14_132 VGND VGND VPWR VPWR sky130_fd_sc_hd__decap_3
XFILLER_42_474 VGND VGND VPWR VPWR sky130_fd_sc_hd__fill_2
XTAP_TAPCELL_ROW_12_311 VGND VPWR sky130_fd_sc_hd__tapvpwrvgnd_1
XFILLER_10_371 VGND VGND VPWR VPWR sky130_fd_sc_hd__fill_2
Xinput37 MEM_LD_DATA[13] VGND VGND VPWR VPWR input37/X sky130_fd_sc_hd__clkdlybuf4s25_1
Xinput26 INSTR_STREAM[3] VGND VGND VPWR VPWR _3322_/C sky130_fd_sc_hd__clkdlybuf4s25_1
Xinput15 INSTR_STREAM[22] VGND VGND VPWR VPWR _3251_/C sky130_fd_sc_hd__clkdlybuf4s25_1
XFILLER_6_342 VGND VGND VPWR VPWR sky130_fd_sc_hd__decap_3
Xinput48 MEM_LD_DATA[9] VGND VGND VPWR VPWR input48/X sky130_fd_sc_hd__clkdlybuf4s25_1
XFILLER_6_386 VGND VGND VPWR VPWR sky130_fd_sc_hd__decap_3
XFILLER_42_6 VGND VGND VPWR VPWR sky130_fd_sc_hd__decap_3
XFILLER_69_316 VGND VGND VPWR VPWR sky130_fd_sc_hd__decap_3
X_4010_ _4011_/A _4011_/B VGND VGND VPWR VPWR _4010_/Y sky130_fd_sc_hd__nand2_2
XFILLER_65_522 VGND VGND VPWR VPWR sky130_fd_sc_hd__fill_1
XFILLER_77_382 VGND VGND VPWR VPWR sky130_fd_sc_hd__fill_1
XFILLER_25_408 VGND VGND VPWR VPWR sky130_fd_sc_hd__decap_3
XFILLER_92_363 VGND VGND VPWR VPWR sky130_fd_sc_hd__fill_1
X_4912_ clkload4/A _4912_/D VGND VGND VPWR VPWR _4912_/Q sky130_fd_sc_hd__dfxtp_2
XFILLER_80_536 VGND VGND VPWR VPWR sky130_fd_sc_hd__fill_2
XFILLER_33_452 VGND VGND VPWR VPWR sky130_fd_sc_hd__decap_3
X_4843_ _4835_/A _4838_/X _4842_/X VGND VGND VPWR VPWR _4843_/Y sky130_fd_sc_hd__a21oi_2
X_4774_ _4772_/X _4773_/Y _4847_/B VGND VGND VPWR VPWR _4774_/Y sky130_fd_sc_hd__o21ai_2
X_3725_ _3825_/B _3725_/B VGND VGND VPWR VPWR _4581_/S sky130_fd_sc_hd__nor2_2
X_3656_ _3705_/A _3656_/B VGND VGND VPWR VPWR _3656_/X sky130_fd_sc_hd__or2_2
X_3587_ _4320_/B _4286_/B VGND VGND VPWR VPWR _4340_/S sky130_fd_sc_hd__nor2_2
X_2607_ _5111_/Q _4999_/Q _4983_/Q _4967_/Q _2676_/S0 _2676_/S1 VGND VGND VPWR VPWR
+ _2607_/X sky130_fd_sc_hd__mux4_2
XFILLER_0_529 VGND VGND VPWR VPWR sky130_fd_sc_hd__decap_3
X_2538_ _4957_/Q _4941_/Q _4925_/Q _4909_/Q _5127_/Q _5128_/Q VGND VGND VPWR VPWR
+ _2538_/X sky130_fd_sc_hd__mux4_2
X_5257_ _5257_/CLK _5257_/D VGND VGND VPWR VPWR _5257_/Q sky130_fd_sc_hd__dfxtp_2
XFILLER_87_113 VGND VGND VPWR VPWR sky130_fd_sc_hd__decap_3
X_4208_ _4190_/X _4191_/X _4206_/X _4207_/Y _4168_/A VGND VGND VPWR VPWR _4209_/B
+ sky130_fd_sc_hd__a32o_2
X_2469_ _5285_/Q _3366_/A VGND VGND VPWR VPWR _5281_/D sky130_fd_sc_hd__and2_2
XFILLER_56_522 VGND VGND VPWR VPWR sky130_fd_sc_hd__decap_3
XFILLER_68_360 VGND VGND VPWR VPWR sky130_fd_sc_hd__decap_3
X_5188_ _5216_/CLK _5188_/D VGND VGND VPWR VPWR _5188_/Q sky130_fd_sc_hd__dfxtp_2
XFILLER_56_555 VGND VGND VPWR VPWR sky130_fd_sc_hd__decap_3
X_4139_ _4191_/A _2881_/B _4123_/Y _4213_/A _4138_/X VGND VGND VPWR VPWR _4139_/X
+ sky130_fd_sc_hd__o221a_2
XFILLER_28_268 VGND VGND VPWR VPWR sky130_fd_sc_hd__fill_2
XFILLER_71_514 VGND VGND VPWR VPWR sky130_fd_sc_hd__decap_3
XFILLER_73_38 VGND VGND VPWR VPWR sky130_fd_sc_hd__fill_2
XTAP_TAPCELL_ROW_54_712 VGND VPWR sky130_fd_sc_hd__tapvpwrvgnd_1
XFILLER_83_385 VGND VGND VPWR VPWR sky130_fd_sc_hd__decap_3
XFILLER_24_430 VGND VGND VPWR VPWR sky130_fd_sc_hd__decap_3
XFILLER_71_536 VGND VGND VPWR VPWR sky130_fd_sc_hd__decap_3
XFILLER_83_396 VGND VGND VPWR VPWR sky130_fd_sc_hd__decap_3
XTAP_TAPCELL_ROW_26_447 VGND VPWR sky130_fd_sc_hd__tapvpwrvgnd_1
XFILLER_11_113 VGND VGND VPWR VPWR sky130_fd_sc_hd__decap_3
XFILLER_24_474 VGND VGND VPWR VPWR sky130_fd_sc_hd__fill_2
XFILLER_11_135 VGND VGND VPWR VPWR sky130_fd_sc_hd__decap_3
XFILLER_7_139 VGND VGND VPWR VPWR sky130_fd_sc_hd__decap_3
XFILLER_7_128 VGND VGND VPWR VPWR sky130_fd_sc_hd__fill_2
Xclkbuf_2_0__f_CLK clkbuf_0_CLK/X VGND VGND VPWR VPWR clkbuf_leaf_5_CLK/A sky130_fd_sc_hd__clkbuf_16
XFILLER_3_378 VGND VGND VPWR VPWR sky130_fd_sc_hd__decap_3
XFILLER_19_213 VGND VGND VPWR VPWR sky130_fd_sc_hd__decap_3
XFILLER_47_511 VGND VGND VPWR VPWR sky130_fd_sc_hd__decap_3
XFILLER_78_179 VGND VGND VPWR VPWR sky130_fd_sc_hd__decap_3
XFILLER_47_555 VGND VGND VPWR VPWR sky130_fd_sc_hd__decap_3
XFILLER_74_330 VGND VGND VPWR VPWR sky130_fd_sc_hd__decap_3
XFILLER_34_238 VGND VGND VPWR VPWR sky130_fd_sc_hd__fill_2
XFILLER_62_547 VGND VGND VPWR VPWR sky130_fd_sc_hd__decap_3
XFILLER_15_430 VGND VGND VPWR VPWR sky130_fd_sc_hd__decap_3
XFILLER_15_452 VGND VGND VPWR VPWR sky130_fd_sc_hd__decap_3
XFILLER_63_60 VGND VGND VPWR VPWR sky130_fd_sc_hd__decap_3
XFILLER_42_293 VGND VGND VPWR VPWR sky130_fd_sc_hd__decap_3
XPHY_EDGE_ROW_7_Left_101 VGND VGND VPWR VPWR sky130_fd_sc_hd__decap_3
XFILLER_30_477 VGND VGND VPWR VPWR sky130_fd_sc_hd__decap_3
X_3510_ _3705_/A _3507_/X _5134_/Q VGND VGND VPWR VPWR _3510_/X sky130_fd_sc_hd__o21a_2
XFILLER_8_88 VGND VGND VPWR VPWR sky130_fd_sc_hd__decap_3
XFILLER_6_150 VGND VGND VPWR VPWR sky130_fd_sc_hd__decap_3
X_4490_ _4304_/X _4484_/X _4489_/X _3947_/C VGND VGND VPWR VPWR _4490_/X sky130_fd_sc_hd__o211a_2
X_3441_ _5202_/Q _4854_/B _3458_/A _3440_/Y VGND VGND VPWR VPWR _3442_/B sky130_fd_sc_hd__o2bb2a_2
XFILLER_40_3 VGND VGND VPWR VPWR sky130_fd_sc_hd__decap_3
X_3372_ _5176_/Q _3357_/X _4854_/B VGND VGND VPWR VPWR _3372_/X sky130_fd_sc_hd__a21o_2
XFILLER_69_102 VGND VGND VPWR VPWR sky130_fd_sc_hd__decap_3
XFILLER_69_113 VGND VGND VPWR VPWR sky130_fd_sc_hd__decap_3
X_5111_ _5111_/CLK _5111_/D VGND VGND VPWR VPWR _5111_/Q sky130_fd_sc_hd__dfxtp_2
XFILLER_88_90 VGND VGND VPWR VPWR sky130_fd_sc_hd__decap_3
X_5042_ clkload8/A _5042_/D VGND VGND VPWR VPWR _5042_/Q sky130_fd_sc_hd__dfxtp_2
XTAP_TAPCELL_ROW_68_848 VGND VPWR sky130_fd_sc_hd__tapvpwrvgnd_1
XFILLER_38_533 VGND VGND VPWR VPWR sky130_fd_sc_hd__fill_2
XFILLER_25_205 VGND VGND VPWR VPWR sky130_fd_sc_hd__decap_3
XFILLER_65_352 VGND VGND VPWR VPWR sky130_fd_sc_hd__decap_3
XFILLER_65_385 VGND VGND VPWR VPWR sky130_fd_sc_hd__decap_3
XFILLER_65_396 VGND VGND VPWR VPWR sky130_fd_sc_hd__decap_3
XTAP_TAPCELL_ROW_23_417 VGND VPWR sky130_fd_sc_hd__tapvpwrvgnd_1
XFILLER_21_444 VGND VGND VPWR VPWR sky130_fd_sc_hd__decap_3
XFILLER_21_455 VGND VGND VPWR VPWR sky130_fd_sc_hd__decap_3
X_4826_ _5169_/Q _4828_/B VGND VGND VPWR VPWR _4827_/A sky130_fd_sc_hd__nand2_2
X_4757_ _4747_/B _4750_/B _4747_/A VGND VGND VPWR VPWR _4758_/B sky130_fd_sc_hd__a21bo_2
XTAP_TAPCELL_ROW_31_494 VGND VPWR sky130_fd_sc_hd__tapvpwrvgnd_1
X_4688_ _4261_/A _4261_/C _4686_/X _3848_/A _4687_/X VGND VGND VPWR VPWR _4688_/X
+ sky130_fd_sc_hd__o221a_2
X_3708_ _4959_/Q _4943_/Q _4927_/Q _4911_/Q _3732_/S0 _3732_/S1 VGND VGND VPWR VPWR
+ _3708_/X sky130_fd_sc_hd__mux4_2
X_3639_ _3637_/X _3638_/X _3705_/A VGND VGND VPWR VPWR _3639_/X sky130_fd_sc_hd__mux2_1
XFILLER_0_304 VGND VGND VPWR VPWR sky130_fd_sc_hd__decap_3
XFILLER_0_315 VGND VGND VPWR VPWR sky130_fd_sc_hd__decap_3
XFILLER_0_348 VGND VGND VPWR VPWR sky130_fd_sc_hd__decap_3
XFILLER_29_522 VGND VGND VPWR VPWR sky130_fd_sc_hd__decap_3
XFILLER_75_105 VGND VGND VPWR VPWR sky130_fd_sc_hd__decap_3
XFILLER_75_116 VGND VGND VPWR VPWR sky130_fd_sc_hd__decap_3
XFILLER_88_488 VGND VGND VPWR VPWR sky130_fd_sc_hd__decap_3
XFILLER_84_48 VGND VGND VPWR VPWR sky130_fd_sc_hd__decap_3
XFILLER_16_227 VGND VGND VPWR VPWR sky130_fd_sc_hd__decap_3
XFILLER_17_53 VGND VGND VPWR VPWR sky130_fd_sc_hd__decap_3
XTAP_TAPCELL_ROW_39_572 VGND VPWR sky130_fd_sc_hd__tapvpwrvgnd_1
XFILLER_83_193 VGND VGND VPWR VPWR sky130_fd_sc_hd__decap_3
XFILLER_16_249 VGND VGND VPWR VPWR sky130_fd_sc_hd__decap_3
XFILLER_71_355 VGND VGND VPWR VPWR sky130_fd_sc_hd__decap_3
XFILLER_71_388 VGND VGND VPWR VPWR sky130_fd_sc_hd__decap_3
XFILLER_12_433 VGND VGND VPWR VPWR sky130_fd_sc_hd__decap_3
XFILLER_24_282 VGND VGND VPWR VPWR sky130_fd_sc_hd__fill_2
XFILLER_33_52 VGND VGND VPWR VPWR sky130_fd_sc_hd__decap_3
XFILLER_8_404 VGND VGND VPWR VPWR sky130_fd_sc_hd__fill_2
XFILLER_12_477 VGND VGND VPWR VPWR sky130_fd_sc_hd__decap_3
XFILLER_8_437 VGND VGND VPWR VPWR sky130_fd_sc_hd__decap_3
XPHY_EDGE_ROW_89_Left_183 VGND VGND VPWR VPWR sky130_fd_sc_hd__decap_3
XFILLER_79_455 VGND VGND VPWR VPWR sky130_fd_sc_hd__decap_3
XFILLER_79_444 VGND VGND VPWR VPWR sky130_fd_sc_hd__decap_3
XFILLER_39_319 VGND VGND VPWR VPWR sky130_fd_sc_hd__decap_3
XFILLER_35_503 VGND VGND VPWR VPWR sky130_fd_sc_hd__fill_1
XFILLER_47_374 VGND VGND VPWR VPWR sky130_fd_sc_hd__decap_3
XTAP_TAPCELL_ROW_65_818 VGND VPWR sky130_fd_sc_hd__tapvpwrvgnd_1
XFILLER_62_344 VGND VGND VPWR VPWR sky130_fd_sc_hd__fill_2
X_3990_ _3990_/A VGND VGND VPWR VPWR _4196_/B sky130_fd_sc_hd__inv_2
XFILLER_62_399 VGND VGND VPWR VPWR sky130_fd_sc_hd__decap_3
X_2941_ _2941_/A _2941_/B VGND VGND VPWR VPWR _2941_/X sky130_fd_sc_hd__or2_2
XTAP_TAPCELL_ROW_73_895 VGND VPWR sky130_fd_sc_hd__tapvpwrvgnd_1
X_4611_ _5235_/Q _4854_/B VGND VGND VPWR VPWR _4611_/Y sky130_fd_sc_hd__nand2_2
X_2872_ _2872_/A _3831_/A VGND VGND VPWR VPWR _2873_/B sky130_fd_sc_hd__xnor2_2
XFILLER_88_3 VGND VGND VPWR VPWR sky130_fd_sc_hd__decap_3
X_4542_ _4393_/C _4393_/D _4638_/S VGND VGND VPWR VPWR _4543_/A sky130_fd_sc_hd__mux2_1
X_4473_ _4236_/A _2589_/B _3774_/Y _2589_/A VGND VGND VPWR VPWR _4473_/X sky130_fd_sc_hd__a22o_2
Xmax_cap134 _2954_/B VGND VGND VPWR VPWR _2970_/A2 sky130_fd_sc_hd__buf_6
Xmax_cap123 _3969_/S VGND VGND VPWR VPWR _3919_/S sky130_fd_sc_hd__buf_6
Xmax_cap112 _4558_/S VGND VGND VPWR VPWR _4682_/S sky130_fd_sc_hd__buf_4
Xmax_cap156 _4376_/B VGND VGND VPWR VPWR _3642_/A sky130_fd_sc_hd__buf_6
Xmax_cap145 _4332_/C VGND VGND VPWR VPWR _4397_/C sky130_fd_sc_hd__buf_8
X_3424_ _3424_/A _3424_/B _3424_/C _3424_/D VGND VGND VPWR VPWR _3424_/X sky130_fd_sc_hd__and4_2
XFILLER_89_208 VGND VGND VPWR VPWR sky130_fd_sc_hd__decap_3
Xmax_cap178 _5131_/Q VGND VGND VPWR VPWR _3732_/S0 sky130_fd_sc_hd__buf_12
X_3355_ _5187_/Q _3230_/B _3230_/Y _3354_/X VGND VGND VPWR VPWR _5187_/D sky130_fd_sc_hd__o22a_2
X_3286_ _3315_/B _3284_/X _3285_/X _3338_/B VGND VGND VPWR VPWR _5146_/D sky130_fd_sc_hd__o211a_2
X_5025_ _5110_/CLK _5025_/D VGND VGND VPWR VPWR _5025_/Q sky130_fd_sc_hd__dfxtp_2
XFILLER_85_447 VGND VGND VPWR VPWR sky130_fd_sc_hd__fill_1
XFILLER_38_363 VGND VGND VPWR VPWR sky130_fd_sc_hd__fill_1
XFILLER_38_374 VGND VGND VPWR VPWR sky130_fd_sc_hd__decap_3
XFILLER_54_29 VGND VGND VPWR VPWR sky130_fd_sc_hd__decap_3
XFILLER_65_160 VGND VGND VPWR VPWR sky130_fd_sc_hd__decap_3
XFILLER_93_480 VGND VGND VPWR VPWR sky130_fd_sc_hd__decap_3
XFILLER_53_355 VGND VGND VPWR VPWR sky130_fd_sc_hd__fill_2
XTAP_TAPCELL_ROW_36_542 VGND VPWR sky130_fd_sc_hd__tapvpwrvgnd_1
XFILLER_80_141 VGND VGND VPWR VPWR sky130_fd_sc_hd__decap_3
XTAP_TAPCELL_ROW_0_189 VGND VPWR sky130_fd_sc_hd__tapvpwrvgnd_1
XFILLER_80_163 VGND VGND VPWR VPWR sky130_fd_sc_hd__decap_3
XFILLER_21_296 VGND VGND VPWR VPWR sky130_fd_sc_hd__fill_1
X_4809_ _4809_/A _4809_/B VGND VGND VPWR VPWR _4814_/B sky130_fd_sc_hd__nor2_2
XPHY_EDGE_ROW_17_Right_17 VGND VGND VPWR VPWR sky130_fd_sc_hd__decap_3
XFILLER_79_37 VGND VGND VPWR VPWR sky130_fd_sc_hd__decap_3
XFILLER_0_134 VGND VGND VPWR VPWR sky130_fd_sc_hd__decap_3
XTAP_TAPCELL_ROW_8_278 VGND VPWR sky130_fd_sc_hd__tapvpwrvgnd_1
XFILLER_0_156 VGND VGND VPWR VPWR sky130_fd_sc_hd__decap_3
XFILLER_0_178 VGND VGND VPWR VPWR sky130_fd_sc_hd__fill_2
XPHY_EDGE_ROW_26_Right_26 VGND VGND VPWR VPWR sky130_fd_sc_hd__decap_3
XFILLER_48_127 VGND VGND VPWR VPWR sky130_fd_sc_hd__fill_1
XFILLER_76_436 VGND VGND VPWR VPWR sky130_fd_sc_hd__decap_3
XFILLER_29_352 VGND VGND VPWR VPWR sky130_fd_sc_hd__decap_3
XFILLER_29_363 VGND VGND VPWR VPWR sky130_fd_sc_hd__decap_3
XFILLER_63_108 VGND VGND VPWR VPWR sky130_fd_sc_hd__decap_3
XFILLER_63_119 VGND VGND VPWR VPWR sky130_fd_sc_hd__decap_3
XFILLER_28_85 VGND VGND VPWR VPWR sky130_fd_sc_hd__decap_3
XFILLER_44_322 VGND VGND VPWR VPWR sky130_fd_sc_hd__decap_3
XFILLER_84_480 VGND VGND VPWR VPWR sky130_fd_sc_hd__decap_3
XFILLER_32_528 VGND VGND VPWR VPWR sky130_fd_sc_hd__decap_3
XFILLER_32_539 VGND VGND VPWR VPWR sky130_fd_sc_hd__fill_1
XFILLER_44_377 VGND VGND VPWR VPWR sky130_fd_sc_hd__decap_3
XFILLER_71_163 VGND VGND VPWR VPWR sky130_fd_sc_hd__decap_3
XFILLER_71_185 VGND VGND VPWR VPWR sky130_fd_sc_hd__decap_3
XTAP_TAPCELL_ROW_70_865 VGND VPWR sky130_fd_sc_hd__tapvpwrvgnd_1
XPHY_EDGE_ROW_35_Right_35 VGND VGND VPWR VPWR sky130_fd_sc_hd__decap_3
XFILLER_8_256 VGND VGND VPWR VPWR sky130_fd_sc_hd__decap_3
XFILLER_5_12 VGND VGND VPWR VPWR sky130_fd_sc_hd__fill_2
XFILLER_69_70 VGND VGND VPWR VPWR sky130_fd_sc_hd__decap_3
XPHY_EDGE_ROW_44_Right_44 VGND VGND VPWR VPWR sky130_fd_sc_hd__decap_3
XFILLER_39_116 VGND VGND VPWR VPWR sky130_fd_sc_hd__decap_3
XFILLER_67_414 VGND VGND VPWR VPWR sky130_fd_sc_hd__decap_3
X_3140_ _2897_/X _3155_/A2 _3139_/Y _5047_/Q VGND VGND VPWR VPWR _5047_/D sky130_fd_sc_hd__a22o_2
XFILLER_67_447 VGND VGND VPWR VPWR sky130_fd_sc_hd__fill_1
XFILLER_67_458 VGND VGND VPWR VPWR sky130_fd_sc_hd__decap_3
XTAP_TAPCELL_ROW_78_943 VGND VPWR sky130_fd_sc_hd__tapvpwrvgnd_1
XFILLER_79_296 VGND VGND VPWR VPWR sky130_fd_sc_hd__decap_3
X_3071_ _2914_/X _3066_/B _3066_/Y _4987_/Q VGND VGND VPWR VPWR _4987_/D sky130_fd_sc_hd__a22o_2
XFILLER_62_130 VGND VGND VPWR VPWR sky130_fd_sc_hd__decap_3
XFILLER_35_388 VGND VGND VPWR VPWR sky130_fd_sc_hd__decap_3
XFILLER_35_399 VGND VGND VPWR VPWR sky130_fd_sc_hd__decap_3
XTAP_TAPCELL_ROW_33_512 VGND VPWR sky130_fd_sc_hd__tapvpwrvgnd_1
XFILLER_50_336 VGND VGND VPWR VPWR sky130_fd_sc_hd__decap_3
X_3973_ _5182_/Q _3978_/A _3977_/A _3766_/B _3884_/D VGND VGND VPWR VPWR _3973_/X
+ sky130_fd_sc_hd__o2111a_2
XPHY_EDGE_ROW_53_Right_53 VGND VGND VPWR VPWR sky130_fd_sc_hd__decap_3
X_2924_ _5276_/Q _5217_/Q _4854_/A _5233_/Q _2923_/X VGND VGND VPWR VPWR _2924_/X
+ sky130_fd_sc_hd__a221o_2
X_2855_ _2853_/X _2854_/X _2855_/S VGND VGND VPWR VPWR _2855_/X sky130_fd_sc_hd__mux2_1
X_4525_ _4308_/X _4292_/X _4572_/S VGND VGND VPWR VPWR _4525_/X sky130_fd_sc_hd__mux2_1
X_2786_ _5071_/Q _5055_/Q _5039_/Q _5023_/Q _2854_/S0 _5136_/Q VGND VGND VPWR VPWR
+ _2786_/X sky130_fd_sc_hd__mux4_2
X_4456_ _4385_/Y _4455_/X _4692_/A VGND VGND VPWR VPWR _5227_/D sky130_fd_sc_hd__a21oi_2
XPHY_EDGE_ROW_62_Right_62 VGND VGND VPWR VPWR sky130_fd_sc_hd__decap_3
X_4387_ _4464_/A VGND VGND VPWR VPWR _4389_/A sky130_fd_sc_hd__inv_2
X_3407_ _3400_/B _3400_/C _3400_/A VGND VGND VPWR VPWR _3408_/B sky130_fd_sc_hd__a21bo_2
XFILLER_58_403 VGND VGND VPWR VPWR sky130_fd_sc_hd__fill_2
X_3338_ _5283_/Q _3338_/B input3/X VGND VGND VPWR VPWR _3338_/X sky130_fd_sc_hd__and3_2
XFILLER_58_436 VGND VGND VPWR VPWR sky130_fd_sc_hd__decap_3
XTAP_TAPCELL_ROW_5_248 VGND VPWR sky130_fd_sc_hd__tapvpwrvgnd_1
XFILLER_45_108 VGND VGND VPWR VPWR sky130_fd_sc_hd__decap_3
X_3269_ _5262_/Q _3305_/B _3268_/Y _3338_/B VGND VGND VPWR VPWR _5141_/D sky130_fd_sc_hd__o211a_2
XFILLER_38_182 VGND VGND VPWR VPWR sky130_fd_sc_hd__decap_3
XFILLER_66_480 VGND VGND VPWR VPWR sky130_fd_sc_hd__decap_3
X_5008_ _5008_/CLK _5008_/D VGND VGND VPWR VPWR _5008_/Q sky130_fd_sc_hd__dfxtp_2
XFILLER_14_517 VGND VGND VPWR VPWR sky130_fd_sc_hd__decap_3
XPHY_EDGE_ROW_71_Right_71 VGND VGND VPWR VPWR sky130_fd_sc_hd__decap_3
XFILLER_53_196 VGND VGND VPWR VPWR sky130_fd_sc_hd__decap_3
XFILLER_14_21 VGND VGND VPWR VPWR sky130_fd_sc_hd__decap_3
XFILLER_14_32 VGND VGND VPWR VPWR sky130_fd_sc_hd__decap_3
XFILLER_14_65 VGND VGND VPWR VPWR sky130_fd_sc_hd__decap_3
XFILLER_30_20 VGND VGND VPWR VPWR sky130_fd_sc_hd__decap_3
XFILLER_5_215 VGND VGND VPWR VPWR sky130_fd_sc_hd__decap_3
XPHY_EDGE_ROW_80_Right_80 VGND VGND VPWR VPWR sky130_fd_sc_hd__decap_3
XFILLER_1_410 VGND VGND VPWR VPWR sky130_fd_sc_hd__decap_3
XFILLER_30_97 VGND VGND VPWR VPWR sky130_fd_sc_hd__decap_3
XFILLER_76_200 VGND VGND VPWR VPWR sky130_fd_sc_hd__fill_2
XFILLER_49_425 VGND VGND VPWR VPWR sky130_fd_sc_hd__fill_2
XFILLER_49_447 VGND VGND VPWR VPWR sky130_fd_sc_hd__fill_1
XFILLER_76_233 VGND VGND VPWR VPWR sky130_fd_sc_hd__fill_1
XTAP_TAPCELL_ROW_75_913 VGND VPWR sky130_fd_sc_hd__tapvpwrvgnd_1
XFILLER_91_225 VGND VGND VPWR VPWR sky130_fd_sc_hd__fill_1
XFILLER_17_333 VGND VGND VPWR VPWR sky130_fd_sc_hd__decap_3
XFILLER_55_72 VGND VGND VPWR VPWR sky130_fd_sc_hd__decap_3
XTAP_TAPCELL_ROW_47_648 VGND VPWR sky130_fd_sc_hd__tapvpwrvgnd_1
XFILLER_72_483 VGND VGND VPWR VPWR sky130_fd_sc_hd__decap_3
XFILLER_32_336 VGND VGND VPWR VPWR sky130_fd_sc_hd__decap_3
XTAP_TAPCELL_ROW_83_990 VGND VPWR sky130_fd_sc_hd__tapvpwrvgnd_1
XFILLER_20_509 VGND VGND VPWR VPWR sky130_fd_sc_hd__decap_3
XFILLER_71_93 VGND VGND VPWR VPWR sky130_fd_sc_hd__fill_1
X_2640_ _3701_/A VGND VGND VPWR VPWR _4147_/A sky130_fd_sc_hd__inv_2
XFILLER_9_554 VGND VGND VPWR VPWR sky130_fd_sc_hd__decap_3
X_2571_ _2660_/A _2568_/X _5130_/Q VGND VGND VPWR VPWR _2571_/X sky130_fd_sc_hd__o21a_2
XTAP_TAPCELL_ROW_10_294 VGND VPWR sky130_fd_sc_hd__tapvpwrvgnd_1
X_4310_ _4310_/A _4310_/B VGND VGND VPWR VPWR _4523_/B sky130_fd_sc_hd__or2_2
X_4241_ _4241_/A _4449_/S VGND VGND VPWR VPWR _4241_/Y sky130_fd_sc_hd__nand2_2
XFILLER_67_211 VGND VGND VPWR VPWR sky130_fd_sc_hd__decap_3
X_4172_ _4145_/A _4145_/B _3834_/Y VGND VGND VPWR VPWR _4173_/C sky130_fd_sc_hd__a21o_2
XFILLER_67_266 VGND VGND VPWR VPWR sky130_fd_sc_hd__decap_3
X_3123_ _2905_/X _3121_/B _3121_/Y _5032_/Q VGND VGND VPWR VPWR _5032_/D sky130_fd_sc_hd__a22o_2
XTAP_TAPCELL_ROW_2_218 VGND VPWR sky130_fd_sc_hd__tapvpwrvgnd_1
XFILLER_27_119 VGND VGND VPWR VPWR sky130_fd_sc_hd__fill_1
XFILLER_48_480 VGND VGND VPWR VPWR sky130_fd_sc_hd__decap_3
X_3054_ _2918_/X _3048_/B _3048_/Y _4972_/Q VGND VGND VPWR VPWR _4972_/D sky130_fd_sc_hd__a22o_2
XFILLER_82_225 VGND VGND VPWR VPWR sky130_fd_sc_hd__decap_3
XFILLER_82_269 VGND VGND VPWR VPWR sky130_fd_sc_hd__decap_3
XTAP_TAPCELL_ROW_18_372 VGND VPWR sky130_fd_sc_hd__tapvpwrvgnd_1
XFILLER_90_291 VGND VGND VPWR VPWR sky130_fd_sc_hd__decap_3
XFILLER_23_369 VGND VGND VPWR VPWR sky130_fd_sc_hd__decap_3
XFILLER_50_144 VGND VGND VPWR VPWR sky130_fd_sc_hd__decap_3
X_3956_ _3899_/X _3906_/X _3956_/S VGND VGND VPWR VPWR _3956_/X sky130_fd_sc_hd__mux2_1
X_2907_ _5277_/Q _5244_/Q _5196_/Q _5275_/Q VGND VGND VPWR VPWR _2907_/X sky130_fd_sc_hd__a22o_2
X_3887_ _2601_/Y _4278_/B _3885_/Y _3889_/B _3883_/X VGND VGND VPWR VPWR _3887_/X
+ sky130_fd_sc_hd__a221o_2
Xclkbuf_leaf_36_CLK clkload0/A VGND VGND VPWR VPWR _5114_/CLK sky130_fd_sc_hd__clkbuf_8
X_2838_ _2832_/X _2834_/X _2837_/X _2435_/Y VGND VGND VPWR VPWR _4828_/B sky130_fd_sc_hd__a22o_2
X_2769_ _5069_/Q _5053_/Q _5037_/Q _5021_/Q _2851_/S0 _2854_/S1 VGND VGND VPWR VPWR
+ _2769_/X sky130_fd_sc_hd__mux4_2
X_4508_ _4502_/Y _4507_/X _4506_/X _4505_/X VGND VGND VPWR VPWR _4509_/C sky130_fd_sc_hd__o211a_2
XFILLER_4_9 VGND VGND VPWR VPWR sky130_fd_sc_hd__decap_3
X_4439_ _4393_/C _4449_/S _4079_/Y VGND VGND VPWR VPWR _4439_/Y sky130_fd_sc_hd__o21ai_2
XTAP_TAPCELL_ROW_92_1079 VGND VPWR sky130_fd_sc_hd__tapvpwrvgnd_1
XFILLER_86_553 VGND VGND VPWR VPWR sky130_fd_sc_hd__decap_3
XFILLER_39_480 VGND VGND VPWR VPWR sky130_fd_sc_hd__decap_3
XFILLER_73_258 VGND VGND VPWR VPWR sky130_fd_sc_hd__decap_3
XFILLER_92_26 VGND VGND VPWR VPWR sky130_fd_sc_hd__fill_2
XFILLER_26_163 VGND VGND VPWR VPWR sky130_fd_sc_hd__decap_3
XFILLER_54_461 VGND VGND VPWR VPWR sky130_fd_sc_hd__decap_3
XTAP_TAPCELL_ROW_44_618 VGND VPWR sky130_fd_sc_hd__tapvpwrvgnd_1
XFILLER_25_42 VGND VGND VPWR VPWR sky130_fd_sc_hd__decap_3
XFILLER_54_483 VGND VGND VPWR VPWR sky130_fd_sc_hd__decap_3
XTAP_TAPCELL_ROW_80_960 VGND VPWR sky130_fd_sc_hd__tapvpwrvgnd_1
XFILLER_22_380 VGND VGND VPWR VPWR sky130_fd_sc_hd__decap_3
XTAP_TAPCELL_ROW_52_695 VGND VPWR sky130_fd_sc_hd__tapvpwrvgnd_1
XFILLER_10_553 VGND VGND VPWR VPWR sky130_fd_sc_hd__decap_3
XFILLER_41_41 VGND VGND VPWR VPWR sky130_fd_sc_hd__decap_3
XFILLER_6_524 VGND VGND VPWR VPWR sky130_fd_sc_hd__decap_3
Xclkbuf_leaf_27_CLK clkload0/A VGND VGND VPWR VPWR _5069_/CLK sky130_fd_sc_hd__clkbuf_8
XFILLER_2_35 VGND VGND VPWR VPWR sky130_fd_sc_hd__fill_1
XFILLER_49_222 VGND VGND VPWR VPWR sky130_fd_sc_hd__fill_2
XFILLER_49_233 VGND VGND VPWR VPWR sky130_fd_sc_hd__decap_3
XFILLER_49_299 VGND VGND VPWR VPWR sky130_fd_sc_hd__fill_1
XFILLER_66_71 VGND VGND VPWR VPWR sky130_fd_sc_hd__decap_3
XFILLER_92_512 VGND VGND VPWR VPWR sky130_fd_sc_hd__decap_3
XFILLER_66_82 VGND VGND VPWR VPWR sky130_fd_sc_hd__fill_2
XFILLER_92_545 VGND VGND VPWR VPWR sky130_fd_sc_hd__decap_3
XFILLER_45_461 VGND VGND VPWR VPWR sky130_fd_sc_hd__fill_1
XFILLER_64_269 VGND VGND VPWR VPWR sky130_fd_sc_hd__decap_3
XFILLER_20_306 VGND VGND VPWR VPWR sky130_fd_sc_hd__fill_2
XFILLER_32_144 VGND VGND VPWR VPWR sky130_fd_sc_hd__decap_3
X_4790_ _4854_/B _4788_/Y _4789_/X _3338_/B VGND VGND VPWR VPWR _5266_/D sky130_fd_sc_hd__o211a_2
X_3810_ _4212_/A _3810_/B VGND VGND VPWR VPWR _3810_/Y sky130_fd_sc_hd__nand2_2
XTAP_TAPCELL_ROW_15_342 VGND VPWR sky130_fd_sc_hd__tapvpwrvgnd_1
XPHY_EDGE_ROW_25_Left_119 VGND VGND VPWR VPWR sky130_fd_sc_hd__decap_3
XFILLER_82_70 VGND VGND VPWR VPWR sky130_fd_sc_hd__decap_3
XFILLER_32_177 VGND VGND VPWR VPWR sky130_fd_sc_hd__decap_3
XFILLER_60_486 VGND VGND VPWR VPWR sky130_fd_sc_hd__decap_3
X_3741_ _3741_/A _4298_/A VGND VGND VPWR VPWR _3741_/Y sky130_fd_sc_hd__nand2_2
XFILLER_13_380 VGND VGND VPWR VPWR sky130_fd_sc_hd__decap_3
XFILLER_9_340 VGND VGND VPWR VPWR sky130_fd_sc_hd__fill_1
Xclkbuf_leaf_18_CLK clkload1/A VGND VGND VPWR VPWR _5283_/CLK sky130_fd_sc_hd__clkbuf_8
X_3672_ _5122_/Q _5010_/Q _4994_/Q _4978_/Q _3732_/S0 _3732_/S1 VGND VGND VPWR VPWR
+ _3672_/X sky130_fd_sc_hd__mux4_2
X_2623_ _5160_/Q _2624_/B _4393_/D _2553_/Y VGND VGND VPWR VPWR _2623_/X sky130_fd_sc_hd__a31o_2
Xoutput103 _2767_/X VGND VGND VPWR VPWR MEM_STR_DATA[5] sky130_fd_sc_hd__clkdlybuf4s25_1
X_2554_ _5161_/Q _3829_/B VGND VGND VPWR VPWR _2624_/B sky130_fd_sc_hd__or2_2
X_5273_ _5286_/CLK _5273_/D VGND VGND VPWR VPWR _5273_/Q sky130_fd_sc_hd__dfxtp_2
X_2485_ _2660_/A _2485_/B VGND VGND VPWR VPWR _2485_/X sky130_fd_sc_hd__or2_2
XPHY_EDGE_ROW_34_Left_128 VGND VGND VPWR VPWR sky130_fd_sc_hd__decap_3
XFILLER_68_520 VGND VGND VPWR VPWR sky130_fd_sc_hd__decap_3
X_4224_ _4224_/A _4224_/B VGND VGND VPWR VPWR _4227_/C sky130_fd_sc_hd__nor2_2
XFILLER_87_328 VGND VGND VPWR VPWR sky130_fd_sc_hd__decap_3
XFILLER_28_406 VGND VGND VPWR VPWR sky130_fd_sc_hd__decap_3
XFILLER_68_542 VGND VGND VPWR VPWR sky130_fd_sc_hd__decap_3
X_4155_ _4155_/A _4155_/B VGND VGND VPWR VPWR _4200_/D sky130_fd_sc_hd__nor2_2
XFILLER_28_439 VGND VGND VPWR VPWR sky130_fd_sc_hd__decap_3
XFILLER_55_225 VGND VGND VPWR VPWR sky130_fd_sc_hd__decap_3
X_3106_ _2908_/X _3119_/A2 _3103_/Y _5017_/Q VGND VGND VPWR VPWR _5017_/D sky130_fd_sc_hd__a22o_2
XFILLER_83_523 VGND VGND VPWR VPWR sky130_fd_sc_hd__decap_3
XFILLER_55_258 VGND VGND VPWR VPWR sky130_fd_sc_hd__decap_3
X_4086_ _4086_/A _4086_/B VGND VGND VPWR VPWR _4086_/Y sky130_fd_sc_hd__xnor2_2
XFILLER_83_556 VGND VGND VPWR VPWR sky130_fd_sc_hd__fill_2
X_3037_ _2924_/X _3029_/B _3029_/Y _4958_/Q VGND VGND VPWR VPWR _4958_/D sky130_fd_sc_hd__a22o_2
XFILLER_23_122 VGND VGND VPWR VPWR sky130_fd_sc_hd__decap_3
XPHY_EDGE_ROW_43_Left_137 VGND VGND VPWR VPWR sky130_fd_sc_hd__decap_3
XFILLER_23_144 VGND VGND VPWR VPWR sky130_fd_sc_hd__decap_3
XFILLER_51_442 VGND VGND VPWR VPWR sky130_fd_sc_hd__decap_3
X_4988_ _5117_/CLK _4988_/D VGND VGND VPWR VPWR _4988_/Q sky130_fd_sc_hd__dfxtp_2
X_3939_ _4357_/A _4313_/S _3938_/Y VGND VGND VPWR VPWR _3939_/Y sky130_fd_sc_hd__o21ai_2
XFILLER_3_505 VGND VGND VPWR VPWR sky130_fd_sc_hd__decap_3
XFILLER_2_6 VGND VGND VPWR VPWR sky130_fd_sc_hd__decap_3
XFILLER_3_538 VGND VGND VPWR VPWR sky130_fd_sc_hd__decap_3
XPHY_EDGE_ROW_52_Left_146 VGND VGND VPWR VPWR sky130_fd_sc_hd__decap_3
XFILLER_87_15 VGND VGND VPWR VPWR sky130_fd_sc_hd__decap_3
XFILLER_87_26 VGND VGND VPWR VPWR sky130_fd_sc_hd__fill_1
XFILLER_93_309 VGND VGND VPWR VPWR sky130_fd_sc_hd__decap_3
XFILLER_19_406 VGND VGND VPWR VPWR sky130_fd_sc_hd__decap_3
XFILLER_19_428 VGND VGND VPWR VPWR sky130_fd_sc_hd__decap_3
XFILLER_86_383 VGND VGND VPWR VPWR sky130_fd_sc_hd__decap_3
XFILLER_74_556 VGND VGND VPWR VPWR sky130_fd_sc_hd__fill_2
XTAP_TAPCELL_ROW_57_743 VGND VPWR sky130_fd_sc_hd__tapvpwrvgnd_1
XFILLER_27_472 VGND VGND VPWR VPWR sky130_fd_sc_hd__decap_3
XFILLER_36_41 VGND VGND VPWR VPWR sky130_fd_sc_hd__decap_3
XTAP_TAPCELL_ROW_29_478 VGND VPWR sky130_fd_sc_hd__tapvpwrvgnd_1
XPHY_EDGE_ROW_61_Left_155 VGND VGND VPWR VPWR sky130_fd_sc_hd__decap_3
XFILLER_14_100 VGND VGND VPWR VPWR sky130_fd_sc_hd__fill_1
XFILLER_36_85 VGND VGND VPWR VPWR sky130_fd_sc_hd__decap_3
XFILLER_61_228 VGND VGND VPWR VPWR sky130_fd_sc_hd__decap_3
XFILLER_42_442 VGND VGND VPWR VPWR sky130_fd_sc_hd__decap_3
XFILLER_42_486 VGND VGND VPWR VPWR sky130_fd_sc_hd__decap_3
XFILLER_52_62 VGND VGND VPWR VPWR sky130_fd_sc_hd__decap_3
XFILLER_52_73 VGND VGND VPWR VPWR sky130_fd_sc_hd__decap_3
XTAP_TAPCELL_ROW_12_312 VGND VPWR sky130_fd_sc_hd__tapvpwrvgnd_1
XFILLER_10_361 VGND VGND VPWR VPWR sky130_fd_sc_hd__decap_3
Xinput27 INSTR_STREAM[4] VGND VGND VPWR VPWR _3324_/C sky130_fd_sc_hd__clkdlybuf4s25_1
Xinput16 INSTR_STREAM[23] VGND VGND VPWR VPWR _3253_/C sky130_fd_sc_hd__clkdlybuf4s25_1
XFILLER_6_321 VGND VGND VPWR VPWR sky130_fd_sc_hd__decap_3
Xinput49 RESET VGND VGND VPWR VPWR _3494_/A sky130_fd_sc_hd__clkbuf_8
Xinput38 MEM_LD_DATA[14] VGND VGND VPWR VPWR input38/X sky130_fd_sc_hd__clkdlybuf4s25_1
XFILLER_6_354 VGND VGND VPWR VPWR sky130_fd_sc_hd__fill_2
XFILLER_6_365 VGND VGND VPWR VPWR sky130_fd_sc_hd__decap_3
XPHY_EDGE_ROW_70_Left_164 VGND VGND VPWR VPWR sky130_fd_sc_hd__decap_3
XFILLER_35_6 VGND VGND VPWR VPWR sky130_fd_sc_hd__decap_3
XFILLER_69_328 VGND VGND VPWR VPWR sky130_fd_sc_hd__fill_1
XFILLER_84_309 VGND VGND VPWR VPWR sky130_fd_sc_hd__decap_3
XFILLER_77_92 VGND VGND VPWR VPWR sky130_fd_sc_hd__decap_3
XFILLER_37_225 VGND VGND VPWR VPWR sky130_fd_sc_hd__decap_3
Xclkbuf_leaf_7_CLK clkload1/A VGND VGND VPWR VPWR _5260_/CLK sky130_fd_sc_hd__clkbuf_8
XFILLER_37_269 VGND VGND VPWR VPWR sky130_fd_sc_hd__decap_3
XFILLER_52_206 VGND VGND VPWR VPWR sky130_fd_sc_hd__decap_3
XFILLER_92_375 VGND VGND VPWR VPWR sky130_fd_sc_hd__fill_1
XFILLER_80_504 VGND VGND VPWR VPWR sky130_fd_sc_hd__decap_3
XFILLER_18_483 VGND VGND VPWR VPWR sky130_fd_sc_hd__decap_3
X_4911_ clkload4/A _4911_/D VGND VGND VPWR VPWR _4911_/Q sky130_fd_sc_hd__dfxtp_2
XFILLER_93_91 VGND VGND VPWR VPWR sky130_fd_sc_hd__decap_3
XFILLER_92_386 VGND VGND VPWR VPWR sky130_fd_sc_hd__fill_1
XFILLER_20_114 VGND VGND VPWR VPWR sky130_fd_sc_hd__fill_1
XFILLER_33_497 VGND VGND VPWR VPWR sky130_fd_sc_hd__decap_3
XFILLER_60_250 VGND VGND VPWR VPWR sky130_fd_sc_hd__fill_2
XFILLER_60_272 VGND VGND VPWR VPWR sky130_fd_sc_hd__fill_2
XFILLER_60_283 VGND VGND VPWR VPWR sky130_fd_sc_hd__fill_1
X_4842_ _5171_/Q _4842_/B VGND VGND VPWR VPWR _4842_/X sky130_fd_sc_hd__xor2_2
X_4773_ _4772_/A _4772_/C _4772_/B VGND VGND VPWR VPWR _4773_/Y sky130_fd_sc_hd__a21oi_2
XFILLER_20_158 VGND VGND VPWR VPWR sky130_fd_sc_hd__decap_3
X_3724_ _3825_/B _3725_/B VGND VGND VPWR VPWR _3726_/A sky130_fd_sc_hd__and2_2
X_3655_ _4901_/Q _4885_/Q _5109_/Q _5093_/Q _3706_/S0 _3706_/S1 VGND VGND VPWR VPWR
+ _3656_/B sky130_fd_sc_hd__mux4_2
X_2606_ _2677_/S _2605_/X _5130_/Q VGND VGND VPWR VPWR _2606_/X sky130_fd_sc_hd__o21a_2
X_3586_ _3888_/A VGND VGND VPWR VPWR _3889_/A sky130_fd_sc_hd__inv_2
XFILLER_0_508 VGND VGND VPWR VPWR sky130_fd_sc_hd__decap_3
X_2537_ _5117_/Q _5005_/Q _4989_/Q _4973_/Q _5127_/Q _5128_/Q VGND VGND VPWR VPWR
+ _2537_/X sky130_fd_sc_hd__mux4_2
X_5256_ _5257_/CLK _5256_/D VGND VGND VPWR VPWR _5256_/Q sky130_fd_sc_hd__dfxtp_2
X_2468_ _3366_/A _2894_/A _4847_/B VGND VGND VPWR VPWR _5282_/D sky130_fd_sc_hd__and3_2
XFILLER_87_125 VGND VGND VPWR VPWR sky130_fd_sc_hd__decap_3
X_4207_ _4207_/A _4207_/B VGND VGND VPWR VPWR _4207_/Y sky130_fd_sc_hd__xnor2_2
XFILLER_87_169 VGND VGND VPWR VPWR sky130_fd_sc_hd__fill_2
XFILLER_87_158 VGND VGND VPWR VPWR sky130_fd_sc_hd__decap_3
XFILLER_28_203 VGND VGND VPWR VPWR sky130_fd_sc_hd__fill_2
X_5187_ _5251_/CLK _5187_/D VGND VGND VPWR VPWR _5187_/Q sky130_fd_sc_hd__dfxtp_2
X_4138_ _4138_/A _4138_/B _4138_/C VGND VGND VPWR VPWR _4138_/X sky130_fd_sc_hd__and3_2
XFILLER_83_320 VGND VGND VPWR VPWR sky130_fd_sc_hd__decap_3
XFILLER_43_206 VGND VGND VPWR VPWR sky130_fd_sc_hd__decap_3
X_4069_ _4069_/A _4378_/A VGND VGND VPWR VPWR _4070_/B sky130_fd_sc_hd__nor2_2
XTAP_TAPCELL_ROW_54_713 VGND VPWR sky130_fd_sc_hd__tapvpwrvgnd_1
XFILLER_83_353 VGND VGND VPWR VPWR sky130_fd_sc_hd__decap_3
XFILLER_43_239 VGND VGND VPWR VPWR sky130_fd_sc_hd__decap_3
XFILLER_71_548 VGND VGND VPWR VPWR sky130_fd_sc_hd__decap_3
XFILLER_24_453 VGND VGND VPWR VPWR sky130_fd_sc_hd__decap_3
XTAP_TAPCELL_ROW_26_448 VGND VPWR sky130_fd_sc_hd__tapvpwrvgnd_1
XFILLER_24_486 VGND VGND VPWR VPWR sky130_fd_sc_hd__decap_3
XFILLER_51_261 VGND VGND VPWR VPWR sky130_fd_sc_hd__fill_2
XTAP_TAPCELL_ROW_62_790 VGND VPWR sky130_fd_sc_hd__tapvpwrvgnd_1
XFILLER_7_107 VGND VGND VPWR VPWR sky130_fd_sc_hd__decap_3
XFILLER_3_302 VGND VGND VPWR VPWR sky130_fd_sc_hd__decap_3
XFILLER_0_3 VGND VGND VPWR VPWR sky130_fd_sc_hd__decap_3
XPHY_EDGE_ROW_5_Left_99 VGND VGND VPWR VPWR sky130_fd_sc_hd__decap_3
XFILLER_66_309 VGND VGND VPWR VPWR sky130_fd_sc_hd__decap_3
XFILLER_78_158 VGND VGND VPWR VPWR sky130_fd_sc_hd__decap_3
XFILLER_78_136 VGND VGND VPWR VPWR sky130_fd_sc_hd__decap_3
XFILLER_47_501 VGND VGND VPWR VPWR sky130_fd_sc_hd__decap_3
XFILLER_47_523 VGND VGND VPWR VPWR sky130_fd_sc_hd__decap_3
XFILLER_59_361 VGND VGND VPWR VPWR sky130_fd_sc_hd__decap_3
XFILLER_19_225 VGND VGND VPWR VPWR sky130_fd_sc_hd__decap_3
XFILLER_19_247 VGND VGND VPWR VPWR sky130_fd_sc_hd__decap_3
XFILLER_47_84 VGND VGND VPWR VPWR sky130_fd_sc_hd__fill_2
XFILLER_15_420 VGND VGND VPWR VPWR sky130_fd_sc_hd__decap_3
XFILLER_74_386 VGND VGND VPWR VPWR sky130_fd_sc_hd__decap_3
XFILLER_30_401 VGND VGND VPWR VPWR sky130_fd_sc_hd__decap_3
XFILLER_63_72 VGND VGND VPWR VPWR sky130_fd_sc_hd__decap_3
XFILLER_8_12 VGND VGND VPWR VPWR sky130_fd_sc_hd__decap_3
XFILLER_30_489 VGND VGND VPWR VPWR sky130_fd_sc_hd__decap_3
XFILLER_8_67 VGND VGND VPWR VPWR sky130_fd_sc_hd__decap_3
XFILLER_10_180 VGND VGND VPWR VPWR sky130_fd_sc_hd__decap_3
XFILLER_6_184 VGND VGND VPWR VPWR sky130_fd_sc_hd__decap_3
X_3440_ _3440_/A _3440_/B VGND VGND VPWR VPWR _3440_/Y sky130_fd_sc_hd__xnor2_2
X_3371_ _5189_/Q _4847_/B _3370_/X _3338_/B VGND VGND VPWR VPWR _5189_/D sky130_fd_sc_hd__o211a_2
X_5110_ _5110_/CLK _5110_/D VGND VGND VPWR VPWR _5110_/Q sky130_fd_sc_hd__dfxtp_2
XFILLER_69_147 VGND VGND VPWR VPWR sky130_fd_sc_hd__decap_3
X_5041_ _5110_/CLK _5041_/D VGND VGND VPWR VPWR _5041_/Q sky130_fd_sc_hd__dfxtp_2
XFILLER_38_556 VGND VGND VPWR VPWR sky130_fd_sc_hd__fill_2
XTAP_TAPCELL_ROW_68_849 VGND VPWR sky130_fd_sc_hd__tapvpwrvgnd_1
XFILLER_65_364 VGND VGND VPWR VPWR sky130_fd_sc_hd__decap_3
XFILLER_92_194 VGND VGND VPWR VPWR sky130_fd_sc_hd__fill_2
XFILLER_80_312 VGND VGND VPWR VPWR sky130_fd_sc_hd__decap_3
XFILLER_80_345 VGND VGND VPWR VPWR sky130_fd_sc_hd__decap_3
XTAP_TAPCELL_ROW_23_418 VGND VPWR sky130_fd_sc_hd__tapvpwrvgnd_1
X_4825_ _5270_/Q _4847_/B _4824_/Y VGND VGND VPWR VPWR _5270_/D sky130_fd_sc_hd__o21a_2
XFILLER_21_467 VGND VGND VPWR VPWR sky130_fd_sc_hd__decap_3
X_4756_ _4756_/A _4756_/B VGND VGND VPWR VPWR _4758_/A sky130_fd_sc_hd__nor2_2
XTAP_TAPCELL_ROW_31_495 VGND VPWR sky130_fd_sc_hd__tapvpwrvgnd_1
X_4687_ _3363_/A _4213_/A _4687_/S VGND VGND VPWR VPWR _4687_/X sky130_fd_sc_hd__mux2_1
X_3707_ _3693_/A _3706_/X _5134_/Q VGND VGND VPWR VPWR _3707_/X sky130_fd_sc_hd__o21a_2
X_3638_ _4963_/Q _4947_/Q _4931_/Q _4915_/Q _5131_/Q _5132_/Q VGND VGND VPWR VPWR
+ _3638_/X sky130_fd_sc_hd__mux4_2
X_3569_ _4069_/A _4175_/A VGND VGND VPWR VPWR _3569_/X sky130_fd_sc_hd__or2_2
XFILLER_68_39 VGND VGND VPWR VPWR sky130_fd_sc_hd__decap_3
XFILLER_88_467 VGND VGND VPWR VPWR sky130_fd_sc_hd__decap_3
XFILLER_88_445 VGND VGND VPWR VPWR sky130_fd_sc_hd__decap_3
X_5239_ _5285_/CLK _5239_/D VGND VGND VPWR VPWR _5239_/Q sky130_fd_sc_hd__dfxtp_2
XFILLER_56_331 VGND VGND VPWR VPWR sky130_fd_sc_hd__decap_3
XFILLER_16_206 VGND VGND VPWR VPWR sky130_fd_sc_hd__decap_3
XFILLER_56_342 VGND VGND VPWR VPWR sky130_fd_sc_hd__decap_3
XFILLER_56_375 VGND VGND VPWR VPWR sky130_fd_sc_hd__decap_3
XTAP_TAPCELL_ROW_39_573 VGND VPWR sky130_fd_sc_hd__tapvpwrvgnd_1
XFILLER_83_172 VGND VGND VPWR VPWR sky130_fd_sc_hd__decap_3
XFILLER_83_161 VGND VGND VPWR VPWR sky130_fd_sc_hd__decap_3
XFILLER_24_261 VGND VGND VPWR VPWR sky130_fd_sc_hd__fill_2
XFILLER_33_31 VGND VGND VPWR VPWR sky130_fd_sc_hd__decap_3
XFILLER_12_489 VGND VGND VPWR VPWR sky130_fd_sc_hd__decap_3
XFILLER_79_401 VGND VGND VPWR VPWR sky130_fd_sc_hd__decap_3
XFILLER_79_467 VGND VGND VPWR VPWR sky130_fd_sc_hd__decap_3
XFILLER_58_83 VGND VGND VPWR VPWR sky130_fd_sc_hd__fill_1
XFILLER_58_94 VGND VGND VPWR VPWR sky130_fd_sc_hd__fill_1
XFILLER_47_342 VGND VGND VPWR VPWR sky130_fd_sc_hd__decap_3
XFILLER_74_150 VGND VGND VPWR VPWR sky130_fd_sc_hd__decap_3
XTAP_TAPCELL_ROW_65_819 VGND VPWR sky130_fd_sc_hd__tapvpwrvgnd_1
XFILLER_35_526 VGND VGND VPWR VPWR sky130_fd_sc_hd__decap_3
XFILLER_62_312 VGND VGND VPWR VPWR sky130_fd_sc_hd__decap_3
XFILLER_62_356 VGND VGND VPWR VPWR sky130_fd_sc_hd__decap_3
XFILLER_74_71 VGND VGND VPWR VPWR sky130_fd_sc_hd__decap_3
XFILLER_22_209 VGND VGND VPWR VPWR sky130_fd_sc_hd__decap_3
XFILLER_50_529 VGND VGND VPWR VPWR sky130_fd_sc_hd__decap_3
X_2940_ _5275_/Q _5206_/Q _2947_/B1 _5238_/Q VGND VGND VPWR VPWR _2941_/B sky130_fd_sc_hd__a22o_2
XTAP_TAPCELL_ROW_73_896 VGND VPWR sky130_fd_sc_hd__tapvpwrvgnd_1
X_2871_ _2873_/A _2871_/B VGND VGND VPWR VPWR _2871_/Y sky130_fd_sc_hd__nor2_2
XFILLER_30_242 VGND VGND VPWR VPWR sky130_fd_sc_hd__decap_3
X_4610_ _4138_/B _4605_/X _4609_/X _4541_/X VGND VGND VPWR VPWR _4610_/X sky130_fd_sc_hd__a31o_2
X_4541_ _5182_/Q _5181_/Q _4854_/B VGND VGND VPWR VPWR _4541_/X sky130_fd_sc_hd__a21o_2
X_4472_ _4595_/B _4472_/B VGND VGND VPWR VPWR _4472_/X sky130_fd_sc_hd__or2_2
Xmax_cap135 _2902_/B VGND VGND VPWR VPWR _2951_/B2 sky130_fd_sc_hd__buf_6
Xmax_cap124 _3515_/X VGND VGND VPWR VPWR _4078_/B sky130_fd_sc_hd__buf_8
Xmax_cap113 _4420_/B VGND VGND VPWR VPWR _4681_/S sky130_fd_sc_hd__buf_4
XFILLER_7_493 VGND VGND VPWR VPWR sky130_fd_sc_hd__decap_3
Xmax_cap157 _3562_/A VGND VGND VPWR VPWR _2703_/A sky130_fd_sc_hd__buf_4
Xmax_cap168 _5157_/Q VGND VGND VPWR VPWR _4732_/A sky130_fd_sc_hd__buf_8
X_3423_ _3424_/B _3424_/C _3424_/D _3424_/A VGND VGND VPWR VPWR _3423_/Y sky130_fd_sc_hd__a22oi_2
Xmax_cap179 _5129_/Q VGND VGND VPWR VPWR _2660_/A sky130_fd_sc_hd__buf_8
X_3354_ _5283_/Q _3366_/A _3354_/C VGND VGND VPWR VPWR _3354_/X sky130_fd_sc_hd__and3_2
X_3285_ _5267_/Q _3305_/B VGND VGND VPWR VPWR _3285_/X sky130_fd_sc_hd__or2_2
XFILLER_85_426 VGND VGND VPWR VPWR sky130_fd_sc_hd__fill_2
XFILLER_85_415 VGND VGND VPWR VPWR sky130_fd_sc_hd__fill_1
X_5024_ clkload7/A _5024_/D VGND VGND VPWR VPWR _5024_/Q sky130_fd_sc_hd__dfxtp_2
XFILLER_38_342 VGND VGND VPWR VPWR sky130_fd_sc_hd__decap_3
XTAP_TAPCELL_ROW_88_1040 VGND VPWR sky130_fd_sc_hd__tapvpwrvgnd_1
XFILLER_38_386 VGND VGND VPWR VPWR sky130_fd_sc_hd__decap_3
XFILLER_65_172 VGND VGND VPWR VPWR sky130_fd_sc_hd__decap_3
XFILLER_93_492 VGND VGND VPWR VPWR sky130_fd_sc_hd__decap_3
XFILLER_26_548 VGND VGND VPWR VPWR sky130_fd_sc_hd__decap_3
XTAP_TAPCELL_ROW_36_543 VGND VPWR sky130_fd_sc_hd__tapvpwrvgnd_1
XFILLER_41_518 VGND VGND VPWR VPWR sky130_fd_sc_hd__decap_3
XFILLER_53_378 VGND VGND VPWR VPWR sky130_fd_sc_hd__decap_3
XFILLER_21_220 VGND VGND VPWR VPWR sky130_fd_sc_hd__decap_3
XFILLER_21_231 VGND VGND VPWR VPWR sky130_fd_sc_hd__decap_3
X_4808_ _5167_/Q _4808_/B VGND VGND VPWR VPWR _4809_/B sky130_fd_sc_hd__nor2_2
X_4739_ _4739_/A _4739_/B VGND VGND VPWR VPWR _4742_/A sky130_fd_sc_hd__nor2_2
XFILLER_79_16 VGND VGND VPWR VPWR sky130_fd_sc_hd__fill_1
XFILLER_0_113 VGND VGND VPWR VPWR sky130_fd_sc_hd__decap_3
XTAP_TAPCELL_ROW_8_279 VGND VPWR sky130_fd_sc_hd__tapvpwrvgnd_1
XFILLER_88_242 VGND VGND VPWR VPWR sky130_fd_sc_hd__fill_1
XFILLER_48_106 VGND VGND VPWR VPWR sky130_fd_sc_hd__decap_3
XFILLER_88_253 VGND VGND VPWR VPWR sky130_fd_sc_hd__fill_2
XFILLER_76_404 VGND VGND VPWR VPWR sky130_fd_sc_hd__decap_3
XFILLER_28_97 VGND VGND VPWR VPWR sky130_fd_sc_hd__decap_3
XFILLER_56_183 VGND VGND VPWR VPWR sky130_fd_sc_hd__decap_3
XFILLER_84_492 VGND VGND VPWR VPWR sky130_fd_sc_hd__fill_2
XFILLER_44_334 VGND VGND VPWR VPWR sky130_fd_sc_hd__decap_3
XFILLER_32_507 VGND VGND VPWR VPWR sky130_fd_sc_hd__decap_3
XFILLER_12_220 VGND VGND VPWR VPWR sky130_fd_sc_hd__decap_3
XFILLER_44_85 VGND VGND VPWR VPWR sky130_fd_sc_hd__fill_2
XFILLER_12_253 VGND VGND VPWR VPWR sky130_fd_sc_hd__fill_1
XTAP_TAPCELL_ROW_70_866 VGND VPWR sky130_fd_sc_hd__tapvpwrvgnd_1
XFILLER_12_297 VGND VGND VPWR VPWR sky130_fd_sc_hd__decap_3
XFILLER_5_35 VGND VGND VPWR VPWR sky130_fd_sc_hd__decap_3
XFILLER_4_485 VGND VGND VPWR VPWR sky130_fd_sc_hd__decap_3
XFILLER_5_68 VGND VGND VPWR VPWR sky130_fd_sc_hd__fill_1
XFILLER_69_82 VGND VGND VPWR VPWR sky130_fd_sc_hd__decap_3
XFILLER_79_253 VGND VGND VPWR VPWR sky130_fd_sc_hd__decap_3
XFILLER_67_426 VGND VGND VPWR VPWR sky130_fd_sc_hd__decap_3
X_3070_ _2911_/X _3066_/B _3066_/Y _4986_/Q VGND VGND VPWR VPWR _4986_/D sky130_fd_sc_hd__a22o_2
XTAP_TAPCELL_ROW_78_944 VGND VPWR sky130_fd_sc_hd__tapvpwrvgnd_1
XFILLER_54_109 VGND VGND VPWR VPWR sky130_fd_sc_hd__decap_3
XFILLER_82_407 VGND VGND VPWR VPWR sky130_fd_sc_hd__decap_3
XFILLER_35_334 VGND VGND VPWR VPWR sky130_fd_sc_hd__fill_2
XFILLER_75_492 VGND VGND VPWR VPWR sky130_fd_sc_hd__decap_3
XFILLER_23_529 VGND VGND VPWR VPWR sky130_fd_sc_hd__decap_3
XFILLER_90_462 VGND VGND VPWR VPWR sky130_fd_sc_hd__decap_3
XFILLER_50_326 VGND VGND VPWR VPWR sky130_fd_sc_hd__fill_1
XFILLER_50_348 VGND VGND VPWR VPWR sky130_fd_sc_hd__decap_3
X_3972_ _4078_/A _4183_/B _3971_/Y _4225_/A VGND VGND VPWR VPWR _3972_/X sky130_fd_sc_hd__o22a_2
XTAP_TAPCELL_ROW_33_513 VGND VPWR sky130_fd_sc_hd__tapvpwrvgnd_1
X_2923_ _5277_/Q _5249_/Q _5201_/Q _5275_/Q VGND VGND VPWR VPWR _2923_/X sky130_fd_sc_hd__a22o_2
X_2854_ _4966_/Q _4950_/Q _4934_/Q _4918_/Q _2854_/S0 _2854_/S1 VGND VGND VPWR VPWR
+ _2854_/X sky130_fd_sc_hd__mux4_2
X_2785_ _2857_/A _4777_/B VGND VGND VPWR VPWR _2785_/X sky130_fd_sc_hd__and2_2
XTAP_TAPCELL_ROW_41_590 VGND VPWR sky130_fd_sc_hd__tapvpwrvgnd_1
X_4524_ _4524_/A _4571_/B VGND VGND VPWR VPWR _4524_/X sky130_fd_sc_hd__or2_2
X_4455_ _3871_/X _4411_/X _4454_/X _4278_/X VGND VGND VPWR VPWR _4455_/X sky130_fd_sc_hd__a31o_2
X_4386_ _4386_/A _4386_/B VGND VGND VPWR VPWR _4464_/A sky130_fd_sc_hd__or2_2
X_3406_ _3406_/A _3406_/B VGND VGND VPWR VPWR _3408_/A sky130_fd_sc_hd__nor2_2
X_3337_ _5166_/Q _3230_/B _3230_/Y _3336_/X VGND VGND VPWR VPWR _5166_/D sky130_fd_sc_hd__o22a_2
XFILLER_58_448 VGND VGND VPWR VPWR sky130_fd_sc_hd__decap_3
XTAP_TAPCELL_ROW_5_249 VGND VPWR sky130_fd_sc_hd__tapvpwrvgnd_1
X_3268_ _3270_/B _3267_/Y _3305_/B VGND VGND VPWR VPWR _3268_/Y sky130_fd_sc_hd__o21ai_2
XFILLER_85_245 VGND VGND VPWR VPWR sky130_fd_sc_hd__fill_1
X_5007_ _5177_/CLK _5007_/D VGND VGND VPWR VPWR _5007_/Q sky130_fd_sc_hd__dfxtp_2
X_3199_ _2918_/X _3193_/B _3193_/Y _5100_/Q VGND VGND VPWR VPWR _5100_/D sky130_fd_sc_hd__a22o_2
XFILLER_26_323 VGND VGND VPWR VPWR sky130_fd_sc_hd__decap_3
XFILLER_66_492 VGND VGND VPWR VPWR sky130_fd_sc_hd__fill_2
XFILLER_14_529 VGND VGND VPWR VPWR sky130_fd_sc_hd__decap_3
XFILLER_26_378 VGND VGND VPWR VPWR sky130_fd_sc_hd__decap_3
XFILLER_53_142 VGND VGND VPWR VPWR sky130_fd_sc_hd__decap_3
XFILLER_53_175 VGND VGND VPWR VPWR sky130_fd_sc_hd__fill_1
XFILLER_81_484 VGND VGND VPWR VPWR sky130_fd_sc_hd__decap_3
XFILLER_81_495 VGND VGND VPWR VPWR sky130_fd_sc_hd__decap_3
XFILLER_14_44 VGND VGND VPWR VPWR sky130_fd_sc_hd__decap_3
XFILLER_22_551 VGND VGND VPWR VPWR sky130_fd_sc_hd__decap_3
XFILLER_41_359 VGND VGND VPWR VPWR sky130_fd_sc_hd__fill_1
XFILLER_14_77 VGND VGND VPWR VPWR sky130_fd_sc_hd__decap_3
XFILLER_14_88 VGND VGND VPWR VPWR sky130_fd_sc_hd__decap_3
XFILLER_5_249 VGND VGND VPWR VPWR sky130_fd_sc_hd__decap_3
XFILLER_57_481 VGND VGND VPWR VPWR sky130_fd_sc_hd__fill_1
XTAP_TAPCELL_ROW_75_914 VGND VPWR sky130_fd_sc_hd__tapvpwrvgnd_1
XFILLER_76_289 VGND VGND VPWR VPWR sky130_fd_sc_hd__decap_3
XTAP_TAPCELL_ROW_47_649 VGND VPWR sky130_fd_sc_hd__tapvpwrvgnd_1
XFILLER_91_259 VGND VGND VPWR VPWR sky130_fd_sc_hd__decap_3
XFILLER_72_451 VGND VGND VPWR VPWR sky130_fd_sc_hd__decap_3
XFILLER_32_315 VGND VGND VPWR VPWR sky130_fd_sc_hd__fill_1
XFILLER_32_348 VGND VGND VPWR VPWR sky130_fd_sc_hd__decap_3
XFILLER_44_197 VGND VGND VPWR VPWR sky130_fd_sc_hd__decap_3
XFILLER_72_495 VGND VGND VPWR VPWR sky130_fd_sc_hd__decap_3
XTAP_TAPCELL_ROW_83_991 VGND VPWR sky130_fd_sc_hd__tapvpwrvgnd_1
XFILLER_40_381 VGND VGND VPWR VPWR sky130_fd_sc_hd__decap_3
X_2570_ _2677_/S _2570_/B VGND VGND VPWR VPWR _2570_/X sky130_fd_sc_hd__or2_2
XTAP_TAPCELL_ROW_10_295 VGND VPWR sky130_fd_sc_hd__tapvpwrvgnd_1
X_4240_ _4365_/A _4449_/S VGND VGND VPWR VPWR _4242_/B sky130_fd_sc_hd__nor2_2
X_4171_ _4191_/A _4171_/B VGND VGND VPWR VPWR _4186_/C sky130_fd_sc_hd__nor2_2
XFILLER_67_223 VGND VGND VPWR VPWR sky130_fd_sc_hd__fill_1
XFILLER_67_234 VGND VGND VPWR VPWR sky130_fd_sc_hd__decap_3
X_3122_ _2897_/X _3121_/B _3121_/Y _5031_/Q VGND VGND VPWR VPWR _5031_/D sky130_fd_sc_hd__a22o_2
XTAP_TAPCELL_ROW_2_219 VGND VPWR sky130_fd_sc_hd__tapvpwrvgnd_1
XFILLER_27_109 VGND VGND VPWR VPWR sky130_fd_sc_hd__decap_3
XFILLER_48_470 VGND VGND VPWR VPWR sky130_fd_sc_hd__decap_3
XFILLER_67_278 VGND VGND VPWR VPWR sky130_fd_sc_hd__fill_2
X_3053_ _2914_/X _3048_/B _3048_/Y _4971_/Q VGND VGND VPWR VPWR _4971_/D sky130_fd_sc_hd__a22o_2
XFILLER_48_492 VGND VGND VPWR VPWR sky130_fd_sc_hd__decap_3
XFILLER_63_440 VGND VGND VPWR VPWR sky130_fd_sc_hd__decap_3
XTAP_TAPCELL_ROW_85_1010 VGND VPWR sky130_fd_sc_hd__tapvpwrvgnd_1
XFILLER_82_259 VGND VGND VPWR VPWR sky130_fd_sc_hd__fill_2
XFILLER_63_473 VGND VGND VPWR VPWR sky130_fd_sc_hd__decap_3
XFILLER_23_315 VGND VGND VPWR VPWR sky130_fd_sc_hd__decap_3
XFILLER_63_495 VGND VGND VPWR VPWR sky130_fd_sc_hd__decap_3
XTAP_TAPCELL_ROW_18_373 VGND VPWR sky130_fd_sc_hd__tapvpwrvgnd_1
XFILLER_90_270 VGND VGND VPWR VPWR sky130_fd_sc_hd__decap_3
XFILLER_50_134 VGND VGND VPWR VPWR sky130_fd_sc_hd__decap_3
X_3955_ _3876_/Y _3904_/Y _3961_/S VGND VGND VPWR VPWR _4071_/B sky130_fd_sc_hd__mux2_1
XFILLER_50_178 VGND VGND VPWR VPWR sky130_fd_sc_hd__decap_3
X_2906_ _4872_/Q _2942_/A2 _2905_/X _2951_/B2 VGND VGND VPWR VPWR _4872_/D sky130_fd_sc_hd__a22o_2
XFILLER_31_381 VGND VGND VPWR VPWR sky130_fd_sc_hd__decap_3
X_3886_ _3891_/A _3886_/B VGND VGND VPWR VPWR _4379_/A sky130_fd_sc_hd__or2_2
X_2837_ _2835_/X _2836_/X _5137_/Q VGND VGND VPWR VPWR _2837_/X sky130_fd_sc_hd__mux2_1
X_2768_ _4893_/Q _4877_/Q _5101_/Q _5085_/Q _2851_/S0 _2854_/S1 VGND VGND VPWR VPWR
+ _2768_/X sky130_fd_sc_hd__mux4_2
X_4507_ _4434_/A _4334_/B _4333_/B _4379_/X VGND VGND VPWR VPWR _4507_/X sky130_fd_sc_hd__o22a_2
X_2699_ _4236_/A _2894_/A _2702_/B VGND VGND VPWR VPWR _2699_/X sky130_fd_sc_hd__and3_2
X_4438_ _4426_/A _4558_/S _4437_/X _4435_/X _4434_/X VGND VGND VPWR VPWR _4438_/X
+ sky130_fd_sc_hd__o311a_2
X_4369_ _4368_/A _4368_/B _4522_/A VGND VGND VPWR VPWR _4370_/B sky130_fd_sc_hd__a21o_2
XFILLER_86_521 VGND VGND VPWR VPWR sky130_fd_sc_hd__decap_3
XFILLER_46_407 VGND VGND VPWR VPWR sky130_fd_sc_hd__fill_1
XFILLER_58_256 VGND VGND VPWR VPWR sky130_fd_sc_hd__decap_3
XFILLER_39_492 VGND VGND VPWR VPWR sky130_fd_sc_hd__decap_3
XFILLER_25_21 VGND VGND VPWR VPWR sky130_fd_sc_hd__decap_3
XFILLER_54_473 VGND VGND VPWR VPWR sky130_fd_sc_hd__decap_3
XTAP_TAPCELL_ROW_44_619 VGND VPWR sky130_fd_sc_hd__tapvpwrvgnd_1
XFILLER_14_315 VGND VGND VPWR VPWR sky130_fd_sc_hd__decap_3
XFILLER_14_337 VGND VGND VPWR VPWR sky130_fd_sc_hd__fill_2
XFILLER_25_54 VGND VGND VPWR VPWR sky130_fd_sc_hd__fill_2
XFILLER_26_175 VGND VGND VPWR VPWR sky130_fd_sc_hd__decap_3
XFILLER_26_197 VGND VGND VPWR VPWR sky130_fd_sc_hd__decap_3
XFILLER_81_270 VGND VGND VPWR VPWR sky130_fd_sc_hd__decap_3
XFILLER_25_87 VGND VGND VPWR VPWR sky130_fd_sc_hd__decap_3
XTAP_TAPCELL_ROW_80_961 VGND VPWR sky130_fd_sc_hd__tapvpwrvgnd_1
XTAP_TAPCELL_ROW_52_696 VGND VPWR sky130_fd_sc_hd__tapvpwrvgnd_1
XFILLER_6_536 VGND VGND VPWR VPWR sky130_fd_sc_hd__fill_1
XFILLER_77_532 VGND VGND VPWR VPWR sky130_fd_sc_hd__decap_3
XFILLER_49_245 VGND VGND VPWR VPWR sky130_fd_sc_hd__decap_3
XFILLER_77_554 VGND VGND VPWR VPWR sky130_fd_sc_hd__decap_3
XFILLER_92_524 VGND VGND VPWR VPWR sky130_fd_sc_hd__decap_3
XFILLER_92_557 VGND VGND VPWR VPWR sky130_fd_sc_hd__fill_1
XFILLER_17_164 VGND VGND VPWR VPWR sky130_fd_sc_hd__decap_3
XFILLER_45_473 VGND VGND VPWR VPWR sky130_fd_sc_hd__decap_3
XFILLER_17_186 VGND VGND VPWR VPWR sky130_fd_sc_hd__decap_3
XFILLER_60_410 VGND VGND VPWR VPWR sky130_fd_sc_hd__decap_3
XFILLER_60_421 VGND VGND VPWR VPWR sky130_fd_sc_hd__fill_1
XFILLER_32_156 VGND VGND VPWR VPWR sky130_fd_sc_hd__decap_3
XFILLER_60_454 VGND VGND VPWR VPWR sky130_fd_sc_hd__fill_1
XTAP_TAPCELL_ROW_15_343 VGND VPWR sky130_fd_sc_hd__tapvpwrvgnd_1
XFILLER_82_93 VGND VGND VPWR VPWR sky130_fd_sc_hd__decap_3
XFILLER_82_82 VGND VGND VPWR VPWR sky130_fd_sc_hd__fill_2
XFILLER_20_329 VGND VGND VPWR VPWR sky130_fd_sc_hd__decap_3
X_3740_ _3740_/A _3740_/B VGND VGND VPWR VPWR _4022_/A sky130_fd_sc_hd__nor2_2
X_3671_ _4962_/Q _4946_/Q _4930_/Q _4914_/Q _3732_/S0 _3732_/S1 VGND VGND VPWR VPWR
+ _3671_/X sky130_fd_sc_hd__mux4_2
X_2622_ _3986_/A _2868_/B _2565_/Y VGND VGND VPWR VPWR _2870_/A sky130_fd_sc_hd__a21bo_2
Xoutput104 _2776_/X VGND VGND VPWR VPWR MEM_STR_DATA[6] sky130_fd_sc_hd__clkdlybuf4s25_1
X_2553_ _2624_/A VGND VGND VPWR VPWR _2553_/Y sky130_fd_sc_hd__inv_2
X_5272_ _5286_/CLK _5272_/D VGND VGND VPWR VPWR _5272_/Q sky130_fd_sc_hd__dfxtp_2
X_2484_ _4901_/Q _4885_/Q _5109_/Q _5093_/Q _2672_/S0 _2672_/S1 VGND VGND VPWR VPWR
+ _2485_/B sky130_fd_sc_hd__mux4_2
XFILLER_87_307 VGND VGND VPWR VPWR sky130_fd_sc_hd__decap_3
X_4223_ _4267_/S _4130_/X _4222_/Y VGND VGND VPWR VPWR _4227_/B sky130_fd_sc_hd__a21oi_2
X_4154_ _4200_/B _4379_/A VGND VGND VPWR VPWR _4154_/Y sky130_fd_sc_hd__nor2_2
X_4085_ _4084_/B _4084_/C _4189_/A _4090_/A VGND VGND VPWR VPWR _4085_/X sky130_fd_sc_hd__o211a_2
X_3105_ _2905_/X _3119_/A2 _3103_/Y _5016_/Q VGND VGND VPWR VPWR _5016_/D sky130_fd_sc_hd__a22o_2
XFILLER_55_237 VGND VGND VPWR VPWR sky130_fd_sc_hd__fill_1
X_3036_ _2921_/X _3028_/Y _3029_/Y _4957_/Q VGND VGND VPWR VPWR _4957_/D sky130_fd_sc_hd__a22o_2
XFILLER_70_207 VGND VGND VPWR VPWR sky130_fd_sc_hd__decap_3
XFILLER_36_495 VGND VGND VPWR VPWR sky130_fd_sc_hd__decap_3
XFILLER_63_270 VGND VGND VPWR VPWR sky130_fd_sc_hd__decap_3
XFILLER_63_281 VGND VGND VPWR VPWR sky130_fd_sc_hd__decap_3
XFILLER_51_465 VGND VGND VPWR VPWR sky130_fd_sc_hd__decap_3
XFILLER_51_498 VGND VGND VPWR VPWR sky130_fd_sc_hd__decap_3
X_4987_ clkload9/A _4987_/D VGND VGND VPWR VPWR _4987_/Q sky130_fd_sc_hd__dfxtp_2
X_3938_ _4320_/A _4313_/S VGND VGND VPWR VPWR _3938_/Y sky130_fd_sc_hd__nand2b_2
X_3869_ _3969_/S _3865_/X _4078_/B VGND VGND VPWR VPWR _3869_/Y sky130_fd_sc_hd__a21oi_2
XFILLER_11_23 VGND VGND VPWR VPWR sky130_fd_sc_hd__fill_1
XFILLER_3_517 VGND VGND VPWR VPWR sky130_fd_sc_hd__decap_3
XFILLER_78_318 VGND VGND VPWR VPWR sky130_fd_sc_hd__decap_3
XFILLER_78_307 VGND VGND VPWR VPWR sky130_fd_sc_hd__fill_1
XFILLER_59_532 VGND VGND VPWR VPWR sky130_fd_sc_hd__decap_3
XFILLER_59_554 VGND VGND VPWR VPWR sky130_fd_sc_hd__decap_3
XFILLER_19_418 VGND VGND VPWR VPWR sky130_fd_sc_hd__decap_3
XTAP_TAPCELL_ROW_57_744 VGND VPWR sky130_fd_sc_hd__tapvpwrvgnd_1
XFILLER_86_395 VGND VGND VPWR VPWR sky130_fd_sc_hd__decap_3
XFILLER_36_53 VGND VGND VPWR VPWR sky130_fd_sc_hd__decap_3
XTAP_TAPCELL_ROW_29_479 VGND VPWR sky130_fd_sc_hd__tapvpwrvgnd_1
XFILLER_14_112 VGND VGND VPWR VPWR sky130_fd_sc_hd__decap_3
XFILLER_27_484 VGND VGND VPWR VPWR sky130_fd_sc_hd__decap_3
XFILLER_54_292 VGND VGND VPWR VPWR sky130_fd_sc_hd__decap_3
XFILLER_42_498 VGND VGND VPWR VPWR sky130_fd_sc_hd__fill_2
XFILLER_52_52 VGND VGND VPWR VPWR sky130_fd_sc_hd__fill_2
XFILLER_52_85 VGND VGND VPWR VPWR sky130_fd_sc_hd__decap_3
XTAP_TAPCELL_ROW_12_313 VGND VPWR sky130_fd_sc_hd__tapvpwrvgnd_1
XFILLER_10_340 VGND VGND VPWR VPWR sky130_fd_sc_hd__decap_3
XFILLER_6_300 VGND VGND VPWR VPWR sky130_fd_sc_hd__decap_3
Xinput28 INSTR_STREAM[5] VGND VGND VPWR VPWR _3326_/C sky130_fd_sc_hd__clkdlybuf4s25_1
Xinput17 INSTR_STREAM[24] VGND VGND VPWR VPWR _3340_/C sky130_fd_sc_hd__clkdlybuf4s25_1
XFILLER_6_333 VGND VGND VPWR VPWR sky130_fd_sc_hd__decap_3
Xinput39 MEM_LD_DATA[15] VGND VGND VPWR VPWR input39/X sky130_fd_sc_hd__clkdlybuf4s25_1
XTAP_TAPCELL_ROW_20_390 VGND VPWR sky130_fd_sc_hd__tapvpwrvgnd_1
XFILLER_69_307 VGND VGND VPWR VPWR sky130_fd_sc_hd__decap_3
XFILLER_77_60 VGND VGND VPWR VPWR sky130_fd_sc_hd__decap_3
XFILLER_77_340 VGND VGND VPWR VPWR sky130_fd_sc_hd__decap_3
XFILLER_65_513 VGND VGND VPWR VPWR sky130_fd_sc_hd__decap_3
XFILLER_65_557 VGND VGND VPWR VPWR sky130_fd_sc_hd__fill_1
XFILLER_92_365 VGND VGND VPWR VPWR sky130_fd_sc_hd__fill_2
XFILLER_80_516 VGND VGND VPWR VPWR sky130_fd_sc_hd__decap_3
XFILLER_18_495 VGND VGND VPWR VPWR sky130_fd_sc_hd__decap_3
XFILLER_45_270 VGND VGND VPWR VPWR sky130_fd_sc_hd__decap_3
XFILLER_45_281 VGND VGND VPWR VPWR sky130_fd_sc_hd__decap_3
X_4910_ _5118_/CLK _4910_/D VGND VGND VPWR VPWR _4910_/Q sky130_fd_sc_hd__dfxtp_2
XFILLER_93_81 VGND VGND VPWR VPWR sky130_fd_sc_hd__decap_3
XFILLER_92_398 VGND VGND VPWR VPWR sky130_fd_sc_hd__decap_3
XFILLER_33_432 VGND VGND VPWR VPWR sky130_fd_sc_hd__decap_3
X_4841_ _4854_/B _4839_/Y _4840_/X _3338_/B VGND VGND VPWR VPWR _5272_/D sky130_fd_sc_hd__o211a_2
XFILLER_60_262 VGND VGND VPWR VPWR sky130_fd_sc_hd__decap_3
X_4772_ _4772_/A _4772_/B _4772_/C VGND VGND VPWR VPWR _4772_/X sky130_fd_sc_hd__and3_2
X_3723_ _3718_/X _3719_/X _3722_/X _2430_/Y VGND VGND VPWR VPWR _3725_/B sky130_fd_sc_hd__a22o_2
X_3654_ _4687_/S _3654_/B VGND VGND VPWR VPWR _4261_/A sky130_fd_sc_hd__nor2_2
X_2605_ _5063_/Q _5047_/Q _5031_/Q _5015_/Q _2672_/S0 _2672_/S1 VGND VGND VPWR VPWR
+ _2605_/X sky130_fd_sc_hd__mux4_2
X_3585_ _4320_/B _4286_/B VGND VGND VPWR VPWR _3888_/A sky130_fd_sc_hd__nand2_2
X_2536_ _5129_/Q _2533_/X _5130_/Q VGND VGND VPWR VPWR _2536_/X sky130_fd_sc_hd__o21a_2
X_5255_ _5257_/CLK _5255_/D VGND VGND VPWR VPWR _5255_/Q sky130_fd_sc_hd__dfxtp_2
X_2467_ _5286_/Q _2467_/B VGND VGND VPWR VPWR _4854_/B sky130_fd_sc_hd__nand2_8
X_4206_ _3841_/X _4686_/B1 _4192_/Y _4203_/X _4205_/X VGND VGND VPWR VPWR _4206_/X
+ sky130_fd_sc_hd__o311a_2
XFILLER_87_137 VGND VGND VPWR VPWR sky130_fd_sc_hd__decap_3
XFILLER_56_513 VGND VGND VPWR VPWR sky130_fd_sc_hd__decap_3
XFILLER_68_351 VGND VGND VPWR VPWR sky130_fd_sc_hd__decap_3
XFILLER_68_373 VGND VGND VPWR VPWR sky130_fd_sc_hd__decap_3
X_5186_ _5251_/CLK _5186_/D VGND VGND VPWR VPWR _5186_/Q sky130_fd_sc_hd__dfxtp_2
X_4137_ _4225_/A _3859_/X _4134_/Y _4135_/X _4136_/Y VGND VGND VPWR VPWR _4138_/C
+ sky130_fd_sc_hd__o2111a_2
XFILLER_28_259 VGND VGND VPWR VPWR sky130_fd_sc_hd__decap_3
XFILLER_71_505 VGND VGND VPWR VPWR sky130_fd_sc_hd__decap_3
X_4068_ _2629_/Y _4056_/X _3826_/Y VGND VGND VPWR VPWR _4086_/B sky130_fd_sc_hd__a21oi_2
XFILLER_24_410 VGND VGND VPWR VPWR sky130_fd_sc_hd__decap_3
XFILLER_24_421 VGND VGND VPWR VPWR sky130_fd_sc_hd__decap_3
XFILLER_43_218 VGND VGND VPWR VPWR sky130_fd_sc_hd__decap_3
XFILLER_73_29 VGND VGND VPWR VPWR sky130_fd_sc_hd__decap_3
X_3019_ _2924_/X _3011_/B _3011_/Y _4942_/Q VGND VGND VPWR VPWR _4942_/D sky130_fd_sc_hd__a22o_2
XTAP_TAPCELL_ROW_54_714 VGND VPWR sky130_fd_sc_hd__tapvpwrvgnd_1
XTAP_TAPCELL_ROW_26_449 VGND VPWR sky130_fd_sc_hd__tapvpwrvgnd_1
XFILLER_24_465 VGND VGND VPWR VPWR sky130_fd_sc_hd__fill_2
XFILLER_51_284 VGND VGND VPWR VPWR sky130_fd_sc_hd__decap_3
XTAP_TAPCELL_ROW_62_791 VGND VPWR sky130_fd_sc_hd__tapvpwrvgnd_1
XFILLER_7_119 VGND VGND VPWR VPWR sky130_fd_sc_hd__decap_3
XFILLER_22_55 VGND VGND VPWR VPWR sky130_fd_sc_hd__fill_2
XFILLER_19_204 VGND VGND VPWR VPWR sky130_fd_sc_hd__decap_3
XFILLER_59_373 VGND VGND VPWR VPWR sky130_fd_sc_hd__fill_1
XFILLER_59_384 VGND VGND VPWR VPWR sky130_fd_sc_hd__decap_3
XFILLER_62_505 VGND VGND VPWR VPWR sky130_fd_sc_hd__decap_3
XFILLER_74_365 VGND VGND VPWR VPWR sky130_fd_sc_hd__decap_3
XFILLER_62_527 VGND VGND VPWR VPWR sky130_fd_sc_hd__decap_3
XFILLER_74_398 VGND VGND VPWR VPWR sky130_fd_sc_hd__decap_3
XFILLER_15_443 VGND VGND VPWR VPWR sky130_fd_sc_hd__decap_3
XFILLER_27_281 VGND VGND VPWR VPWR sky130_fd_sc_hd__decap_3
XFILLER_30_413 VGND VGND VPWR VPWR sky130_fd_sc_hd__decap_3
XFILLER_42_240 VGND VGND VPWR VPWR sky130_fd_sc_hd__decap_3
XFILLER_42_273 VGND VGND VPWR VPWR sky130_fd_sc_hd__decap_3
XFILLER_63_84 VGND VGND VPWR VPWR sky130_fd_sc_hd__decap_3
XFILLER_30_424 VGND VGND VPWR VPWR sky130_fd_sc_hd__decap_3
XFILLER_42_284 VGND VGND VPWR VPWR sky130_fd_sc_hd__decap_3
XFILLER_8_24 VGND VGND VPWR VPWR sky130_fd_sc_hd__decap_3
XFILLER_30_457 VGND VGND VPWR VPWR sky130_fd_sc_hd__decap_3
XFILLER_8_79 VGND VGND VPWR VPWR sky130_fd_sc_hd__decap_3
XFILLER_10_192 VGND VGND VPWR VPWR sky130_fd_sc_hd__decap_3
XFILLER_6_130 VGND VGND VPWR VPWR sky130_fd_sc_hd__decap_3
XFILLER_6_141 VGND VGND VPWR VPWR sky130_fd_sc_hd__decap_3
X_3370_ _5185_/Q _5184_/Q _2463_/A _3369_/Y _4854_/B VGND VGND VPWR VPWR _3370_/X
+ sky130_fd_sc_hd__a41o_2
XFILLER_69_159 VGND VGND VPWR VPWR sky130_fd_sc_hd__decap_3
X_5040_ clkload7/A _5040_/D VGND VGND VPWR VPWR _5040_/Q sky130_fd_sc_hd__dfxtp_2
XFILLER_26_3 VGND VGND VPWR VPWR sky130_fd_sc_hd__decap_3
XFILLER_38_502 VGND VGND VPWR VPWR sky130_fd_sc_hd__decap_3
XFILLER_38_524 VGND VGND VPWR VPWR sky130_fd_sc_hd__decap_3
XFILLER_77_181 VGND VGND VPWR VPWR sky130_fd_sc_hd__decap_3
XFILLER_53_505 VGND VGND VPWR VPWR sky130_fd_sc_hd__decap_3
XFILLER_65_343 VGND VGND VPWR VPWR sky130_fd_sc_hd__decap_3
XFILLER_65_376 VGND VGND VPWR VPWR sky130_fd_sc_hd__decap_3
XFILLER_18_281 VGND VGND VPWR VPWR sky130_fd_sc_hd__decap_3
XFILLER_80_357 VGND VGND VPWR VPWR sky130_fd_sc_hd__decap_3
XTAP_TAPCELL_ROW_23_419 VGND VPWR sky130_fd_sc_hd__tapvpwrvgnd_1
XFILLER_80_379 VGND VGND VPWR VPWR sky130_fd_sc_hd__decap_3
XFILLER_33_284 VGND VGND VPWR VPWR sky130_fd_sc_hd__decap_3
X_4824_ _4847_/B _4823_/X _3494_/A VGND VGND VPWR VPWR _4824_/Y sky130_fd_sc_hd__a21oi_2
XFILLER_21_479 VGND VGND VPWR VPWR sky130_fd_sc_hd__decap_3
X_4755_ _5160_/Q _4755_/B VGND VGND VPWR VPWR _4756_/B sky130_fd_sc_hd__nor2_2
X_3706_ _5071_/Q _5055_/Q _5039_/Q _5023_/Q _3706_/S0 _3706_/S1 VGND VGND VPWR VPWR
+ _3706_/X sky130_fd_sc_hd__mux4_2
X_4686_ _5171_/Q _4191_/A _4686_/B1 VGND VGND VPWR VPWR _4686_/X sky130_fd_sc_hd__o21a_2
XTAP_TAPCELL_ROW_31_496 VGND VPWR sky130_fd_sc_hd__tapvpwrvgnd_1
X_3637_ _5123_/Q _5011_/Q _4995_/Q _4979_/Q _5131_/Q _5132_/Q VGND VGND VPWR VPWR
+ _3637_/X sky130_fd_sc_hd__mux4_2
X_3568_ _4069_/A _4175_/A VGND VGND VPWR VPWR _4070_/A sky130_fd_sc_hd__nor2_2
X_2519_ _5168_/Q _3642_/A VGND VGND VPWR VPWR _2521_/B sky130_fd_sc_hd__nor2_2
X_3499_ _5066_/Q _5050_/Q _5034_/Q _5018_/Q _5131_/Q _5132_/Q VGND VGND VPWR VPWR
+ _3499_/X sky130_fd_sc_hd__mux4_2
XFILLER_88_457 VGND VGND VPWR VPWR sky130_fd_sc_hd__decap_3
XFILLER_29_513 VGND VGND VPWR VPWR sky130_fd_sc_hd__decap_3
X_5238_ _5285_/CLK _5238_/D VGND VGND VPWR VPWR _5238_/Q sky130_fd_sc_hd__dfxtp_2
X_5169_ _5271_/CLK _5169_/D VGND VGND VPWR VPWR _5169_/Q sky130_fd_sc_hd__dfxtp_2
XFILLER_29_557 VGND VGND VPWR VPWR sky130_fd_sc_hd__fill_1
XFILLER_56_354 VGND VGND VPWR VPWR sky130_fd_sc_hd__fill_2
XFILLER_84_39 VGND VGND VPWR VPWR sky130_fd_sc_hd__decap_3
XFILLER_16_218 VGND VGND VPWR VPWR sky130_fd_sc_hd__decap_3
XFILLER_56_398 VGND VGND VPWR VPWR sky130_fd_sc_hd__decap_3
XFILLER_71_324 VGND VGND VPWR VPWR sky130_fd_sc_hd__decap_3
XTAP_TAPCELL_ROW_39_574 VGND VPWR sky130_fd_sc_hd__tapvpwrvgnd_1
XFILLER_83_184 VGND VGND VPWR VPWR sky130_fd_sc_hd__decap_3
XFILLER_71_335 VGND VGND VPWR VPWR sky130_fd_sc_hd__fill_1
XFILLER_71_346 VGND VGND VPWR VPWR sky130_fd_sc_hd__decap_3
XFILLER_24_251 VGND VGND VPWR VPWR sky130_fd_sc_hd__fill_1
XFILLER_71_379 VGND VGND VPWR VPWR sky130_fd_sc_hd__decap_3
XFILLER_12_424 VGND VGND VPWR VPWR sky130_fd_sc_hd__decap_3
XFILLER_24_295 VGND VGND VPWR VPWR sky130_fd_sc_hd__decap_3
XFILLER_33_76 VGND VGND VPWR VPWR sky130_fd_sc_hd__fill_1
XFILLER_8_417 VGND VGND VPWR VPWR sky130_fd_sc_hd__decap_3
XFILLER_3_166 VGND VGND VPWR VPWR sky130_fd_sc_hd__fill_2
XFILLER_79_435 VGND VGND VPWR VPWR sky130_fd_sc_hd__decap_3
XFILLER_66_118 VGND VGND VPWR VPWR sky130_fd_sc_hd__decap_3
XFILLER_12_9 VGND VGND VPWR VPWR sky130_fd_sc_hd__fill_1
XFILLER_47_310 VGND VGND VPWR VPWR sky130_fd_sc_hd__decap_3
XFILLER_35_505 VGND VGND VPWR VPWR sky130_fd_sc_hd__decap_3
XFILLER_62_302 VGND VGND VPWR VPWR sky130_fd_sc_hd__decap_3
XFILLER_62_324 VGND VGND VPWR VPWR sky130_fd_sc_hd__decap_3
XFILLER_74_83 VGND VGND VPWR VPWR sky130_fd_sc_hd__fill_1
XFILLER_74_94 VGND VGND VPWR VPWR sky130_fd_sc_hd__fill_1
XFILLER_15_240 VGND VGND VPWR VPWR sky130_fd_sc_hd__decap_3
XTAP_TAPCELL_ROW_73_897 VGND VPWR sky130_fd_sc_hd__tapvpwrvgnd_1
XFILLER_15_295 VGND VGND VPWR VPWR sky130_fd_sc_hd__decap_3
X_2870_ _2870_/A _3775_/B VGND VGND VPWR VPWR _2871_/B sky130_fd_sc_hd__xnor2_2
XFILLER_90_82 VGND VGND VPWR VPWR sky130_fd_sc_hd__fill_2
XFILLER_30_298 VGND VGND VPWR VPWR sky130_fd_sc_hd__decap_3
X_4540_ _5231_/Q _4854_/B VGND VGND VPWR VPWR _4540_/Y sky130_fd_sc_hd__nand2_2
X_4471_ _4470_/X _4535_/A _4681_/S VGND VGND VPWR VPWR _4472_/B sky130_fd_sc_hd__mux2_1
Xmax_cap125 _3211_/B VGND VGND VPWR VPWR _3227_/A2 sky130_fd_sc_hd__buf_6
Xmax_cap114 _4486_/S VGND VGND VPWR VPWR _4515_/B sky130_fd_sc_hd__buf_6
Xmax_cap158 _4021_/B VGND VGND VPWR VPWR _4261_/C sky130_fd_sc_hd__buf_8
Xmax_cap147 _4397_/A VGND VGND VPWR VPWR _3701_/A sky130_fd_sc_hd__buf_6
X_3422_ _3408_/A _3408_/B _3415_/B _3406_/A VGND VGND VPWR VPWR _3424_/D sky130_fd_sc_hd__a211o_2
Xmax_cap169 _5137_/Q VGND VGND VPWR VPWR _2855_/S sky130_fd_sc_hd__buf_8
X_3353_ _5186_/Q _3230_/B _3230_/Y _3352_/X VGND VGND VPWR VPWR _5186_/D sky130_fd_sc_hd__o22a_2
X_3284_ _5146_/Q _3297_/B VGND VGND VPWR VPWR _3284_/X sky130_fd_sc_hd__xor2_2
XFILLER_38_321 VGND VGND VPWR VPWR sky130_fd_sc_hd__decap_3
X_5023_ _5103_/CLK _5023_/D VGND VGND VPWR VPWR _5023_/Q sky130_fd_sc_hd__dfxtp_2
XFILLER_85_449 VGND VGND VPWR VPWR sky130_fd_sc_hd__decap_3
XFILLER_38_354 VGND VGND VPWR VPWR sky130_fd_sc_hd__decap_3
XTAP_TAPCELL_ROW_88_1041 VGND VPWR sky130_fd_sc_hd__tapvpwrvgnd_1
XFILLER_26_516 VGND VGND VPWR VPWR sky130_fd_sc_hd__decap_3
XFILLER_38_365 VGND VGND VPWR VPWR sky130_fd_sc_hd__decap_3
XFILLER_38_398 VGND VGND VPWR VPWR sky130_fd_sc_hd__decap_3
XFILLER_53_335 VGND VGND VPWR VPWR sky130_fd_sc_hd__fill_1
XFILLER_65_184 VGND VGND VPWR VPWR sky130_fd_sc_hd__fill_1
XTAP_TAPCELL_ROW_36_544 VGND VPWR sky130_fd_sc_hd__tapvpwrvgnd_1
XFILLER_80_132 VGND VGND VPWR VPWR sky130_fd_sc_hd__decap_3
XFILLER_0_91 VGND VGND VPWR VPWR sky130_fd_sc_hd__decap_3
XFILLER_80_154 VGND VGND VPWR VPWR sky130_fd_sc_hd__decap_3
XFILLER_80_187 VGND VGND VPWR VPWR sky130_fd_sc_hd__fill_1
XFILLER_21_254 VGND VGND VPWR VPWR sky130_fd_sc_hd__decap_3
X_4807_ _4809_/A VGND VGND VPWR VPWR _4807_/Y sky130_fd_sc_hd__inv_2
XPHY_EDGE_ROW_3_Right_3 VGND VGND VPWR VPWR sky130_fd_sc_hd__decap_3
XFILLER_21_287 VGND VGND VPWR VPWR sky130_fd_sc_hd__decap_3
X_2999_ _2918_/X _2992_/Y _2993_/Y _4924_/Q VGND VGND VPWR VPWR _4924_/D sky130_fd_sc_hd__a22o_2
X_4738_ _5158_/Q _4738_/B VGND VGND VPWR VPWR _4739_/B sky130_fd_sc_hd__nor2_2
X_4669_ _3363_/A _4213_/A _4669_/S VGND VGND VPWR VPWR _4669_/X sky130_fd_sc_hd__mux2_1
XFILLER_79_28 VGND VGND VPWR VPWR sky130_fd_sc_hd__decap_3
XFILLER_0_103 VGND VGND VPWR VPWR sky130_fd_sc_hd__decap_3
XFILLER_0_125 VGND VGND VPWR VPWR sky130_fd_sc_hd__decap_3
XFILLER_0_147 VGND VGND VPWR VPWR sky130_fd_sc_hd__fill_1
XFILLER_0_169 VGND VGND VPWR VPWR sky130_fd_sc_hd__decap_3
XFILLER_76_416 VGND VGND VPWR VPWR sky130_fd_sc_hd__decap_3
XFILLER_48_118 VGND VGND VPWR VPWR sky130_fd_sc_hd__decap_3
XFILLER_76_427 VGND VGND VPWR VPWR sky130_fd_sc_hd__decap_3
XFILLER_17_527 VGND VGND VPWR VPWR sky130_fd_sc_hd__fill_2
XFILLER_84_471 VGND VGND VPWR VPWR sky130_fd_sc_hd__decap_3
XFILLER_84_460 VGND VGND VPWR VPWR sky130_fd_sc_hd__decap_3
XFILLER_56_195 VGND VGND VPWR VPWR sky130_fd_sc_hd__fill_1
XFILLER_71_110 VGND VGND VPWR VPWR sky130_fd_sc_hd__fill_2
XFILLER_71_132 VGND VGND VPWR VPWR sky130_fd_sc_hd__fill_2
XFILLER_44_368 VGND VGND VPWR VPWR sky130_fd_sc_hd__decap_3
XFILLER_71_154 VGND VGND VPWR VPWR sky130_fd_sc_hd__decap_3
XFILLER_12_243 VGND VGND VPWR VPWR sky130_fd_sc_hd__decap_3
XTAP_TAPCELL_ROW_70_867 VGND VPWR sky130_fd_sc_hd__tapvpwrvgnd_1
XFILLER_8_247 VGND VGND VPWR VPWR sky130_fd_sc_hd__decap_3
XFILLER_60_85 VGND VGND VPWR VPWR sky130_fd_sc_hd__decap_3
XFILLER_4_442 VGND VGND VPWR VPWR sky130_fd_sc_hd__decap_3
XFILLER_4_475 VGND VGND VPWR VPWR sky130_fd_sc_hd__fill_1
XFILLER_4_497 VGND VGND VPWR VPWR sky130_fd_sc_hd__decap_3
XFILLER_79_221 VGND VGND VPWR VPWR sky130_fd_sc_hd__decap_3
XFILLER_67_405 VGND VGND VPWR VPWR sky130_fd_sc_hd__decap_3
XFILLER_69_94 VGND VGND VPWR VPWR sky130_fd_sc_hd__fill_1
XFILLER_79_276 VGND VGND VPWR VPWR sky130_fd_sc_hd__decap_3
XFILLER_79_243 VGND VGND VPWR VPWR sky130_fd_sc_hd__fill_2
XFILLER_67_438 VGND VGND VPWR VPWR sky130_fd_sc_hd__decap_3
XFILLER_67_449 VGND VGND VPWR VPWR sky130_fd_sc_hd__decap_3
XTAP_TAPCELL_ROW_78_945 VGND VPWR sky130_fd_sc_hd__tapvpwrvgnd_1
XFILLER_79_287 VGND VGND VPWR VPWR sky130_fd_sc_hd__decap_3
XFILLER_85_93 VGND VGND VPWR VPWR sky130_fd_sc_hd__fill_1
XFILLER_85_82 VGND VGND VPWR VPWR sky130_fd_sc_hd__decap_3
XFILLER_75_471 VGND VGND VPWR VPWR sky130_fd_sc_hd__decap_3
XFILLER_62_154 VGND VGND VPWR VPWR sky130_fd_sc_hd__decap_3
X_3971_ _3971_/A VGND VGND VPWR VPWR _3971_/Y sky130_fd_sc_hd__inv_2
XFILLER_62_187 VGND VGND VPWR VPWR sky130_fd_sc_hd__decap_3
X_2922_ _4877_/Q _2942_/A2 _2921_/X _2951_/B2 VGND VGND VPWR VPWR _4877_/D sky130_fd_sc_hd__a22o_2
XTAP_TAPCELL_ROW_33_514 VGND VPWR sky130_fd_sc_hd__tapvpwrvgnd_1
XFILLER_90_485 VGND VGND VPWR VPWR sky130_fd_sc_hd__fill_1
XFILLER_93_3 VGND VGND VPWR VPWR sky130_fd_sc_hd__decap_3
X_2853_ _5126_/Q _5014_/Q _4998_/Q _4982_/Q _2854_/S0 _2854_/S1 VGND VGND VPWR VPWR
+ _2853_/X sky130_fd_sc_hd__mux4_2
X_2784_ _5138_/Q _2779_/X _2781_/X _2783_/X VGND VGND VPWR VPWR _4777_/B sky130_fd_sc_hd__a22o_2
XTAP_TAPCELL_ROW_41_591 VGND VPWR sky130_fd_sc_hd__tapvpwrvgnd_1
X_4523_ _4572_/S _4523_/B VGND VGND VPWR VPWR _4571_/B sky130_fd_sc_hd__or2_2
X_4454_ _4304_/X _4453_/X _4447_/X _4438_/X VGND VGND VPWR VPWR _4454_/X sky130_fd_sc_hd__o211a_2
X_4385_ _5227_/Q _4854_/B VGND VGND VPWR VPWR _4385_/Y sky130_fd_sc_hd__nand2_2
X_3405_ _5160_/Q _5141_/Q VGND VGND VPWR VPWR _3406_/B sky130_fd_sc_hd__nor2_2
X_3336_ _5283_/Q _3338_/B input2/X VGND VGND VPWR VPWR _3336_/X sky130_fd_sc_hd__and3_2
XFILLER_58_427 VGND VGND VPWR VPWR sky130_fd_sc_hd__decap_3
Xload_slew150 _4321_/B VGND VGND VPWR VPWR _3867_/A sky130_fd_sc_hd__buf_4
X_5006_ _5118_/CLK _5006_/D VGND VGND VPWR VPWR _5006_/Q sky130_fd_sc_hd__dfxtp_2
X_3267_ _5141_/Q _3267_/B VGND VGND VPWR VPWR _3267_/Y sky130_fd_sc_hd__nor2_2
XFILLER_26_313 VGND VGND VPWR VPWR sky130_fd_sc_hd__fill_1
X_3198_ _2914_/X _3193_/B _3193_/Y _5099_/Q VGND VGND VPWR VPWR _5099_/D sky130_fd_sc_hd__a22o_2
XFILLER_85_279 VGND VGND VPWR VPWR sky130_fd_sc_hd__fill_1
XFILLER_26_335 VGND VGND VPWR VPWR sky130_fd_sc_hd__decap_3
XFILLER_26_357 VGND VGND VPWR VPWR sky130_fd_sc_hd__fill_2
XFILLER_81_463 VGND VGND VPWR VPWR sky130_fd_sc_hd__decap_3
XFILLER_81_452 VGND VGND VPWR VPWR sky130_fd_sc_hd__fill_1
XFILLER_14_12 VGND VGND VPWR VPWR sky130_fd_sc_hd__decap_3
XFILLER_14_56 VGND VGND VPWR VPWR sky130_fd_sc_hd__decap_3
XFILLER_5_206 VGND VGND VPWR VPWR sky130_fd_sc_hd__decap_3
XFILLER_5_228 VGND VGND VPWR VPWR sky130_fd_sc_hd__fill_1
XFILLER_30_44 VGND VGND VPWR VPWR sky130_fd_sc_hd__decap_3
XFILLER_89_552 VGND VGND VPWR VPWR sky130_fd_sc_hd__decap_3
XFILLER_39_64 VGND VGND VPWR VPWR sky130_fd_sc_hd__decap_3
XFILLER_49_416 VGND VGND VPWR VPWR sky130_fd_sc_hd__decap_3
XFILLER_49_449 VGND VGND VPWR VPWR sky130_fd_sc_hd__decap_3
XFILLER_39_86 VGND VGND VPWR VPWR sky130_fd_sc_hd__fill_1
XFILLER_76_268 VGND VGND VPWR VPWR sky130_fd_sc_hd__decap_3
XFILLER_64_419 VGND VGND VPWR VPWR sky130_fd_sc_hd__fill_1
XTAP_TAPCELL_ROW_75_915 VGND VPWR sky130_fd_sc_hd__tapvpwrvgnd_1
XFILLER_17_346 VGND VGND VPWR VPWR sky130_fd_sc_hd__decap_3
XFILLER_55_52 VGND VGND VPWR VPWR sky130_fd_sc_hd__decap_3
XFILLER_72_430 VGND VGND VPWR VPWR sky130_fd_sc_hd__decap_3
XFILLER_84_290 VGND VGND VPWR VPWR sky130_fd_sc_hd__fill_2
XFILLER_32_305 VGND VGND VPWR VPWR sky130_fd_sc_hd__decap_3
XFILLER_55_63 VGND VGND VPWR VPWR sky130_fd_sc_hd__decap_3
XFILLER_72_474 VGND VGND VPWR VPWR sky130_fd_sc_hd__fill_2
XFILLER_32_327 VGND VGND VPWR VPWR sky130_fd_sc_hd__decap_3
XTAP_TAPCELL_ROW_83_992 VGND VPWR sky130_fd_sc_hd__tapvpwrvgnd_1
XFILLER_13_552 VGND VGND VPWR VPWR sky130_fd_sc_hd__decap_3
XFILLER_40_360 VGND VGND VPWR VPWR sky130_fd_sc_hd__decap_3
XFILLER_71_73 VGND VGND VPWR VPWR sky130_fd_sc_hd__decap_3
XFILLER_9_534 VGND VGND VPWR VPWR sky130_fd_sc_hd__decap_3
XTAP_TAPCELL_ROW_10_296 VGND VPWR sky130_fd_sc_hd__tapvpwrvgnd_1
X_4170_ _4169_/B _4169_/D _4261_/C _4200_/A VGND VGND VPWR VPWR _4186_/B sky130_fd_sc_hd__a211oi_2
X_3121_ _4692_/A _3121_/B VGND VGND VPWR VPWR _3121_/Y sky130_fd_sc_hd__nor2_4
XFILLER_67_246 VGND VGND VPWR VPWR sky130_fd_sc_hd__decap_3
X_3052_ _2911_/X _3048_/B _3048_/Y _4970_/Q VGND VGND VPWR VPWR _4970_/D sky130_fd_sc_hd__a22o_2
XFILLER_75_290 VGND VGND VPWR VPWR sky130_fd_sc_hd__decap_3
XTAP_TAPCELL_ROW_85_1011 VGND VPWR sky130_fd_sc_hd__tapvpwrvgnd_1
XFILLER_23_305 VGND VGND VPWR VPWR sky130_fd_sc_hd__fill_2
XFILLER_35_143 VGND VGND VPWR VPWR sky130_fd_sc_hd__decap_3
XFILLER_63_452 VGND VGND VPWR VPWR sky130_fd_sc_hd__decap_3
XTAP_TAPCELL_ROW_18_374 VGND VPWR sky130_fd_sc_hd__tapvpwrvgnd_1
XFILLER_50_157 VGND VGND VPWR VPWR sky130_fd_sc_hd__decap_3
X_3954_ _3977_/A _3954_/B VGND VGND VPWR VPWR _3954_/Y sky130_fd_sc_hd__xnor2_2
X_3885_ _3891_/A _3886_/B VGND VGND VPWR VPWR _3885_/Y sky130_fd_sc_hd__nor2_2
X_2905_ _5277_/Q _5243_/Q _5227_/Q _4854_/A _2904_/X VGND VGND VPWR VPWR _2905_/X
+ sky130_fd_sc_hd__a221o_2
X_2836_ _4964_/Q _4948_/Q _4932_/Q _4916_/Q _5135_/Q _5136_/Q VGND VGND VPWR VPWR
+ _2836_/X sky130_fd_sc_hd__mux4_2
X_2767_ _2857_/A _4763_/B VGND VGND VPWR VPWR _2767_/X sky130_fd_sc_hd__and2_2
X_4506_ _3747_/A _3743_/Y _3778_/D _2577_/Y VGND VGND VPWR VPWR _4506_/X sky130_fd_sc_hd__o22a_2
X_2698_ _2703_/A _2894_/A _2702_/B VGND VGND VPWR VPWR _2698_/X sky130_fd_sc_hd__and3_2
X_4437_ _4437_/A _4437_/B VGND VGND VPWR VPWR _4437_/X sky130_fd_sc_hd__or2_2
XFILLER_58_202 VGND VGND VPWR VPWR sky130_fd_sc_hd__decap_3
X_4368_ _4368_/A _4368_/B VGND VGND VPWR VPWR _4410_/A sky130_fd_sc_hd__nor2_2
XFILLER_86_533 VGND VGND VPWR VPWR sky130_fd_sc_hd__decap_3
XFILLER_76_29 VGND VGND VPWR VPWR sky130_fd_sc_hd__fill_2
X_4299_ _4299_/A _4299_/B VGND VGND VPWR VPWR _4299_/X sky130_fd_sc_hd__or2_2
X_3319_ _5156_/Q _4868_/A2 _4870_/B1 _3318_/X VGND VGND VPWR VPWR _5156_/D sky130_fd_sc_hd__o22a_2
XFILLER_54_430 VGND VGND VPWR VPWR sky130_fd_sc_hd__decap_3
XFILLER_54_452 VGND VGND VPWR VPWR sky130_fd_sc_hd__decap_3
XFILLER_14_305 VGND VGND VPWR VPWR sky130_fd_sc_hd__decap_3
XFILLER_25_33 VGND VGND VPWR VPWR sky130_fd_sc_hd__decap_3
XFILLER_41_113 VGND VGND VPWR VPWR sky130_fd_sc_hd__decap_3
XFILLER_25_66 VGND VGND VPWR VPWR sky130_fd_sc_hd__decap_3
XFILLER_41_157 VGND VGND VPWR VPWR sky130_fd_sc_hd__fill_2
XTAP_TAPCELL_ROW_80_962 VGND VPWR sky130_fd_sc_hd__tapvpwrvgnd_1
XFILLER_22_371 VGND VGND VPWR VPWR sky130_fd_sc_hd__decap_3
XFILLER_10_533 VGND VGND VPWR VPWR sky130_fd_sc_hd__decap_3
XFILLER_41_32 VGND VGND VPWR VPWR sky130_fd_sc_hd__decap_3
XTAP_TAPCELL_ROW_52_697 VGND VPWR sky130_fd_sc_hd__tapvpwrvgnd_1
XFILLER_41_54 VGND VGND VPWR VPWR sky130_fd_sc_hd__fill_2
XFILLER_41_65 VGND VGND VPWR VPWR sky130_fd_sc_hd__decap_3
XFILLER_6_504 VGND VGND VPWR VPWR sky130_fd_sc_hd__fill_1
XFILLER_49_213 VGND VGND VPWR VPWR sky130_fd_sc_hd__decap_3
XFILLER_49_257 VGND VGND VPWR VPWR sky130_fd_sc_hd__decap_3
XFILLER_37_408 VGND VGND VPWR VPWR sky130_fd_sc_hd__decap_3
XFILLER_66_40 VGND VGND VPWR VPWR sky130_fd_sc_hd__decap_3
XFILLER_66_62 VGND VGND VPWR VPWR sky130_fd_sc_hd__decap_3
XFILLER_92_503 VGND VGND VPWR VPWR sky130_fd_sc_hd__decap_3
XFILLER_57_290 VGND VGND VPWR VPWR sky130_fd_sc_hd__decap_3
XFILLER_92_536 VGND VGND VPWR VPWR sky130_fd_sc_hd__fill_1
XFILLER_45_441 VGND VGND VPWR VPWR sky130_fd_sc_hd__decap_3
XFILLER_45_452 VGND VGND VPWR VPWR sky130_fd_sc_hd__decap_3
XFILLER_32_102 VGND VGND VPWR VPWR sky130_fd_sc_hd__decap_3
XFILLER_60_433 VGND VGND VPWR VPWR sky130_fd_sc_hd__decap_3
XTAP_TAPCELL_ROW_15_344 VGND VPWR sky130_fd_sc_hd__tapvpwrvgnd_1
XFILLER_82_61 VGND VGND VPWR VPWR sky130_fd_sc_hd__decap_3
XFILLER_32_168 VGND VGND VPWR VPWR sky130_fd_sc_hd__decap_3
XFILLER_60_477 VGND VGND VPWR VPWR sky130_fd_sc_hd__decap_3
XFILLER_13_393 VGND VGND VPWR VPWR sky130_fd_sc_hd__decap_3
X_3670_ _3733_/S _3669_/X _5134_/Q VGND VGND VPWR VPWR _3670_/X sky130_fd_sc_hd__o21a_2
X_2621_ _2866_/A _3958_/A _2577_/Y VGND VGND VPWR VPWR _2868_/B sky130_fd_sc_hd__a21bo_2
Xoutput105 _2785_/X VGND VGND VPWR VPWR MEM_STR_DATA[7] sky130_fd_sc_hd__clkdlybuf4s25_1
X_2552_ _5161_/Q _3829_/B VGND VGND VPWR VPWR _2624_/A sky130_fd_sc_hd__nand2_2
X_5271_ _5271_/CLK _5271_/D VGND VGND VPWR VPWR _5271_/Q sky130_fd_sc_hd__dfxtp_2
X_4222_ _4267_/S _4221_/X _3755_/Y VGND VGND VPWR VPWR _4222_/Y sky130_fd_sc_hd__o21ai_2
X_2483_ _5077_/Q _5061_/Q _5045_/Q _5029_/Q _2672_/S0 _2672_/S1 VGND VGND VPWR VPWR
+ _2483_/X sky130_fd_sc_hd__mux4_2
XFILLER_68_500 VGND VGND VPWR VPWR sky130_fd_sc_hd__decap_3
XTAP_TAPCELL_ROW_91_1070 VGND VPWR sky130_fd_sc_hd__tapvpwrvgnd_1
XFILLER_87_319 VGND VGND VPWR VPWR sky130_fd_sc_hd__decap_3
XFILLER_68_555 VGND VGND VPWR VPWR sky130_fd_sc_hd__decap_3
X_4153_ _4175_/A _3927_/X _4070_/X VGND VGND VPWR VPWR _4161_/A sky130_fd_sc_hd__o21a_2
X_4084_ _4090_/A _4084_/B _4084_/C _4261_/C VGND VGND VPWR VPWR _4087_/D sky130_fd_sc_hd__or4_2
X_3104_ _2897_/X _3119_/A2 _3103_/Y _5015_/Q VGND VGND VPWR VPWR _5015_/D sky130_fd_sc_hd__a22o_2
XFILLER_55_249 VGND VGND VPWR VPWR sky130_fd_sc_hd__fill_1
X_3035_ _2918_/X _3028_/Y _3029_/Y _4956_/Q VGND VGND VPWR VPWR _4956_/D sky130_fd_sc_hd__a22o_2
XFILLER_83_547 VGND VGND VPWR VPWR sky130_fd_sc_hd__decap_3
XFILLER_83_536 VGND VGND VPWR VPWR sky130_fd_sc_hd__fill_2
XFILLER_23_102 VGND VGND VPWR VPWR sky130_fd_sc_hd__fill_2
XFILLER_23_113 VGND VGND VPWR VPWR sky130_fd_sc_hd__decap_3
XFILLER_70_219 VGND VGND VPWR VPWR sky130_fd_sc_hd__decap_3
X_4986_ clkload9/A _4986_/D VGND VGND VPWR VPWR _4986_/Q sky130_fd_sc_hd__dfxtp_2
X_3937_ _2443_/X _2865_/B _3820_/Y _3936_/X VGND VGND VPWR VPWR _3948_/C sky130_fd_sc_hd__o22a_2
X_3868_ _3969_/S _3868_/B _3867_/Y VGND VGND VPWR VPWR _3868_/X sky130_fd_sc_hd__or3b_2
X_3799_ _3943_/A _3799_/B VGND VGND VPWR VPWR _3978_/A sky130_fd_sc_hd__nand2_2
X_2819_ _2817_/X _2818_/X _5137_/Q VGND VGND VPWR VPWR _2819_/X sky130_fd_sc_hd__mux2_1
XFILLER_11_57 VGND VGND VPWR VPWR sky130_fd_sc_hd__decap_3
XFILLER_3_529 VGND VGND VPWR VPWR sky130_fd_sc_hd__decap_3
XFILLER_86_341 VGND VGND VPWR VPWR sky130_fd_sc_hd__decap_3
XFILLER_86_374 VGND VGND VPWR VPWR sky130_fd_sc_hd__decap_3
XFILLER_86_363 VGND VGND VPWR VPWR sky130_fd_sc_hd__fill_1
XTAP_TAPCELL_ROW_57_745 VGND VPWR sky130_fd_sc_hd__tapvpwrvgnd_1
XFILLER_27_463 VGND VGND VPWR VPWR sky130_fd_sc_hd__decap_3
XFILLER_36_32 VGND VGND VPWR VPWR sky130_fd_sc_hd__decap_3
XFILLER_27_496 VGND VGND VPWR VPWR sky130_fd_sc_hd__decap_3
XFILLER_61_219 VGND VGND VPWR VPWR sky130_fd_sc_hd__decap_3
XFILLER_14_135 VGND VGND VPWR VPWR sky130_fd_sc_hd__decap_3
XFILLER_42_477 VGND VGND VPWR VPWR sky130_fd_sc_hd__decap_3
XTAP_TAPCELL_ROW_12_314 VGND VPWR sky130_fd_sc_hd__tapvpwrvgnd_1
XFILLER_52_97 VGND VGND VPWR VPWR sky130_fd_sc_hd__decap_3
Xinput18 INSTR_STREAM[25] VGND VGND VPWR VPWR _3342_/C sky130_fd_sc_hd__clkdlybuf4s25_1
XFILLER_6_312 VGND VGND VPWR VPWR sky130_fd_sc_hd__decap_3
Xinput29 INSTR_STREAM[6] VGND VGND VPWR VPWR _3328_/C sky130_fd_sc_hd__clkdlybuf4s25_1
XFILLER_6_345 VGND VGND VPWR VPWR sky130_fd_sc_hd__decap_3
XTAP_TAPCELL_ROW_20_391 VGND VPWR sky130_fd_sc_hd__tapvpwrvgnd_1
XFILLER_6_389 VGND VGND VPWR VPWR sky130_fd_sc_hd__fill_1
XFILLER_2_551 VGND VGND VPWR VPWR sky130_fd_sc_hd__decap_3
XFILLER_42_9 VGND VGND VPWR VPWR sky130_fd_sc_hd__fill_1
XFILLER_69_319 VGND VGND VPWR VPWR sky130_fd_sc_hd__decap_3
XFILLER_77_72 VGND VGND VPWR VPWR sky130_fd_sc_hd__decap_3
XFILLER_77_83 VGND VGND VPWR VPWR sky130_fd_sc_hd__decap_3
XFILLER_77_352 VGND VGND VPWR VPWR sky130_fd_sc_hd__fill_2
XFILLER_37_216 VGND VGND VPWR VPWR sky130_fd_sc_hd__decap_3
XFILLER_18_430 VGND VGND VPWR VPWR sky130_fd_sc_hd__decap_3
XFILLER_93_60 VGND VGND VPWR VPWR sky130_fd_sc_hd__decap_3
XFILLER_33_444 VGND VGND VPWR VPWR sky130_fd_sc_hd__decap_3
XFILLER_33_455 VGND VGND VPWR VPWR sky130_fd_sc_hd__decap_3
X_4840_ _5272_/Q _4847_/B VGND VGND VPWR VPWR _4840_/X sky130_fd_sc_hd__or2_2
XFILLER_33_488 VGND VGND VPWR VPWR sky130_fd_sc_hd__decap_3
XFILLER_60_296 VGND VGND VPWR VPWR sky130_fd_sc_hd__decap_3
X_4771_ _5161_/Q _4763_/B _4758_/A _4758_/B _4756_/A VGND VGND VPWR VPWR _4772_/C
+ sky130_fd_sc_hd__a221o_2
X_3722_ _3720_/X _3721_/X _3733_/S VGND VGND VPWR VPWR _3722_/X sky130_fd_sc_hd__mux2_1
X_3653_ _3653_/A _3784_/B VGND VGND VPWR VPWR _3654_/B sky130_fd_sc_hd__and2_2
X_2604_ _2660_/A _2604_/B VGND VGND VPWR VPWR _2604_/X sky130_fd_sc_hd__or2_2
X_3584_ _3963_/A _3584_/B VGND VGND VPWR VPWR _3584_/Y sky130_fd_sc_hd__nand2_2
X_2535_ _2677_/S _2535_/B VGND VGND VPWR VPWR _2535_/X sky130_fd_sc_hd__or2_2
X_5254_ _5254_/CLK _5254_/D VGND VGND VPWR VPWR _5254_/Q sky130_fd_sc_hd__dfxtp_2
X_2466_ _5286_/Q _2467_/B VGND VGND VPWR VPWR _4275_/B sky130_fd_sc_hd__and2_4
XFILLER_87_116 VGND VGND VPWR VPWR sky130_fd_sc_hd__decap_3
XFILLER_68_330 VGND VGND VPWR VPWR sky130_fd_sc_hd__decap_3
X_4205_ _4198_/X _4205_/B _4647_/A _4205_/D VGND VGND VPWR VPWR _4205_/X sky130_fd_sc_hd__and4b_2
X_5185_ _5251_/CLK _5185_/D VGND VGND VPWR VPWR _5185_/Q sky130_fd_sc_hd__dfxtp_2
XFILLER_68_363 VGND VGND VPWR VPWR sky130_fd_sc_hd__fill_1
X_4136_ _2642_/Y _3764_/X _4278_/B _3776_/A _4854_/B VGND VGND VPWR VPWR _4136_/Y
+ sky130_fd_sc_hd__a221oi_2
XFILLER_56_525 VGND VGND VPWR VPWR sky130_fd_sc_hd__fill_2
XFILLER_83_311 VGND VGND VPWR VPWR sky130_fd_sc_hd__decap_3
X_4067_ _5217_/Q _4854_/B VGND VGND VPWR VPWR _4067_/Y sky130_fd_sc_hd__nand2_2
XFILLER_83_344 VGND VGND VPWR VPWR sky130_fd_sc_hd__decap_3
XFILLER_36_271 VGND VGND VPWR VPWR sky130_fd_sc_hd__decap_3
XFILLER_71_517 VGND VGND VPWR VPWR sky130_fd_sc_hd__decap_3
XFILLER_71_539 VGND VGND VPWR VPWR sky130_fd_sc_hd__decap_3
X_3018_ _2921_/X _3011_/B _3011_/Y _4941_/Q VGND VGND VPWR VPWR _4941_/D sky130_fd_sc_hd__a22o_2
XTAP_TAPCELL_ROW_54_715 VGND VPWR sky130_fd_sc_hd__tapvpwrvgnd_1
XFILLER_83_399 VGND VGND VPWR VPWR sky130_fd_sc_hd__decap_3
XFILLER_83_388 VGND VGND VPWR VPWR sky130_fd_sc_hd__decap_3
XFILLER_24_433 VGND VGND VPWR VPWR sky130_fd_sc_hd__decap_3
XFILLER_24_477 VGND VGND VPWR VPWR sky130_fd_sc_hd__decap_3
XFILLER_51_241 VGND VGND VPWR VPWR sky130_fd_sc_hd__decap_3
XFILLER_11_116 VGND VGND VPWR VPWR sky130_fd_sc_hd__fill_1
XFILLER_11_138 VGND VGND VPWR VPWR sky130_fd_sc_hd__decap_3
X_4969_ _4994_/CLK _4969_/D VGND VGND VPWR VPWR _4969_/Q sky130_fd_sc_hd__dfxtp_2
XTAP_TAPCELL_ROW_62_792 VGND VPWR sky130_fd_sc_hd__tapvpwrvgnd_1
XFILLER_47_514 VGND VGND VPWR VPWR sky130_fd_sc_hd__decap_3
XFILLER_59_352 VGND VGND VPWR VPWR sky130_fd_sc_hd__decap_3
XFILLER_93_108 VGND VGND VPWR VPWR sky130_fd_sc_hd__decap_3
XFILLER_86_171 VGND VGND VPWR VPWR sky130_fd_sc_hd__decap_3
XFILLER_27_271 VGND VGND VPWR VPWR sky130_fd_sc_hd__decap_3
XFILLER_63_41 VGND VGND VPWR VPWR sky130_fd_sc_hd__decap_3
XFILLER_15_455 VGND VGND VPWR VPWR sky130_fd_sc_hd__decap_3
XFILLER_63_63 VGND VGND VPWR VPWR sky130_fd_sc_hd__decap_3
XFILLER_42_296 VGND VGND VPWR VPWR sky130_fd_sc_hd__decap_3
XFILLER_8_58 VGND VGND VPWR VPWR sky130_fd_sc_hd__decap_3
XFILLER_6_153 VGND VGND VPWR VPWR sky130_fd_sc_hd__fill_1
XFILLER_6_175 VGND VGND VPWR VPWR sky130_fd_sc_hd__decap_3
XFILLER_40_6 VGND VGND VPWR VPWR sky130_fd_sc_hd__fill_1
XFILLER_6_197 VGND VGND VPWR VPWR sky130_fd_sc_hd__fill_2
XFILLER_69_105 VGND VGND VPWR VPWR sky130_fd_sc_hd__fill_1
XFILLER_69_116 VGND VGND VPWR VPWR sky130_fd_sc_hd__decap_3
XFILLER_88_82 VGND VGND VPWR VPWR sky130_fd_sc_hd__fill_2
XFILLER_88_93 VGND VGND VPWR VPWR sky130_fd_sc_hd__decap_3
XFILLER_19_3 VGND VGND VPWR VPWR sky130_fd_sc_hd__decap_3
XFILLER_65_322 VGND VGND VPWR VPWR sky130_fd_sc_hd__decap_3
XFILLER_65_355 VGND VGND VPWR VPWR sky130_fd_sc_hd__decap_3
XFILLER_25_208 VGND VGND VPWR VPWR sky130_fd_sc_hd__decap_3
XFILLER_25_219 VGND VGND VPWR VPWR sky130_fd_sc_hd__decap_3
XFILLER_65_388 VGND VGND VPWR VPWR sky130_fd_sc_hd__decap_3
XFILLER_65_399 VGND VGND VPWR VPWR sky130_fd_sc_hd__decap_3
XFILLER_33_252 VGND VGND VPWR VPWR sky130_fd_sc_hd__fill_2
X_4823_ _4823_/A _4823_/B VGND VGND VPWR VPWR _4823_/X sky130_fd_sc_hd__xor2_2
XFILLER_21_447 VGND VGND VPWR VPWR sky130_fd_sc_hd__fill_1
XFILLER_21_458 VGND VGND VPWR VPWR sky130_fd_sc_hd__decap_3
X_4754_ _4754_/A VGND VGND VPWR VPWR _4756_/A sky130_fd_sc_hd__inv_2
X_3705_ _3705_/A _3705_/B VGND VGND VPWR VPWR _3705_/X sky130_fd_sc_hd__or2_2
X_4685_ _2482_/A _3778_/D _4684_/X VGND VGND VPWR VPWR _4685_/X sky130_fd_sc_hd__o21ba_2
XTAP_TAPCELL_ROW_31_497 VGND VPWR sky130_fd_sc_hd__tapvpwrvgnd_1
X_3636_ _3693_/A _3635_/X _5134_/Q VGND VGND VPWR VPWR _3636_/X sky130_fd_sc_hd__o21a_2
X_3567_ _5159_/Q _4298_/A _3567_/S VGND VGND VPWR VPWR _4175_/A sky130_fd_sc_hd__mux2_1
XFILLER_0_307 VGND VGND VPWR VPWR sky130_fd_sc_hd__fill_1
XFILLER_0_318 VGND VGND VPWR VPWR sky130_fd_sc_hd__decap_3
X_2518_ _5168_/Q _3642_/A VGND VGND VPWR VPWR _2518_/Y sky130_fd_sc_hd__nand2_2
X_5237_ _5257_/CLK _5237_/D VGND VGND VPWR VPWR _5237_/Q sky130_fd_sc_hd__dfxtp_2
X_3498_ _3705_/A _3498_/B VGND VGND VPWR VPWR _3498_/X sky130_fd_sc_hd__or2_2
XFILLER_75_108 VGND VGND VPWR VPWR sky130_fd_sc_hd__decap_3
X_2449_ _3773_/A _5181_/Q VGND VGND VPWR VPWR _3766_/B sky130_fd_sc_hd__and2_2
XFILLER_29_525 VGND VGND VPWR VPWR sky130_fd_sc_hd__decap_3
XFILLER_75_119 VGND VGND VPWR VPWR sky130_fd_sc_hd__decap_3
X_5168_ _5271_/CLK _5168_/D VGND VGND VPWR VPWR _5168_/Q sky130_fd_sc_hd__dfxtp_2
XFILLER_84_29 VGND VGND VPWR VPWR sky130_fd_sc_hd__fill_2
XFILLER_17_23 VGND VGND VPWR VPWR sky130_fd_sc_hd__decap_3
XFILLER_68_193 VGND VGND VPWR VPWR sky130_fd_sc_hd__decap_3
X_4119_ _4119_/A _4119_/B VGND VGND VPWR VPWR _4119_/Y sky130_fd_sc_hd__nor2_2
X_5099_ _5099_/CLK _5099_/D VGND VGND VPWR VPWR _5099_/Q sky130_fd_sc_hd__dfxtp_2
XTAP_TAPCELL_ROW_67_840 VGND VPWR sky130_fd_sc_hd__tapvpwrvgnd_1
XFILLER_44_517 VGND VGND VPWR VPWR sky130_fd_sc_hd__decap_3
XTAP_TAPCELL_ROW_39_575 VGND VPWR sky130_fd_sc_hd__tapvpwrvgnd_1
XFILLER_71_358 VGND VGND VPWR VPWR sky130_fd_sc_hd__decap_3
XFILLER_83_196 VGND VGND VPWR VPWR sky130_fd_sc_hd__fill_1
XFILLER_12_436 VGND VGND VPWR VPWR sky130_fd_sc_hd__decap_3
XFILLER_12_469 VGND VGND VPWR VPWR sky130_fd_sc_hd__decap_3
XFILLER_33_55 VGND VGND VPWR VPWR sky130_fd_sc_hd__fill_1
XPHY_EDGE_ROW_49_Left_143 VGND VGND VPWR VPWR sky130_fd_sc_hd__decap_3
XFILLER_20_480 VGND VGND VPWR VPWR sky130_fd_sc_hd__decap_3
XFILLER_3_101 VGND VGND VPWR VPWR sky130_fd_sc_hd__decap_3
XFILLER_79_458 VGND VGND VPWR VPWR sky130_fd_sc_hd__decap_3
XFILLER_79_447 VGND VGND VPWR VPWR sky130_fd_sc_hd__fill_1
XFILLER_58_52 VGND VGND VPWR VPWR sky130_fd_sc_hd__decap_3
XFILLER_58_74 VGND VGND VPWR VPWR sky130_fd_sc_hd__decap_3
XPHY_EDGE_ROW_58_Left_152 VGND VGND VPWR VPWR sky130_fd_sc_hd__decap_3
XFILLER_47_322 VGND VGND VPWR VPWR sky130_fd_sc_hd__decap_3
XFILLER_58_85 VGND VGND VPWR VPWR sky130_fd_sc_hd__decap_3
XFILLER_87_480 VGND VGND VPWR VPWR sky130_fd_sc_hd__decap_3
XFILLER_47_377 VGND VGND VPWR VPWR sky130_fd_sc_hd__decap_3
XFILLER_74_62 VGND VGND VPWR VPWR sky130_fd_sc_hd__decap_3
XFILLER_15_252 VGND VGND VPWR VPWR sky130_fd_sc_hd__fill_2
XFILLER_30_200 VGND VGND VPWR VPWR sky130_fd_sc_hd__decap_3
XTAP_TAPCELL_ROW_73_898 VGND VPWR sky130_fd_sc_hd__tapvpwrvgnd_1
XPHY_EDGE_ROW_67_Left_161 VGND VGND VPWR VPWR sky130_fd_sc_hd__decap_3
XFILLER_88_6 VGND VGND VPWR VPWR sky130_fd_sc_hd__decap_3
X_4470_ _3867_/A _4638_/S _3545_/Y VGND VGND VPWR VPWR _4470_/X sky130_fd_sc_hd__o21a_2
Xmax_cap126 _3192_/Y VGND VGND VPWR VPWR _3193_/B sky130_fd_sc_hd__buf_6
Xmax_cap115 _4487_/A VGND VGND VPWR VPWR _4572_/S sky130_fd_sc_hd__buf_6
Xmax_cap159 _4022_/B VGND VGND VPWR VPWR _4189_/A sky130_fd_sc_hd__buf_4
X_3421_ _5162_/Q _5143_/Q VGND VGND VPWR VPWR _3424_/C sky130_fd_sc_hd__or2_2
X_3352_ _5283_/Q _3366_/A _3352_/C VGND VGND VPWR VPWR _3352_/X sky130_fd_sc_hd__and3_2
XPHY_EDGE_ROW_76_Left_170 VGND VGND VPWR VPWR sky130_fd_sc_hd__decap_3
X_3283_ _5145_/Q _3315_/B _3278_/X _3282_/X _3338_/B VGND VGND VPWR VPWR _5145_/D
+ sky130_fd_sc_hd__o311a_2
X_5022_ _5102_/CLK _5022_/D VGND VGND VPWR VPWR _5022_/Q sky130_fd_sc_hd__dfxtp_2
XTAP_TAPCELL_ROW_88_1042 VGND VPWR sky130_fd_sc_hd__tapvpwrvgnd_1
XFILLER_38_377 VGND VGND VPWR VPWR sky130_fd_sc_hd__decap_3
XFILLER_53_314 VGND VGND VPWR VPWR sky130_fd_sc_hd__decap_3
XFILLER_65_163 VGND VGND VPWR VPWR sky130_fd_sc_hd__fill_2
XTAP_TAPCELL_ROW_64_810 VGND VPWR sky130_fd_sc_hd__tapvpwrvgnd_1
XFILLER_93_483 VGND VGND VPWR VPWR sky130_fd_sc_hd__decap_3
XFILLER_80_111 VGND VGND VPWR VPWR sky130_fd_sc_hd__fill_2
XTAP_TAPCELL_ROW_36_545 VGND VPWR sky130_fd_sc_hd__tapvpwrvgnd_1
XFILLER_80_166 VGND VGND VPWR VPWR sky130_fd_sc_hd__fill_1
XFILLER_80_144 VGND VGND VPWR VPWR sky130_fd_sc_hd__fill_1
XFILLER_21_211 VGND VGND VPWR VPWR sky130_fd_sc_hd__decap_3
XFILLER_61_391 VGND VGND VPWR VPWR sky130_fd_sc_hd__fill_1
X_4806_ _5167_/Q _4808_/B VGND VGND VPWR VPWR _4809_/A sky130_fd_sc_hd__and2_2
X_2998_ _2914_/X _2992_/Y _2993_/Y _4923_/Q VGND VGND VPWR VPWR _4923_/D sky130_fd_sc_hd__a22o_2
X_4737_ _5158_/Q _4738_/B VGND VGND VPWR VPWR _4739_/A sky130_fd_sc_hd__and2_2
X_4668_ _4191_/A _2495_/B _3778_/D _2695_/B VGND VGND VPWR VPWR _4671_/B sky130_fd_sc_hd__o22a_2
X_3619_ _4412_/S _3619_/B VGND VGND VPWR VPWR _3889_/B sky130_fd_sc_hd__and2b_2
X_4599_ _4692_/A _4599_/B VGND VGND VPWR VPWR _5234_/D sky130_fd_sc_hd__nor2_2
XFILLER_88_200 VGND VGND VPWR VPWR sky130_fd_sc_hd__decap_3
XFILLER_0_137 VGND VGND VPWR VPWR sky130_fd_sc_hd__decap_3
XFILLER_0_159 VGND VGND VPWR VPWR sky130_fd_sc_hd__decap_3
XFILLER_69_480 VGND VGND VPWR VPWR sky130_fd_sc_hd__decap_3
XFILLER_76_439 VGND VGND VPWR VPWR sky130_fd_sc_hd__fill_1
XFILLER_29_355 VGND VGND VPWR VPWR sky130_fd_sc_hd__fill_1
XFILLER_29_366 VGND VGND VPWR VPWR sky130_fd_sc_hd__decap_3
XFILLER_56_141 VGND VGND VPWR VPWR sky130_fd_sc_hd__decap_3
XFILLER_84_483 VGND VGND VPWR VPWR sky130_fd_sc_hd__decap_3
XFILLER_44_325 VGND VGND VPWR VPWR sky130_fd_sc_hd__decap_3
XFILLER_71_166 VGND VGND VPWR VPWR sky130_fd_sc_hd__fill_2
XFILLER_44_65 VGND VGND VPWR VPWR sky130_fd_sc_hd__fill_1
XFILLER_71_188 VGND VGND VPWR VPWR sky130_fd_sc_hd__decap_3
XTAP_TAPCELL_ROW_70_868 VGND VPWR sky130_fd_sc_hd__tapvpwrvgnd_1
XFILLER_12_288 VGND VGND VPWR VPWR sky130_fd_sc_hd__decap_3
XFILLER_60_64 VGND VGND VPWR VPWR sky130_fd_sc_hd__fill_1
XFILLER_8_259 VGND VGND VPWR VPWR sky130_fd_sc_hd__decap_3
XFILLER_69_40 VGND VGND VPWR VPWR sky130_fd_sc_hd__decap_3
XFILLER_69_73 VGND VGND VPWR VPWR sky130_fd_sc_hd__decap_3
XFILLER_39_119 VGND VGND VPWR VPWR sky130_fd_sc_hd__decap_3
XFILLER_67_417 VGND VGND VPWR VPWR sky130_fd_sc_hd__decap_3
XTAP_TAPCELL_ROW_7_270 VGND VPWR sky130_fd_sc_hd__tapvpwrvgnd_1
XTAP_TAPCELL_ROW_78_946 VGND VPWR sky130_fd_sc_hd__tapvpwrvgnd_1
XFILLER_79_299 VGND VGND VPWR VPWR sky130_fd_sc_hd__decap_3
XPHY_EDGE_ROW_13_Right_13 VGND VGND VPWR VPWR sky130_fd_sc_hd__decap_3
XFILLER_62_122 VGND VGND VPWR VPWR sky130_fd_sc_hd__decap_3
XFILLER_62_133 VGND VGND VPWR VPWR sky130_fd_sc_hd__decap_3
XFILLER_75_483 VGND VGND VPWR VPWR sky130_fd_sc_hd__decap_3
X_3970_ _3969_/X _4076_/B _4078_/B VGND VGND VPWR VPWR _3971_/A sky130_fd_sc_hd__mux2_1
XFILLER_50_339 VGND VGND VPWR VPWR sky130_fd_sc_hd__decap_3
X_2921_ _5275_/Q _5200_/Q _4854_/A _5232_/Q _2920_/X VGND VGND VPWR VPWR _2921_/X
+ sky130_fd_sc_hd__a221o_2
XTAP_TAPCELL_ROW_33_515 VGND VPWR sky130_fd_sc_hd__tapvpwrvgnd_1
XFILLER_90_497 VGND VGND VPWR VPWR sky130_fd_sc_hd__fill_2
XFILLER_43_391 VGND VGND VPWR VPWR sky130_fd_sc_hd__fill_1
X_2852_ _2832_/A _2851_/X _5138_/Q VGND VGND VPWR VPWR _2852_/X sky130_fd_sc_hd__o21a_2
XFILLER_86_3 VGND VGND VPWR VPWR sky130_fd_sc_hd__decap_3
X_2783_ _5137_/Q _2782_/X _2435_/Y VGND VGND VPWR VPWR _2783_/X sky130_fd_sc_hd__o21a_2
XTAP_TAPCELL_ROW_41_592 VGND VPWR sky130_fd_sc_hd__tapvpwrvgnd_1
XPHY_EDGE_ROW_22_Right_22 VGND VGND VPWR VPWR sky130_fd_sc_hd__decap_3
X_4522_ _4522_/A _4522_/B _4522_/C VGND VGND VPWR VPWR _4522_/X sky130_fd_sc_hd__or3_2
X_4453_ _4450_/X _4551_/A _4572_/S VGND VGND VPWR VPWR _4453_/X sky130_fd_sc_hd__mux2_1
XFILLER_7_292 VGND VGND VPWR VPWR sky130_fd_sc_hd__fill_2
X_3404_ _5160_/Q _5141_/Q VGND VGND VPWR VPWR _3406_/A sky130_fd_sc_hd__and2_2
X_4384_ _4277_/Y _4383_/X _4692_/A VGND VGND VPWR VPWR _5226_/D sky130_fd_sc_hd__a21oi_2
X_3335_ _5165_/Q _3230_/B _3230_/Y _3334_/X VGND VGND VPWR VPWR _5165_/D sky130_fd_sc_hd__o22a_2
XFILLER_58_417 VGND VGND VPWR VPWR sky130_fd_sc_hd__decap_3
XFILLER_58_439 VGND VGND VPWR VPWR sky130_fd_sc_hd__decap_3
X_3266_ _3311_/S _3277_/D VGND VGND VPWR VPWR _3270_/B sky130_fd_sc_hd__and2_2
XPHY_EDGE_ROW_31_Right_31 VGND VGND VPWR VPWR sky130_fd_sc_hd__decap_3
X_5005_ _5117_/CLK _5005_/D VGND VGND VPWR VPWR _5005_/Q sky130_fd_sc_hd__dfxtp_2
XFILLER_38_141 VGND VGND VPWR VPWR sky130_fd_sc_hd__decap_3
XFILLER_66_450 VGND VGND VPWR VPWR sky130_fd_sc_hd__decap_3
XFILLER_66_472 VGND VGND VPWR VPWR sky130_fd_sc_hd__decap_3
X_3197_ _2911_/X _3193_/B _3193_/Y _5098_/Q VGND VGND VPWR VPWR _5098_/D sky130_fd_sc_hd__a22o_2
XFILLER_38_185 VGND VGND VPWR VPWR sky130_fd_sc_hd__fill_2
XFILLER_53_111 VGND VGND VPWR VPWR sky130_fd_sc_hd__fill_1
XFILLER_66_483 VGND VGND VPWR VPWR sky130_fd_sc_hd__decap_3
XTAP_TAPCELL_ROW_49_670 VGND VPWR sky130_fd_sc_hd__tapvpwrvgnd_1
XFILLER_81_431 VGND VGND VPWR VPWR sky130_fd_sc_hd__decap_3
XFILLER_53_199 VGND VGND VPWR VPWR sky130_fd_sc_hd__decap_3
XFILLER_14_24 VGND VGND VPWR VPWR sky130_fd_sc_hd__decap_3
XFILLER_14_35 VGND VGND VPWR VPWR sky130_fd_sc_hd__decap_3
XFILLER_22_542 VGND VGND VPWR VPWR sky130_fd_sc_hd__decap_3
XFILLER_14_68 VGND VGND VPWR VPWR sky130_fd_sc_hd__decap_3
Xclkbuf_leaf_39_CLK clkbuf_leaf_5_CLK/A VGND VGND VPWR VPWR _5117_/CLK sky130_fd_sc_hd__clkbuf_8
XPHY_EDGE_ROW_40_Right_40 VGND VGND VPWR VPWR sky130_fd_sc_hd__decap_3
XFILLER_30_23 VGND VGND VPWR VPWR sky130_fd_sc_hd__decap_3
XFILLER_5_218 VGND VGND VPWR VPWR sky130_fd_sc_hd__decap_3
XTAP_TAPCELL_ROW_4_240 VGND VPWR sky130_fd_sc_hd__tapvpwrvgnd_1
XTAP_TAPCELL_ROW_75_916 VGND VPWR sky130_fd_sc_hd__tapvpwrvgnd_1
XFILLER_72_442 VGND VGND VPWR VPWR sky130_fd_sc_hd__decap_3
XFILLER_32_339 VGND VGND VPWR VPWR sky130_fd_sc_hd__decap_3
XFILLER_72_486 VGND VGND VPWR VPWR sky130_fd_sc_hd__decap_3
XTAP_TAPCELL_ROW_83_993 VGND VPWR sky130_fd_sc_hd__tapvpwrvgnd_1
XFILLER_9_557 VGND VGND VPWR VPWR sky130_fd_sc_hd__fill_1
XTAP_TAPCELL_ROW_10_297 VGND VPWR sky130_fd_sc_hd__tapvpwrvgnd_1
XFILLER_67_214 VGND VGND VPWR VPWR sky130_fd_sc_hd__decap_3
XFILLER_67_225 VGND VGND VPWR VPWR sky130_fd_sc_hd__decap_3
X_3120_ _3192_/B _3156_/B VGND VGND VPWR VPWR _3120_/Y sky130_fd_sc_hd__nor2_4
XFILLER_48_461 VGND VGND VPWR VPWR sky130_fd_sc_hd__decap_3
XFILLER_67_269 VGND VGND VPWR VPWR sky130_fd_sc_hd__decap_3
X_3051_ _2908_/X _3048_/B _3048_/Y _4969_/Q VGND VGND VPWR VPWR _4969_/D sky130_fd_sc_hd__a22o_2
XFILLER_35_111 VGND VGND VPWR VPWR sky130_fd_sc_hd__fill_1
XFILLER_35_122 VGND VGND VPWR VPWR sky130_fd_sc_hd__decap_3
XFILLER_48_483 VGND VGND VPWR VPWR sky130_fd_sc_hd__decap_3
XFILLER_63_431 VGND VGND VPWR VPWR sky130_fd_sc_hd__decap_3
XTAP_TAPCELL_ROW_85_1012 VGND VPWR sky130_fd_sc_hd__tapvpwrvgnd_1
XFILLER_82_228 VGND VGND VPWR VPWR sky130_fd_sc_hd__decap_3
XTAP_TAPCELL_ROW_46_640 VGND VPWR sky130_fd_sc_hd__tapvpwrvgnd_1
XFILLER_35_166 VGND VGND VPWR VPWR sky130_fd_sc_hd__fill_2
XTAP_TAPCELL_ROW_18_375 VGND VPWR sky130_fd_sc_hd__tapvpwrvgnd_1
XFILLER_16_380 VGND VGND VPWR VPWR sky130_fd_sc_hd__decap_3
XFILLER_50_147 VGND VGND VPWR VPWR sky130_fd_sc_hd__fill_2
X_3953_ _3934_/A _3934_/B _3604_/B VGND VGND VPWR VPWR _3954_/B sky130_fd_sc_hd__a21o_2
XFILLER_90_294 VGND VGND VPWR VPWR sky130_fd_sc_hd__fill_1
XFILLER_50_169 VGND VGND VPWR VPWR sky130_fd_sc_hd__decap_3
X_3884_ _5183_/Q _5182_/Q _5181_/Q _3884_/D VGND VGND VPWR VPWR _4278_/B sky130_fd_sc_hd__and4_2
X_2904_ _5276_/Q _5211_/Q _5195_/Q _5275_/Q VGND VGND VPWR VPWR _2904_/X sky130_fd_sc_hd__a22o_2
XFILLER_31_372 VGND VGND VPWR VPWR sky130_fd_sc_hd__decap_3
X_2835_ _5124_/Q _5012_/Q _4996_/Q _4980_/Q _5135_/Q _5136_/Q VGND VGND VPWR VPWR
+ _2835_/X sky130_fd_sc_hd__mux4_2
X_2766_ _2761_/X _2762_/X _2765_/X _2435_/Y VGND VGND VPWR VPWR _4763_/B sky130_fd_sc_hd__a22o_2
X_4505_ _3567_/S _2443_/X _4505_/S VGND VGND VPWR VPWR _4505_/X sky130_fd_sc_hd__mux2_1
X_2697_ _2707_/C _2707_/D VGND VGND VPWR VPWR _2702_/B sky130_fd_sc_hd__nand2_2
X_4436_ _4666_/A _4436_/B VGND VGND VPWR VPWR _4437_/B sky130_fd_sc_hd__nand2_2
X_4367_ _4367_/A _4367_/B VGND VGND VPWR VPWR _4368_/B sky130_fd_sc_hd__xnor2_2
X_3318_ _5283_/Q _3338_/B input1/X VGND VGND VPWR VPWR _3318_/X sky130_fd_sc_hd__and3_2
X_4298_ _4298_/A _4298_/B VGND VGND VPWR VPWR _4299_/B sky130_fd_sc_hd__and2_2
XFILLER_86_556 VGND VGND VPWR VPWR sky130_fd_sc_hd__fill_2
XFILLER_39_461 VGND VGND VPWR VPWR sky130_fd_sc_hd__decap_3
X_3249_ _5283_/Q _3338_/B _3249_/C VGND VGND VPWR VPWR _3249_/X sky130_fd_sc_hd__and3_2
XFILLER_26_100 VGND VGND VPWR VPWR sky130_fd_sc_hd__decap_3
XFILLER_39_483 VGND VGND VPWR VPWR sky130_fd_sc_hd__decap_3
XFILLER_66_280 VGND VGND VPWR VPWR sky130_fd_sc_hd__decap_3
XTAP_TAPCELL_ROW_1_210 VGND VPWR sky130_fd_sc_hd__tapvpwrvgnd_1
XFILLER_25_12 VGND VGND VPWR VPWR sky130_fd_sc_hd__fill_1
XFILLER_54_464 VGND VGND VPWR VPWR sky130_fd_sc_hd__decap_3
XFILLER_92_29 VGND VGND VPWR VPWR sky130_fd_sc_hd__fill_1
XFILLER_14_328 VGND VGND VPWR VPWR sky130_fd_sc_hd__decap_3
XFILLER_25_45 VGND VGND VPWR VPWR sky130_fd_sc_hd__decap_3
XFILLER_26_166 VGND VGND VPWR VPWR sky130_fd_sc_hd__decap_3
XFILLER_81_261 VGND VGND VPWR VPWR sky130_fd_sc_hd__decap_3
XFILLER_25_78 VGND VGND VPWR VPWR sky130_fd_sc_hd__decap_3
XFILLER_41_169 VGND VGND VPWR VPWR sky130_fd_sc_hd__fill_2
XTAP_TAPCELL_ROW_80_963 VGND VPWR sky130_fd_sc_hd__tapvpwrvgnd_1
XFILLER_22_383 VGND VGND VPWR VPWR sky130_fd_sc_hd__fill_1
XTAP_TAPCELL_ROW_52_698 VGND VPWR sky130_fd_sc_hd__tapvpwrvgnd_1
XFILLER_10_556 VGND VGND VPWR VPWR sky130_fd_sc_hd__fill_2
XFILLER_41_44 VGND VGND VPWR VPWR sky130_fd_sc_hd__fill_2
XFILLER_6_527 VGND VGND VPWR VPWR sky130_fd_sc_hd__decap_3
XFILLER_89_350 VGND VGND VPWR VPWR sky130_fd_sc_hd__decap_3
XFILLER_1_254 VGND VGND VPWR VPWR sky130_fd_sc_hd__decap_3
XFILLER_77_523 VGND VGND VPWR VPWR sky130_fd_sc_hd__decap_3
XFILLER_49_236 VGND VGND VPWR VPWR sky130_fd_sc_hd__decap_3
XFILLER_92_515 VGND VGND VPWR VPWR sky130_fd_sc_hd__decap_3
XFILLER_64_239 VGND VGND VPWR VPWR sky130_fd_sc_hd__decap_3
XFILLER_92_548 VGND VGND VPWR VPWR sky130_fd_sc_hd__decap_3
XFILLER_17_155 VGND VGND VPWR VPWR sky130_fd_sc_hd__decap_3
XFILLER_60_401 VGND VGND VPWR VPWR sky130_fd_sc_hd__decap_3
XTAP_TAPCELL_ROW_43_610 VGND VPWR sky130_fd_sc_hd__tapvpwrvgnd_1
XFILLER_82_40 VGND VGND VPWR VPWR sky130_fd_sc_hd__decap_3
XFILLER_32_147 VGND VGND VPWR VPWR sky130_fd_sc_hd__decap_3
XFILLER_82_73 VGND VGND VPWR VPWR sky130_fd_sc_hd__decap_3
XFILLER_13_361 VGND VGND VPWR VPWR sky130_fd_sc_hd__fill_2
XFILLER_20_309 VGND VGND VPWR VPWR sky130_fd_sc_hd__fill_2
XFILLER_60_489 VGND VGND VPWR VPWR sky130_fd_sc_hd__decap_3
XTAP_TAPCELL_ROW_15_345 VGND VPWR sky130_fd_sc_hd__tapvpwrvgnd_1
XFILLER_13_383 VGND VGND VPWR VPWR sky130_fd_sc_hd__decap_3
X_2620_ _2620_/A _2620_/B VGND VGND VPWR VPWR _3958_/A sky130_fd_sc_hd__nand2_2
Xoutput106 _2794_/X VGND VGND VPWR VPWR MEM_STR_DATA[8] sky130_fd_sc_hd__clkdlybuf4s25_1
X_2551_ _2546_/X _2547_/X _2550_/X _2433_/Y VGND VGND VPWR VPWR _3829_/B sky130_fd_sc_hd__a22o_2
X_5270_ _5270_/CLK _5270_/D VGND VGND VPWR VPWR _5270_/Q sky130_fd_sc_hd__dfxtp_2
X_2482_ _2482_/A _2482_/B VGND VGND VPWR VPWR _3848_/A sky130_fd_sc_hd__and2_2
X_4221_ _4220_/X _4179_/X _4266_/S VGND VGND VPWR VPWR _4221_/X sky130_fd_sc_hd__mux2_1
XFILLER_68_523 VGND VGND VPWR VPWR sky130_fd_sc_hd__fill_1
X_4152_ _3755_/Y _4150_/X _4151_/X VGND VGND VPWR VPWR _4152_/Y sky130_fd_sc_hd__a21boi_2
XFILLER_28_409 VGND VGND VPWR VPWR sky130_fd_sc_hd__fill_2
X_4083_ _4051_/A _4082_/X _4078_/X _4077_/X VGND VGND VPWR VPWR _4087_/C sky130_fd_sc_hd__o211a_2
X_3103_ _4692_/A _3103_/B VGND VGND VPWR VPWR _3103_/Y sky130_fd_sc_hd__nor2_4
XFILLER_55_228 VGND VGND VPWR VPWR sky130_fd_sc_hd__decap_3
X_3034_ _2914_/X _3028_/Y _3029_/Y _4955_/Q VGND VGND VPWR VPWR _4955_/D sky130_fd_sc_hd__a22o_2
XFILLER_83_526 VGND VGND VPWR VPWR sky130_fd_sc_hd__decap_3
XFILLER_36_442 VGND VGND VPWR VPWR sky130_fd_sc_hd__decap_3
XFILLER_51_412 VGND VGND VPWR VPWR sky130_fd_sc_hd__decap_3
XFILLER_23_125 VGND VGND VPWR VPWR sky130_fd_sc_hd__decap_3
XFILLER_23_147 VGND VGND VPWR VPWR sky130_fd_sc_hd__decap_3
XFILLER_51_445 VGND VGND VPWR VPWR sky130_fd_sc_hd__decap_3
X_4985_ _4994_/CLK _4985_/D VGND VGND VPWR VPWR _4985_/Q sky130_fd_sc_hd__dfxtp_2
XFILLER_23_169 VGND VGND VPWR VPWR sky130_fd_sc_hd__decap_3
X_3936_ _3820_/A _3820_/B _3894_/X VGND VGND VPWR VPWR _3936_/X sky130_fd_sc_hd__a21o_2
X_3867_ _3867_/A _4638_/S VGND VGND VPWR VPWR _3867_/Y sky130_fd_sc_hd__nand2_2
XPHY_EDGE_ROW_12_Left_106 VGND VGND VPWR VPWR sky130_fd_sc_hd__decap_3
X_3798_ _4321_/B _4281_/A VGND VGND VPWR VPWR _3799_/B sky130_fd_sc_hd__or2_2
X_2818_ _4962_/Q _4946_/Q _4930_/Q _4914_/Q _2818_/S0 _5136_/Q VGND VGND VPWR VPWR
+ _2818_/X sky130_fd_sc_hd__mux4_2
XFILLER_3_508 VGND VGND VPWR VPWR sky130_fd_sc_hd__decap_3
X_2749_ _2857_/A _4746_/B VGND VGND VPWR VPWR _2749_/X sky130_fd_sc_hd__and2_2
XFILLER_2_9 VGND VGND VPWR VPWR sky130_fd_sc_hd__fill_2
XFILLER_78_309 VGND VGND VPWR VPWR sky130_fd_sc_hd__decap_3
X_4419_ _4287_/Y _4288_/X _4422_/S VGND VGND VPWR VPWR _4420_/B sky130_fd_sc_hd__mux2_1
XPHY_EDGE_ROW_21_Left_115 VGND VGND VPWR VPWR sky130_fd_sc_hd__decap_3
XFILLER_19_409 VGND VGND VPWR VPWR sky130_fd_sc_hd__fill_2
XFILLER_74_515 VGND VGND VPWR VPWR sky130_fd_sc_hd__decap_3
XFILLER_86_386 VGND VGND VPWR VPWR sky130_fd_sc_hd__decap_3
XFILLER_27_431 VGND VGND VPWR VPWR sky130_fd_sc_hd__decap_3
XFILLER_36_22 VGND VGND VPWR VPWR sky130_fd_sc_hd__decap_3
XFILLER_36_44 VGND VGND VPWR VPWR sky130_fd_sc_hd__decap_3
XTAP_TAPCELL_ROW_57_746 VGND VPWR sky130_fd_sc_hd__tapvpwrvgnd_1
XFILLER_27_475 VGND VGND VPWR VPWR sky130_fd_sc_hd__fill_1
XFILLER_36_88 VGND VGND VPWR VPWR sky130_fd_sc_hd__decap_3
XFILLER_54_272 VGND VGND VPWR VPWR sky130_fd_sc_hd__decap_3
XFILLER_42_445 VGND VGND VPWR VPWR sky130_fd_sc_hd__decap_3
XFILLER_42_489 VGND VGND VPWR VPWR sky130_fd_sc_hd__decap_3
XPHY_EDGE_ROW_30_Left_124 VGND VGND VPWR VPWR sky130_fd_sc_hd__decap_3
XFILLER_52_65 VGND VGND VPWR VPWR sky130_fd_sc_hd__fill_2
XFILLER_52_76 VGND VGND VPWR VPWR sky130_fd_sc_hd__decap_3
XTAP_TAPCELL_ROW_12_315 VGND VPWR sky130_fd_sc_hd__tapvpwrvgnd_1
Xinput19 INSTR_STREAM[26] VGND VGND VPWR VPWR _3344_/C sky130_fd_sc_hd__clkdlybuf4s25_1
XFILLER_6_324 VGND VGND VPWR VPWR sky130_fd_sc_hd__fill_2
XFILLER_6_368 VGND VGND VPWR VPWR sky130_fd_sc_hd__fill_1
XTAP_TAPCELL_ROW_20_392 VGND VPWR sky130_fd_sc_hd__tapvpwrvgnd_1
XFILLER_2_530 VGND VGND VPWR VPWR sky130_fd_sc_hd__fill_2
XFILLER_35_9 VGND VGND VPWR VPWR sky130_fd_sc_hd__decap_3
XFILLER_77_320 VGND VGND VPWR VPWR sky130_fd_sc_hd__decap_3
XFILLER_77_95 VGND VGND VPWR VPWR sky130_fd_sc_hd__fill_1
XFILLER_37_239 VGND VGND VPWR VPWR sky130_fd_sc_hd__decap_3
XFILLER_92_312 VGND VGND VPWR VPWR sky130_fd_sc_hd__decap_3
XFILLER_92_301 VGND VGND VPWR VPWR sky130_fd_sc_hd__decap_3
XFILLER_80_507 VGND VGND VPWR VPWR sky130_fd_sc_hd__decap_3
XFILLER_18_486 VGND VGND VPWR VPWR sky130_fd_sc_hd__decap_3
XFILLER_93_72 VGND VGND VPWR VPWR sky130_fd_sc_hd__decap_3
XFILLER_33_423 VGND VGND VPWR VPWR sky130_fd_sc_hd__decap_3
XFILLER_60_220 VGND VGND VPWR VPWR sky130_fd_sc_hd__decap_3
XTAP_TAPCELL_ROW_28_470 VGND VPWR sky130_fd_sc_hd__tapvpwrvgnd_1
XFILLER_93_94 VGND VGND VPWR VPWR sky130_fd_sc_hd__decap_3
XFILLER_60_253 VGND VGND VPWR VPWR sky130_fd_sc_hd__decap_3
X_4770_ _4770_/A _4770_/B VGND VGND VPWR VPWR _4772_/B sky130_fd_sc_hd__nor2_2
X_3721_ _5118_/Q _5006_/Q _4990_/Q _4974_/Q _3732_/S0 _3732_/S1 VGND VGND VPWR VPWR
+ _3721_/X sky130_fd_sc_hd__mux4_2
X_3652_ _3653_/A _3784_/B VGND VGND VPWR VPWR _4687_/S sky130_fd_sc_hd__nor2_2
X_3583_ _3579_/X _4002_/B _4044_/S VGND VGND VPWR VPWR _3584_/B sky130_fd_sc_hd__mux2_1
X_2603_ _4887_/Q _4871_/Q _5095_/Q _5079_/Q _2672_/S0 _2672_/S1 VGND VGND VPWR VPWR
+ _2604_/B sky130_fd_sc_hd__mux4_2
X_2534_ _5069_/Q _5053_/Q _5037_/Q _5021_/Q _2672_/S0 _2672_/S1 VGND VGND VPWR VPWR
+ _2535_/B sky130_fd_sc_hd__mux4_2
XFILLER_5_390 VGND VGND VPWR VPWR sky130_fd_sc_hd__fill_2
X_5253_ _5253_/CLK _5253_/D VGND VGND VPWR VPWR _5253_/Q sky130_fd_sc_hd__dfxtp_2
X_2465_ _2455_/X _2461_/X _2463_/Y _2453_/X VGND VGND VPWR VPWR _2465_/X sky130_fd_sc_hd__a211o_2
X_4204_ _2890_/A _4522_/A _4434_/A _4233_/B _4213_/A VGND VGND VPWR VPWR _4205_/B
+ sky130_fd_sc_hd__o221a_2
X_5184_ _5251_/CLK _5184_/D VGND VGND VPWR VPWR _5184_/Q sky130_fd_sc_hd__dfxtp_2
XFILLER_87_128 VGND VGND VPWR VPWR sky130_fd_sc_hd__decap_3
X_4135_ _3884_/D _4200_/C _4155_/A _3886_/B VGND VGND VPWR VPWR _4135_/X sky130_fd_sc_hd__a211o_2
XFILLER_83_323 VGND VGND VPWR VPWR sky130_fd_sc_hd__decap_3
X_4066_ _5216_/Q _4275_/B _4065_/Y _3366_/A VGND VGND VPWR VPWR _5216_/D sky130_fd_sc_hd__o211a_2
XFILLER_83_356 VGND VGND VPWR VPWR sky130_fd_sc_hd__fill_1
XFILLER_36_250 VGND VGND VPWR VPWR sky130_fd_sc_hd__fill_2
XFILLER_43_209 VGND VGND VPWR VPWR sky130_fd_sc_hd__decap_3
X_3017_ _2918_/X _3011_/B _3011_/Y _4940_/Q VGND VGND VPWR VPWR _4940_/D sky130_fd_sc_hd__a22o_2
XTAP_TAPCELL_ROW_54_716 VGND VPWR sky130_fd_sc_hd__tapvpwrvgnd_1
XFILLER_24_456 VGND VGND VPWR VPWR sky130_fd_sc_hd__decap_3
X_4968_ _5118_/CLK _4968_/D VGND VGND VPWR VPWR _4968_/Q sky130_fd_sc_hd__dfxtp_2
XTAP_TAPCELL_ROW_62_793 VGND VPWR sky130_fd_sc_hd__tapvpwrvgnd_1
X_4899_ _5107_/CLK _4899_/D VGND VGND VPWR VPWR _4899_/Q sky130_fd_sc_hd__dfxtp_2
X_3919_ _3552_/X _3535_/A _3919_/S VGND VGND VPWR VPWR _3920_/A sky130_fd_sc_hd__mux2_1
XFILLER_3_305 VGND VGND VPWR VPWR sky130_fd_sc_hd__decap_3
XFILLER_0_6 VGND VGND VPWR VPWR sky130_fd_sc_hd__decap_3
XFILLER_59_320 VGND VGND VPWR VPWR sky130_fd_sc_hd__decap_3
XFILLER_78_139 VGND VGND VPWR VPWR sky130_fd_sc_hd__fill_1
XFILLER_59_364 VGND VGND VPWR VPWR sky130_fd_sc_hd__decap_3
XFILLER_86_150 VGND VGND VPWR VPWR sky130_fd_sc_hd__decap_3
XFILLER_19_228 VGND VGND VPWR VPWR sky130_fd_sc_hd__fill_1
XFILLER_47_526 VGND VGND VPWR VPWR sky130_fd_sc_hd__decap_3
XFILLER_27_250 VGND VGND VPWR VPWR sky130_fd_sc_hd__decap_3
XFILLER_62_518 VGND VGND VPWR VPWR sky130_fd_sc_hd__decap_3
XFILLER_74_389 VGND VGND VPWR VPWR sky130_fd_sc_hd__decap_3
XFILLER_30_404 VGND VGND VPWR VPWR sky130_fd_sc_hd__decap_3
XFILLER_42_253 VGND VGND VPWR VPWR sky130_fd_sc_hd__fill_2
XFILLER_63_75 VGND VGND VPWR VPWR sky130_fd_sc_hd__decap_3
XTAP_TAPCELL_ROW_25_440 VGND VPWR sky130_fd_sc_hd__tapvpwrvgnd_1
XPHY_EDGE_ROW_69_Right_69 VGND VGND VPWR VPWR sky130_fd_sc_hd__decap_3
XFILLER_8_15 VGND VGND VPWR VPWR sky130_fd_sc_hd__decap_3
XFILLER_30_448 VGND VGND VPWR VPWR sky130_fd_sc_hd__decap_3
XFILLER_6_110 VGND VGND VPWR VPWR sky130_fd_sc_hd__fill_2
XFILLER_10_183 VGND VGND VPWR VPWR sky130_fd_sc_hd__decap_3
XFILLER_6_165 VGND VGND VPWR VPWR sky130_fd_sc_hd__fill_2
XFILLER_6_187 VGND VGND VPWR VPWR sky130_fd_sc_hd__decap_3
XPHY_EDGE_ROW_78_Right_78 VGND VGND VPWR VPWR sky130_fd_sc_hd__decap_3
XFILLER_38_515 VGND VGND VPWR VPWR sky130_fd_sc_hd__decap_3
XFILLER_77_172 VGND VGND VPWR VPWR sky130_fd_sc_hd__decap_3
XFILLER_77_150 VGND VGND VPWR VPWR sky130_fd_sc_hd__decap_3
XFILLER_53_518 VGND VGND VPWR VPWR sky130_fd_sc_hd__decap_3
XFILLER_65_367 VGND VGND VPWR VPWR sky130_fd_sc_hd__decap_3
XFILLER_80_315 VGND VGND VPWR VPWR sky130_fd_sc_hd__decap_3
XPHY_EDGE_ROW_87_Right_87 VGND VGND VPWR VPWR sky130_fd_sc_hd__decap_3
XFILLER_92_197 VGND VGND VPWR VPWR sky130_fd_sc_hd__fill_1
XFILLER_80_348 VGND VGND VPWR VPWR sky130_fd_sc_hd__decap_3
X_4822_ _4818_/A _4818_/B _4823_/B VGND VGND VPWR VPWR _4822_/X sky130_fd_sc_hd__a21o_2
X_4753_ _5160_/Q _4755_/B VGND VGND VPWR VPWR _4754_/A sky130_fd_sc_hd__nand2_2
X_3704_ _4895_/Q _4879_/Q _5103_/Q _5087_/Q _3706_/S0 _3706_/S1 VGND VGND VPWR VPWR
+ _3705_/B sky130_fd_sc_hd__mux4_2
X_4684_ _2703_/A _2482_/B _4684_/B1 _3654_/B VGND VGND VPWR VPWR _4684_/X sky130_fd_sc_hd__a22o_2
XTAP_TAPCELL_ROW_31_498 VGND VPWR sky130_fd_sc_hd__tapvpwrvgnd_1
X_3635_ _5075_/Q _5059_/Q _5043_/Q _5027_/Q _3706_/S0 _3706_/S1 VGND VGND VPWR VPWR
+ _3635_/X sky130_fd_sc_hd__mux4_2
X_3566_ _3961_/S _3565_/X _4016_/A _3561_/Y VGND VGND VPWR VPWR _3566_/X sky130_fd_sc_hd__o211a_2
X_3497_ _4890_/Q _4874_/Q _5098_/Q _5082_/Q _5131_/Q _5132_/Q VGND VGND VPWR VPWR
+ _3498_/B sky130_fd_sc_hd__mux4_2
X_2517_ _5168_/Q _3642_/A VGND VGND VPWR VPWR _2890_/A sky130_fd_sc_hd__and2_2
X_5236_ _5285_/CLK _5236_/D VGND VGND VPWR VPWR _5236_/Q sky130_fd_sc_hd__dfxtp_2
X_2448_ _3773_/A _3576_/A VGND VGND VPWR VPWR _3363_/A sky130_fd_sc_hd__nand2_2
XFILLER_88_448 VGND VGND VPWR VPWR sky130_fd_sc_hd__decap_3
XFILLER_68_150 VGND VGND VPWR VPWR sky130_fd_sc_hd__decap_3
X_5167_ _5271_/CLK _5167_/D VGND VGND VPWR VPWR _5167_/Q sky130_fd_sc_hd__dfxtp_2
XFILLER_56_345 VGND VGND VPWR VPWR sky130_fd_sc_hd__decap_3
XFILLER_68_183 VGND VGND VPWR VPWR sky130_fd_sc_hd__fill_1
X_4118_ _5218_/Q _4847_/B _4117_/Y _3366_/A VGND VGND VPWR VPWR _5218_/D sky130_fd_sc_hd__o211a_2
X_5098_ _5099_/CLK _5098_/D VGND VGND VPWR VPWR _5098_/Q sky130_fd_sc_hd__dfxtp_2
XTAP_TAPCELL_ROW_67_841 VGND VPWR sky130_fd_sc_hd__tapvpwrvgnd_1
XFILLER_16_209 VGND VGND VPWR VPWR sky130_fd_sc_hd__decap_3
XFILLER_56_378 VGND VGND VPWR VPWR sky130_fd_sc_hd__decap_3
XFILLER_71_315 VGND VGND VPWR VPWR sky130_fd_sc_hd__decap_3
X_4049_ _4267_/S _4049_/B VGND VGND VPWR VPWR _4049_/Y sky130_fd_sc_hd__nor2_2
XTAP_TAPCELL_ROW_39_576 VGND VPWR sky130_fd_sc_hd__tapvpwrvgnd_1
XFILLER_83_175 VGND VGND VPWR VPWR sky130_fd_sc_hd__decap_3
XFILLER_83_164 VGND VGND VPWR VPWR sky130_fd_sc_hd__decap_3
XFILLER_17_68 VGND VGND VPWR VPWR sky130_fd_sc_hd__decap_3
XFILLER_71_337 VGND VGND VPWR VPWR sky130_fd_sc_hd__decap_3
XTAP_TAPCELL_ROW_22_410 VGND VPWR sky130_fd_sc_hd__tapvpwrvgnd_1
XFILLER_20_492 VGND VGND VPWR VPWR sky130_fd_sc_hd__decap_3
XFILLER_79_404 VGND VGND VPWR VPWR sky130_fd_sc_hd__decap_3
XFILLER_79_426 VGND VGND VPWR VPWR sky130_fd_sc_hd__decap_3
XFILLER_47_301 VGND VGND VPWR VPWR sky130_fd_sc_hd__decap_3
XFILLER_59_150 VGND VGND VPWR VPWR sky130_fd_sc_hd__decap_3
XFILLER_59_172 VGND VGND VPWR VPWR sky130_fd_sc_hd__decap_3
XFILLER_47_345 VGND VGND VPWR VPWR sky130_fd_sc_hd__decap_3
XFILLER_47_356 VGND VGND VPWR VPWR sky130_fd_sc_hd__decap_3
XFILLER_87_492 VGND VGND VPWR VPWR sky130_fd_sc_hd__decap_3
XFILLER_47_389 VGND VGND VPWR VPWR sky130_fd_sc_hd__decap_3
XFILLER_62_315 VGND VGND VPWR VPWR sky130_fd_sc_hd__decap_3
XFILLER_74_153 VGND VGND VPWR VPWR sky130_fd_sc_hd__decap_3
XFILLER_74_41 VGND VGND VPWR VPWR sky130_fd_sc_hd__decap_3
XFILLER_74_197 VGND VGND VPWR VPWR sky130_fd_sc_hd__fill_2
XFILLER_74_74 VGND VGND VPWR VPWR sky130_fd_sc_hd__decap_3
XFILLER_74_85 VGND VGND VPWR VPWR sky130_fd_sc_hd__decap_3
XFILLER_15_231 VGND VGND VPWR VPWR sky130_fd_sc_hd__decap_3
XFILLER_62_359 VGND VGND VPWR VPWR sky130_fd_sc_hd__decap_3
XFILLER_70_381 VGND VGND VPWR VPWR sky130_fd_sc_hd__decap_3
XTAP_TAPCELL_ROW_73_899 VGND VPWR sky130_fd_sc_hd__tapvpwrvgnd_1
XFILLER_30_245 VGND VGND VPWR VPWR sky130_fd_sc_hd__decap_3
XFILLER_30_289 VGND VGND VPWR VPWR sky130_fd_sc_hd__decap_3
Xmax_cap116 _4044_/S VGND VGND VPWR VPWR _4016_/A sky130_fd_sc_hd__buf_4
Xmax_cap149 _4357_/B VGND VGND VPWR VPWR _4320_/A sky130_fd_sc_hd__buf_8
Xmax_cap138 _3894_/X VGND VGND VPWR VPWR _4686_/B1 sky130_fd_sc_hd__buf_8
Xmax_cap127 _3175_/B VGND VGND VPWR VPWR _3191_/A2 sky130_fd_sc_hd__buf_6
X_3420_ _5162_/Q _5143_/Q VGND VGND VPWR VPWR _3424_/B sky130_fd_sc_hd__nand2_2
XFILLER_7_496 VGND VGND VPWR VPWR sky130_fd_sc_hd__decap_3
X_3351_ _5185_/Q _3230_/B _3230_/Y _3350_/X VGND VGND VPWR VPWR _5185_/D sky130_fd_sc_hd__o22a_2
XFILLER_31_3 VGND VGND VPWR VPWR sky130_fd_sc_hd__decap_3
X_3282_ _3315_/B _3297_/B _5266_/Q _5189_/Q VGND VGND VPWR VPWR _3282_/X sky130_fd_sc_hd__a2bb2o_2
XFILLER_38_312 VGND VGND VPWR VPWR sky130_fd_sc_hd__decap_3
X_5021_ _5102_/CLK _5021_/D VGND VGND VPWR VPWR _5021_/Q sky130_fd_sc_hd__dfxtp_2
XFILLER_38_345 VGND VGND VPWR VPWR sky130_fd_sc_hd__decap_3
XFILLER_38_389 VGND VGND VPWR VPWR sky130_fd_sc_hd__decap_3
XTAP_TAPCELL_ROW_64_811 VGND VPWR sky130_fd_sc_hd__tapvpwrvgnd_1
XFILLER_0_60 VGND VGND VPWR VPWR sky130_fd_sc_hd__decap_3
XFILLER_65_175 VGND VGND VPWR VPWR sky130_fd_sc_hd__decap_3
XFILLER_93_495 VGND VGND VPWR VPWR sky130_fd_sc_hd__decap_3
XTAP_TAPCELL_ROW_36_546 VGND VPWR sky130_fd_sc_hd__tapvpwrvgnd_1
XFILLER_21_223 VGND VGND VPWR VPWR sky130_fd_sc_hd__fill_1
XFILLER_21_234 VGND VGND VPWR VPWR sky130_fd_sc_hd__decap_3
X_4805_ _4854_/B _4803_/Y _4804_/X _3338_/B VGND VGND VPWR VPWR _5268_/D sky130_fd_sc_hd__o211a_2
X_2997_ _2911_/X _2992_/Y _2993_/Y _4922_/Q VGND VGND VPWR VPWR _4922_/D sky130_fd_sc_hd__a22o_2
X_4736_ _5259_/Q _4847_/B _4735_/X _3338_/B VGND VGND VPWR VPWR _5259_/D sky130_fd_sc_hd__o211a_2
X_4667_ _2703_/A _2495_/B _4684_/B1 _3665_/B VGND VGND VPWR VPWR _4671_/A sky130_fd_sc_hd__a22oi_2
X_3618_ _4320_/A _4286_/A VGND VGND VPWR VPWR _3619_/B sky130_fd_sc_hd__nand2_2
X_4598_ _5234_/Q _4854_/B _4541_/X _4597_/X VGND VGND VPWR VPWR _4599_/B sky130_fd_sc_hd__o2bb2a_2
XFILLER_0_116 VGND VGND VPWR VPWR sky130_fd_sc_hd__decap_3
X_3549_ _4393_/C _3866_/B VGND VGND VPWR VPWR _3549_/Y sky130_fd_sc_hd__nand2b_2
XFILLER_88_212 VGND VGND VPWR VPWR sky130_fd_sc_hd__fill_2
XFILLER_76_407 VGND VGND VPWR VPWR sky130_fd_sc_hd__decap_3
XFILLER_29_301 VGND VGND VPWR VPWR sky130_fd_sc_hd__fill_2
XFILLER_48_109 VGND VGND VPWR VPWR sky130_fd_sc_hd__decap_3
X_5219_ _5254_/CLK _5219_/D VGND VGND VPWR VPWR _5219_/Q sky130_fd_sc_hd__dfxtp_2
XFILLER_56_131 VGND VGND VPWR VPWR sky130_fd_sc_hd__fill_1
XFILLER_17_518 VGND VGND VPWR VPWR sky130_fd_sc_hd__decap_3
XFILLER_56_153 VGND VGND VPWR VPWR sky130_fd_sc_hd__decap_3
XFILLER_84_451 VGND VGND VPWR VPWR sky130_fd_sc_hd__decap_3
XFILLER_44_337 VGND VGND VPWR VPWR sky130_fd_sc_hd__fill_1
XFILLER_56_186 VGND VGND VPWR VPWR sky130_fd_sc_hd__decap_3
XFILLER_56_197 VGND VGND VPWR VPWR sky130_fd_sc_hd__decap_3
XFILLER_40_521 VGND VGND VPWR VPWR sky130_fd_sc_hd__fill_2
XTAP_TAPCELL_ROW_70_869 VGND VPWR sky130_fd_sc_hd__tapvpwrvgnd_1
XFILLER_4_411 VGND VGND VPWR VPWR sky130_fd_sc_hd__decap_3
XFILLER_5_38 VGND VGND VPWR VPWR sky130_fd_sc_hd__fill_1
XFILLER_4_488 VGND VGND VPWR VPWR sky130_fd_sc_hd__decap_3
XFILLER_79_212 VGND VGND VPWR VPWR sky130_fd_sc_hd__decap_3
XFILLER_69_85 VGND VGND VPWR VPWR sky130_fd_sc_hd__decap_3
XFILLER_79_256 VGND VGND VPWR VPWR sky130_fd_sc_hd__fill_1
XFILLER_67_429 VGND VGND VPWR VPWR sky130_fd_sc_hd__decap_3
XTAP_TAPCELL_ROW_7_271 VGND VPWR sky130_fd_sc_hd__tapvpwrvgnd_1
XTAP_TAPCELL_ROW_78_947 VGND VPWR sky130_fd_sc_hd__tapvpwrvgnd_1
XFILLER_85_62 VGND VGND VPWR VPWR sky130_fd_sc_hd__decap_3
XFILLER_75_462 VGND VGND VPWR VPWR sky130_fd_sc_hd__decap_3
XFILLER_35_337 VGND VGND VPWR VPWR sky130_fd_sc_hd__decap_3
XFILLER_90_421 VGND VGND VPWR VPWR sky130_fd_sc_hd__fill_2
XFILLER_75_495 VGND VGND VPWR VPWR sky130_fd_sc_hd__decap_3
XFILLER_90_465 VGND VGND VPWR VPWR sky130_fd_sc_hd__fill_1
XFILLER_43_370 VGND VGND VPWR VPWR sky130_fd_sc_hd__decap_3
XFILLER_62_167 VGND VGND VPWR VPWR sky130_fd_sc_hd__fill_2
XFILLER_62_178 VGND VGND VPWR VPWR sky130_fd_sc_hd__decap_3
X_2920_ _5277_/Q _5248_/Q _5216_/Q _5276_/Q VGND VGND VPWR VPWR _2920_/X sky130_fd_sc_hd__a22o_2
XTAP_TAPCELL_ROW_33_516 VGND VPWR sky130_fd_sc_hd__tapvpwrvgnd_1
X_2851_ _5078_/Q _5062_/Q _5046_/Q _5030_/Q _2851_/S0 _2854_/S1 VGND VGND VPWR VPWR
+ _2851_/X sky130_fd_sc_hd__mux4_2
X_2782_ _5118_/Q _5006_/Q _4990_/Q _4974_/Q _2818_/S0 _5136_/Q VGND VGND VPWR VPWR
+ _2782_/X sky130_fd_sc_hd__mux4_2
XTAP_TAPCELL_ROW_41_593 VGND VPWR sky130_fd_sc_hd__tapvpwrvgnd_1
XFILLER_79_3 VGND VGND VPWR VPWR sky130_fd_sc_hd__decap_3
X_4521_ _5230_/Q _4854_/B VGND VGND VPWR VPWR _4521_/Y sky130_fd_sc_hd__nand2_2
XFILLER_7_260 VGND VGND VPWR VPWR sky130_fd_sc_hd__fill_2
X_4452_ _4451_/X _4515_/A _4515_/B VGND VGND VPWR VPWR _4551_/A sky130_fd_sc_hd__mux2_1
X_3403_ _3396_/Y _3402_/X _3494_/A VGND VGND VPWR VPWR _5197_/D sky130_fd_sc_hd__a21oi_2
X_4383_ _4370_/X _4381_/X _4278_/X VGND VGND VPWR VPWR _4383_/X sky130_fd_sc_hd__a21o_2
X_3334_ _5283_/Q _3338_/B _3334_/C VGND VGND VPWR VPWR _3334_/X sky130_fd_sc_hd__and3_2
X_3265_ _5141_/Q _5140_/Q _5139_/Q VGND VGND VPWR VPWR _3277_/D sky130_fd_sc_hd__and3_2
X_5004_ _5117_/CLK _5004_/D VGND VGND VPWR VPWR _5004_/Q sky130_fd_sc_hd__dfxtp_2
X_3196_ _2908_/X _3193_/B _3193_/Y _5097_/Q VGND VGND VPWR VPWR _5097_/D sky130_fd_sc_hd__a22o_2
XFILLER_26_326 VGND VGND VPWR VPWR sky130_fd_sc_hd__decap_3
XFILLER_38_197 VGND VGND VPWR VPWR sky130_fd_sc_hd__decap_3
XTAP_TAPCELL_ROW_49_671 VGND VPWR sky130_fd_sc_hd__tapvpwrvgnd_1
XFILLER_93_281 VGND VGND VPWR VPWR sky130_fd_sc_hd__fill_2
XFILLER_81_443 VGND VGND VPWR VPWR sky130_fd_sc_hd__decap_3
XFILLER_81_498 VGND VGND VPWR VPWR sky130_fd_sc_hd__decap_3
XFILLER_34_381 VGND VGND VPWR VPWR sky130_fd_sc_hd__fill_1
XFILLER_14_47 VGND VGND VPWR VPWR sky130_fd_sc_hd__decap_3
XFILLER_22_554 VGND VGND VPWR VPWR sky130_fd_sc_hd__decap_3
X_4719_ _5254_/Q _4725_/B VGND VGND VPWR VPWR _4719_/X sky130_fd_sc_hd__or2_2
XFILLER_39_55 VGND VGND VPWR VPWR sky130_fd_sc_hd__fill_1
XTAP_TAPCELL_ROW_4_241 VGND VPWR sky130_fd_sc_hd__tapvpwrvgnd_1
XTAP_TAPCELL_ROW_75_917 VGND VPWR sky130_fd_sc_hd__tapvpwrvgnd_1
XFILLER_17_337 VGND VGND VPWR VPWR sky130_fd_sc_hd__decap_3
XFILLER_72_421 VGND VGND VPWR VPWR sky130_fd_sc_hd__decap_3
XFILLER_84_281 VGND VGND VPWR VPWR sky130_fd_sc_hd__decap_3
XFILLER_72_454 VGND VGND VPWR VPWR sky130_fd_sc_hd__decap_3
XFILLER_72_498 VGND VGND VPWR VPWR sky130_fd_sc_hd__decap_3
XTAP_TAPCELL_ROW_83_994 VGND VPWR sky130_fd_sc_hd__tapvpwrvgnd_1
XFILLER_13_521 VGND VGND VPWR VPWR sky130_fd_sc_hd__decap_3
XFILLER_25_381 VGND VGND VPWR VPWR sky130_fd_sc_hd__decap_3
XFILLER_71_42 VGND VGND VPWR VPWR sky130_fd_sc_hd__decap_3
XFILLER_9_514 VGND VGND VPWR VPWR sky130_fd_sc_hd__decap_3
XFILLER_40_384 VGND VGND VPWR VPWR sky130_fd_sc_hd__fill_2
XTAP_TAPCELL_ROW_10_298 VGND VPWR sky130_fd_sc_hd__tapvpwrvgnd_1
XFILLER_0_491 VGND VGND VPWR VPWR sky130_fd_sc_hd__decap_3
XFILLER_67_237 VGND VGND VPWR VPWR sky130_fd_sc_hd__decap_3
X_3050_ _2905_/X _3048_/B _3048_/Y _4968_/Q VGND VGND VPWR VPWR _4968_/D sky130_fd_sc_hd__a22o_2
XFILLER_48_473 VGND VGND VPWR VPWR sky130_fd_sc_hd__decap_3
XFILLER_48_495 VGND VGND VPWR VPWR sky130_fd_sc_hd__decap_3
XFILLER_75_281 VGND VGND VPWR VPWR sky130_fd_sc_hd__decap_3
XTAP_TAPCELL_ROW_85_1013 VGND VPWR sky130_fd_sc_hd__tapvpwrvgnd_1
XFILLER_63_443 VGND VGND VPWR VPWR sky130_fd_sc_hd__fill_2
XTAP_TAPCELL_ROW_46_641 VGND VPWR sky130_fd_sc_hd__tapvpwrvgnd_1
XFILLER_23_318 VGND VGND VPWR VPWR sky130_fd_sc_hd__fill_1
XFILLER_63_476 VGND VGND VPWR VPWR sky130_fd_sc_hd__decap_3
XFILLER_63_498 VGND VGND VPWR VPWR sky130_fd_sc_hd__decap_3
XTAP_TAPCELL_ROW_18_376 VGND VPWR sky130_fd_sc_hd__tapvpwrvgnd_1
XFILLER_90_273 VGND VGND VPWR VPWR sky130_fd_sc_hd__fill_1
XFILLER_50_137 VGND VGND VPWR VPWR sky130_fd_sc_hd__decap_3
X_3952_ _4692_/A _3952_/B VGND VGND VPWR VPWR _5212_/D sky130_fd_sc_hd__nor2_2
XFILLER_31_340 VGND VGND VPWR VPWR sky130_fd_sc_hd__decap_3
X_3883_ _2599_/Y _3764_/X _3767_/Y _3619_/B _4684_/B1 VGND VGND VPWR VPWR _3883_/X
+ sky130_fd_sc_hd__a221o_2
X_2903_ _2897_/X _2951_/B2 _2942_/A2 _4871_/Q VGND VGND VPWR VPWR _4871_/D sky130_fd_sc_hd__a22o_2
XFILLER_31_384 VGND VGND VPWR VPWR sky130_fd_sc_hd__decap_3
X_2834_ _2855_/S _2833_/X _5138_/Q VGND VGND VPWR VPWR _2834_/X sky130_fd_sc_hd__o21a_2
X_4504_ _3363_/A _4503_/B _3894_/X _3958_/A _4503_/Y VGND VGND VPWR VPWR _4509_/B
+ sky130_fd_sc_hd__o221a_2
X_2765_ _2763_/X _2764_/X _5137_/Q VGND VGND VPWR VPWR _2765_/X sky130_fd_sc_hd__mux2_1
X_2696_ _2695_/B _4236_/B _3848_/A VGND VGND VPWR VPWR _2707_/D sky130_fd_sc_hd__a21bo_2
XFILLER_6_81 VGND VGND VPWR VPWR sky130_fd_sc_hd__decap_3
X_4435_ _4379_/A _4382_/B _4430_/X _4416_/X _3898_/D VGND VGND VPWR VPWR _4435_/X
+ sky130_fd_sc_hd__o311a_2
X_4366_ _4364_/Y _4386_/B VGND VGND VPWR VPWR _4367_/B sky130_fd_sc_hd__and2b_2
X_3317_ _5155_/Q _5280_/D _5281_/D VGND VGND VPWR VPWR _5155_/D sky130_fd_sc_hd__o21ba_2
XFILLER_86_524 VGND VGND VPWR VPWR sky130_fd_sc_hd__fill_1
X_4297_ _4298_/A _4298_/B VGND VGND VPWR VPWR _4299_/A sky130_fd_sc_hd__nor2_2
XFILLER_58_259 VGND VGND VPWR VPWR sky130_fd_sc_hd__decap_3
X_3248_ _5176_/Q _4868_/A2 _4870_/B1 _3247_/X VGND VGND VPWR VPWR _5135_/D sky130_fd_sc_hd__o22a_2
XFILLER_26_112 VGND VGND VPWR VPWR sky130_fd_sc_hd__fill_1
XFILLER_39_495 VGND VGND VPWR VPWR sky130_fd_sc_hd__decap_3
XFILLER_66_270 VGND VGND VPWR VPWR sky130_fd_sc_hd__fill_2
X_3179_ _2911_/X _3191_/A2 _3191_/B1 _5082_/Q VGND VGND VPWR VPWR _5082_/D sky130_fd_sc_hd__a22o_2
XTAP_TAPCELL_ROW_1_211 VGND VPWR sky130_fd_sc_hd__tapvpwrvgnd_1
XFILLER_54_443 VGND VGND VPWR VPWR sky130_fd_sc_hd__decap_3
XFILLER_14_318 VGND VGND VPWR VPWR sky130_fd_sc_hd__fill_2
XFILLER_25_24 VGND VGND VPWR VPWR sky130_fd_sc_hd__decap_3
XFILLER_26_178 VGND VGND VPWR VPWR sky130_fd_sc_hd__fill_1
XFILLER_81_273 VGND VGND VPWR VPWR sky130_fd_sc_hd__decap_3
XFILLER_81_251 VGND VGND VPWR VPWR sky130_fd_sc_hd__decap_3
XFILLER_25_57 VGND VGND VPWR VPWR sky130_fd_sc_hd__decap_3
XTAP_TAPCELL_ROW_80_964 VGND VPWR sky130_fd_sc_hd__tapvpwrvgnd_1
XFILLER_41_12 VGND VGND VPWR VPWR sky130_fd_sc_hd__decap_3
XTAP_TAPCELL_ROW_52_699 VGND VPWR sky130_fd_sc_hd__tapvpwrvgnd_1
XFILLER_9_3 VGND VGND VPWR VPWR sky130_fd_sc_hd__decap_3
XFILLER_49_248 VGND VGND VPWR VPWR sky130_fd_sc_hd__decap_3
XFILLER_77_557 VGND VGND VPWR VPWR sky130_fd_sc_hd__fill_1
XFILLER_77_535 VGND VGND VPWR VPWR sky130_fd_sc_hd__decap_3
XFILLER_57_281 VGND VGND VPWR VPWR sky130_fd_sc_hd__decap_3
XFILLER_92_527 VGND VGND VPWR VPWR sky130_fd_sc_hd__decap_3
XFILLER_45_432 VGND VGND VPWR VPWR sky130_fd_sc_hd__decap_3
XFILLER_17_167 VGND VGND VPWR VPWR sky130_fd_sc_hd__fill_1
XFILLER_45_476 VGND VGND VPWR VPWR sky130_fd_sc_hd__decap_3
XFILLER_60_413 VGND VGND VPWR VPWR sky130_fd_sc_hd__decap_3
XFILLER_72_251 VGND VGND VPWR VPWR sky130_fd_sc_hd__fill_1
XFILLER_17_189 VGND VGND VPWR VPWR sky130_fd_sc_hd__fill_1
XTAP_TAPCELL_ROW_43_611 VGND VPWR sky130_fd_sc_hd__tapvpwrvgnd_1
XFILLER_82_52 VGND VGND VPWR VPWR sky130_fd_sc_hd__decap_3
XFILLER_13_340 VGND VGND VPWR VPWR sky130_fd_sc_hd__decap_3
XFILLER_32_159 VGND VGND VPWR VPWR sky130_fd_sc_hd__decap_3
XTAP_TAPCELL_ROW_15_346 VGND VPWR sky130_fd_sc_hd__tapvpwrvgnd_1
XFILLER_15_90 VGND VGND VPWR VPWR sky130_fd_sc_hd__decap_3
XFILLER_40_192 VGND VGND VPWR VPWR sky130_fd_sc_hd__decap_3
Xoutput107 _2803_/X VGND VGND VPWR VPWR MEM_STR_DATA[9] sky130_fd_sc_hd__clkdlybuf4s25_1
X_2550_ _2548_/X _2549_/X _5129_/Q VGND VGND VPWR VPWR _2550_/X sky130_fd_sc_hd__mux2_1
X_2481_ _5171_/Q _3653_/A VGND VGND VPWR VPWR _2482_/B sky130_fd_sc_hd__or2_2
X_4220_ _4376_/A _3642_/A _4449_/S VGND VGND VPWR VPWR _4220_/X sky130_fd_sc_hd__mux2_1
X_4151_ _4267_/S _3941_/C _4224_/B _3918_/X _4225_/A VGND VGND VPWR VPWR _4151_/X
+ sky130_fd_sc_hd__o32a_2
X_4082_ _4081_/X _3976_/C _4267_/S VGND VGND VPWR VPWR _4082_/X sky130_fd_sc_hd__mux2_1
X_3102_ _3174_/B _3156_/B VGND VGND VPWR VPWR _3103_/B sky130_fd_sc_hd__nor2_4
XFILLER_83_505 VGND VGND VPWR VPWR sky130_fd_sc_hd__decap_3
XFILLER_55_218 VGND VGND VPWR VPWR sky130_fd_sc_hd__decap_3
X_3033_ _2911_/X _3028_/Y _3029_/Y _4954_/Q VGND VGND VPWR VPWR _4954_/D sky130_fd_sc_hd__a22o_2
XFILLER_36_421 VGND VGND VPWR VPWR sky130_fd_sc_hd__decap_3
XFILLER_63_273 VGND VGND VPWR VPWR sky130_fd_sc_hd__decap_3
XFILLER_36_498 VGND VGND VPWR VPWR sky130_fd_sc_hd__decap_3
XFILLER_63_284 VGND VGND VPWR VPWR sky130_fd_sc_hd__decap_3
X_4984_ _5118_/CLK _4984_/D VGND VGND VPWR VPWR _4984_/Q sky130_fd_sc_hd__dfxtp_2
XFILLER_51_468 VGND VGND VPWR VPWR sky130_fd_sc_hd__decap_3
X_3935_ _3934_/A _3934_/B _3934_/Y _3891_/B _3884_/D VGND VGND VPWR VPWR _3948_/B
+ sky130_fd_sc_hd__a2111o_2
XFILLER_31_181 VGND VGND VPWR VPWR sky130_fd_sc_hd__decap_3
X_3866_ _4320_/A _3866_/B VGND VGND VPWR VPWR _3868_/B sky130_fd_sc_hd__nor2_2
X_3797_ _3934_/A _3797_/B VGND VGND VPWR VPWR _3943_/A sky130_fd_sc_hd__or2_2
X_2817_ _5122_/Q _5010_/Q _4994_/Q _4978_/Q _2818_/S0 _5136_/Q VGND VGND VPWR VPWR
+ _2817_/X sky130_fd_sc_hd__mux4_2
X_2748_ _5138_/Q _2743_/X _2745_/X _2747_/X VGND VGND VPWR VPWR _4746_/B sky130_fd_sc_hd__a22o_2
X_4418_ _3817_/B _4638_/S _3868_/B VGND VGND VPWR VPWR _4420_/A sky130_fd_sc_hd__a21o_2
X_2679_ _2673_/X _2674_/X _2677_/X _2433_/Y VGND VGND VPWR VPWR _4397_/D sky130_fd_sc_hd__a22o_2
XFILLER_59_535 VGND VGND VPWR VPWR sky130_fd_sc_hd__decap_3
X_4349_ _4397_/B _4397_/C VGND VGND VPWR VPWR _4351_/A sky130_fd_sc_hd__xor2_2
XFILLER_86_321 VGND VGND VPWR VPWR sky130_fd_sc_hd__decap_3
XFILLER_59_557 VGND VGND VPWR VPWR sky130_fd_sc_hd__fill_1
XFILLER_86_365 VGND VGND VPWR VPWR sky130_fd_sc_hd__decap_3
XFILLER_86_398 VGND VGND VPWR VPWR sky130_fd_sc_hd__decap_3
XFILLER_39_281 VGND VGND VPWR VPWR sky130_fd_sc_hd__decap_3
XTAP_TAPCELL_ROW_57_747 VGND VPWR sky130_fd_sc_hd__tapvpwrvgnd_1
XFILLER_27_487 VGND VGND VPWR VPWR sky130_fd_sc_hd__decap_3
XFILLER_36_56 VGND VGND VPWR VPWR sky130_fd_sc_hd__decap_3
XFILLER_14_115 VGND VGND VPWR VPWR sky130_fd_sc_hd__decap_3
XFILLER_54_295 VGND VGND VPWR VPWR sky130_fd_sc_hd__decap_3
XTAP_TAPCELL_ROW_12_316 VGND VPWR sky130_fd_sc_hd__tapvpwrvgnd_1
XFILLER_10_343 VGND VGND VPWR VPWR sky130_fd_sc_hd__decap_3
XFILLER_52_88 VGND VGND VPWR VPWR sky130_fd_sc_hd__fill_1
XFILLER_10_365 VGND VGND VPWR VPWR sky130_fd_sc_hd__decap_3
XFILLER_6_303 VGND VGND VPWR VPWR sky130_fd_sc_hd__decap_3
XFILLER_6_336 VGND VGND VPWR VPWR sky130_fd_sc_hd__decap_3
XTAP_TAPCELL_ROW_20_393 VGND VPWR sky130_fd_sc_hd__tapvpwrvgnd_1
XFILLER_2_542 VGND VGND VPWR VPWR sky130_fd_sc_hd__decap_3
XFILLER_89_192 VGND VGND VPWR VPWR sky130_fd_sc_hd__decap_3
XFILLER_77_63 VGND VGND VPWR VPWR sky130_fd_sc_hd__decap_3
XFILLER_77_52 VGND VGND VPWR VPWR sky130_fd_sc_hd__decap_3
XFILLER_77_332 VGND VGND VPWR VPWR sky130_fd_sc_hd__decap_3
XFILLER_77_343 VGND VGND VPWR VPWR sky130_fd_sc_hd__decap_3
XFILLER_65_516 VGND VGND VPWR VPWR sky130_fd_sc_hd__decap_3
XFILLER_77_376 VGND VGND VPWR VPWR sky130_fd_sc_hd__decap_3
XFILLER_18_421 VGND VGND VPWR VPWR sky130_fd_sc_hd__decap_3
XFILLER_92_357 VGND VGND VPWR VPWR sky130_fd_sc_hd__decap_3
XFILLER_33_402 VGND VGND VPWR VPWR sky130_fd_sc_hd__decap_3
XFILLER_80_519 VGND VGND VPWR VPWR sky130_fd_sc_hd__decap_3
XFILLER_18_498 VGND VGND VPWR VPWR sky130_fd_sc_hd__decap_3
XFILLER_33_435 VGND VGND VPWR VPWR sky130_fd_sc_hd__fill_2
XTAP_TAPCELL_ROW_28_471 VGND VPWR sky130_fd_sc_hd__tapvpwrvgnd_1
XFILLER_60_232 VGND VGND VPWR VPWR sky130_fd_sc_hd__decap_3
XFILLER_60_265 VGND VGND VPWR VPWR sky130_fd_sc_hd__fill_2
X_3720_ _4958_/Q _4942_/Q _4926_/Q _4910_/Q _3732_/S0 _3732_/S1 VGND VGND VPWR VPWR
+ _3720_/X sky130_fd_sc_hd__mux4_2
X_3651_ _3645_/X _3647_/X _3650_/X _2430_/Y VGND VGND VPWR VPWR _3784_/B sky130_fd_sc_hd__a22o_2
X_3582_ _3580_/X _3581_/X _3961_/S VGND VGND VPWR VPWR _4002_/B sky130_fd_sc_hd__mux2_1
X_2602_ _4732_/A _4320_/A VGND VGND VPWR VPWR _2862_/A sky130_fd_sc_hd__xnor2_2
X_2533_ _4893_/Q _4877_/Q _5101_/Q _5085_/Q _2676_/S0 _2676_/S1 VGND VGND VPWR VPWR
+ _2533_/X sky130_fd_sc_hd__mux4_2
X_5252_ _5254_/CLK _5252_/D VGND VGND VPWR VPWR _5252_/Q sky130_fd_sc_hd__dfxtp_2
X_2464_ _2455_/X _2461_/X _2463_/Y _2453_/X VGND VGND VPWR VPWR _2467_/B sky130_fd_sc_hd__a211oi_2
XFILLER_68_321 VGND VGND VPWR VPWR sky130_fd_sc_hd__decap_3
X_4203_ _3755_/Y _4195_/X _4224_/B _3994_/X VGND VGND VPWR VPWR _4203_/X sky130_fd_sc_hd__o2bb2a_2
X_5183_ _5253_/CLK _5183_/D VGND VGND VPWR VPWR _5183_/Q sky130_fd_sc_hd__dfxtp_2
XFILLER_3_60 VGND VGND VPWR VPWR sky130_fd_sc_hd__decap_3
XFILLER_68_354 VGND VGND VPWR VPWR sky130_fd_sc_hd__decap_3
X_4134_ _4175_/A _3878_/X _4070_/X VGND VGND VPWR VPWR _4134_/Y sky130_fd_sc_hd__o21ai_2
XFILLER_56_516 VGND VGND VPWR VPWR sky130_fd_sc_hd__decap_3
XFILLER_68_376 VGND VGND VPWR VPWR sky130_fd_sc_hd__decap_3
XFILLER_68_398 VGND VGND VPWR VPWR sky130_fd_sc_hd__decap_3
XFILLER_83_302 VGND VGND VPWR VPWR sky130_fd_sc_hd__decap_3
X_4065_ _4060_/X _4064_/X _4275_/B VGND VGND VPWR VPWR _4065_/Y sky130_fd_sc_hd__o21ai_2
XFILLER_36_262 VGND VGND VPWR VPWR sky130_fd_sc_hd__decap_3
XFILLER_71_508 VGND VGND VPWR VPWR sky130_fd_sc_hd__decap_3
X_3016_ _2914_/X _3011_/B _3011_/Y _4939_/Q VGND VGND VPWR VPWR _4939_/D sky130_fd_sc_hd__a22o_2
XTAP_TAPCELL_ROW_54_717 VGND VPWR sky130_fd_sc_hd__tapvpwrvgnd_1
XFILLER_83_379 VGND VGND VPWR VPWR sky130_fd_sc_hd__decap_3
XFILLER_24_413 VGND VGND VPWR VPWR sky130_fd_sc_hd__decap_3
XFILLER_24_424 VGND VGND VPWR VPWR sky130_fd_sc_hd__decap_3
XFILLER_51_221 VGND VGND VPWR VPWR sky130_fd_sc_hd__decap_3
XFILLER_51_232 VGND VGND VPWR VPWR sky130_fd_sc_hd__decap_3
XFILLER_51_287 VGND VGND VPWR VPWR sky130_fd_sc_hd__decap_3
X_4967_ clkload3/A _4967_/D VGND VGND VPWR VPWR _4967_/Q sky130_fd_sc_hd__dfxtp_2
XTAP_TAPCELL_ROW_62_794 VGND VPWR sky130_fd_sc_hd__tapvpwrvgnd_1
X_4898_ _5110_/CLK _4898_/D VGND VGND VPWR VPWR _4898_/Q sky130_fd_sc_hd__dfxtp_2
X_3918_ _3916_/X _3917_/X _4078_/B VGND VGND VPWR VPWR _3918_/X sky130_fd_sc_hd__mux2_1
X_3849_ _5171_/Q _4378_/A VGND VGND VPWR VPWR _3849_/Y sky130_fd_sc_hd__nor2_2
XFILLER_47_505 VGND VGND VPWR VPWR sky130_fd_sc_hd__decap_3
XFILLER_19_207 VGND VGND VPWR VPWR sky130_fd_sc_hd__decap_3
XFILLER_59_387 VGND VGND VPWR VPWR sky130_fd_sc_hd__decap_3
XFILLER_86_162 VGND VGND VPWR VPWR sky130_fd_sc_hd__fill_1
XFILLER_86_195 VGND VGND VPWR VPWR sky130_fd_sc_hd__fill_1
XFILLER_27_262 VGND VGND VPWR VPWR sky130_fd_sc_hd__decap_3
XFILLER_62_508 VGND VGND VPWR VPWR sky130_fd_sc_hd__decap_3
XFILLER_74_368 VGND VGND VPWR VPWR sky130_fd_sc_hd__decap_3
XFILLER_27_284 VGND VGND VPWR VPWR sky130_fd_sc_hd__fill_2
XFILLER_42_221 VGND VGND VPWR VPWR sky130_fd_sc_hd__decap_3
XFILLER_15_446 VGND VGND VPWR VPWR sky130_fd_sc_hd__fill_2
XFILLER_42_243 VGND VGND VPWR VPWR sky130_fd_sc_hd__decap_3
XFILLER_70_552 VGND VGND VPWR VPWR sky130_fd_sc_hd__decap_3
XTAP_TAPCELL_ROW_25_441 VGND VPWR sky130_fd_sc_hd__tapvpwrvgnd_1
XFILLER_30_416 VGND VGND VPWR VPWR sky130_fd_sc_hd__decap_3
XFILLER_30_427 VGND VGND VPWR VPWR sky130_fd_sc_hd__decap_3
XFILLER_42_287 VGND VGND VPWR VPWR sky130_fd_sc_hd__decap_3
XFILLER_63_87 VGND VGND VPWR VPWR sky130_fd_sc_hd__fill_2
XFILLER_8_27 VGND VGND VPWR VPWR sky130_fd_sc_hd__fill_1
XFILLER_10_195 VGND VGND VPWR VPWR sky130_fd_sc_hd__fill_1
XFILLER_6_133 VGND VGND VPWR VPWR sky130_fd_sc_hd__decap_3
XFILLER_6_144 VGND VGND VPWR VPWR sky130_fd_sc_hd__decap_3
XFILLER_26_6 VGND VGND VPWR VPWR sky130_fd_sc_hd__decap_3
XFILLER_38_505 VGND VGND VPWR VPWR sky130_fd_sc_hd__fill_2
XFILLER_38_527 VGND VGND VPWR VPWR sky130_fd_sc_hd__decap_3
XFILLER_77_162 VGND VGND VPWR VPWR sky130_fd_sc_hd__decap_3
XFILLER_65_335 VGND VGND VPWR VPWR sky130_fd_sc_hd__fill_1
XFILLER_65_346 VGND VGND VPWR VPWR sky130_fd_sc_hd__decap_3
XFILLER_77_184 VGND VGND VPWR VPWR sky130_fd_sc_hd__decap_3
XFILLER_53_508 VGND VGND VPWR VPWR sky130_fd_sc_hd__fill_2
XFILLER_65_379 VGND VGND VPWR VPWR sky130_fd_sc_hd__decap_3
XFILLER_18_262 VGND VGND VPWR VPWR sky130_fd_sc_hd__fill_2
XFILLER_18_284 VGND VGND VPWR VPWR sky130_fd_sc_hd__fill_2
XFILLER_33_210 VGND VGND VPWR VPWR sky130_fd_sc_hd__decap_3
XFILLER_80_327 VGND VGND VPWR VPWR sky130_fd_sc_hd__decap_3
XFILLER_73_390 VGND VGND VPWR VPWR sky130_fd_sc_hd__fill_2
X_4821_ _4821_/A _4821_/B VGND VGND VPWR VPWR _4823_/B sky130_fd_sc_hd__nand2_2
XFILLER_33_287 VGND VGND VPWR VPWR sky130_fd_sc_hd__decap_3
XFILLER_21_438 VGND VGND VPWR VPWR sky130_fd_sc_hd__decap_3
XFILLER_21_449 VGND VGND VPWR VPWR sky130_fd_sc_hd__decap_3
X_4752_ _5261_/Q _4847_/B _4751_/X _3338_/B VGND VGND VPWR VPWR _5261_/D sky130_fd_sc_hd__o211a_2
X_4683_ _4666_/A _4578_/Y _4682_/X _4437_/B VGND VGND VPWR VPWR _4683_/X sky130_fd_sc_hd__o22a_2
X_3703_ _4200_/C _4155_/A VGND VGND VPWR VPWR _4123_/A sky130_fd_sc_hd__or2_2
X_3634_ _3705_/A _3634_/B VGND VGND VPWR VPWR _3634_/X sky130_fd_sc_hd__or2_2
XTAP_TAPCELL_ROW_31_499 VGND VPWR sky130_fd_sc_hd__tapvpwrvgnd_1
X_3565_ _3867_/A _4390_/A _3905_/B VGND VGND VPWR VPWR _3565_/X sky130_fd_sc_hd__mux2_1
XFILLER_0_309 VGND VGND VPWR VPWR sky130_fd_sc_hd__decap_3
X_3496_ _3773_/A _4437_/A VGND VGND VPWR VPWR _4422_/S sky130_fd_sc_hd__nor2_2
X_2516_ _4376_/B VGND VGND VPWR VPWR _3852_/A sky130_fd_sc_hd__inv_2
X_5235_ _5253_/CLK _5235_/D VGND VGND VPWR VPWR _5235_/Q sky130_fd_sc_hd__dfxtp_2
X_2447_ _5183_/Q _4069_/A VGND VGND VPWR VPWR _2706_/B sky130_fd_sc_hd__nor2_2
XFILLER_29_516 VGND VGND VPWR VPWR sky130_fd_sc_hd__decap_3
XFILLER_68_162 VGND VGND VPWR VPWR sky130_fd_sc_hd__decap_3
X_5166_ _5270_/CLK _5166_/D VGND VGND VPWR VPWR _5166_/Q sky130_fd_sc_hd__dfxtp_2
X_4117_ _4112_/X _4116_/Y _4847_/B VGND VGND VPWR VPWR _4117_/Y sky130_fd_sc_hd__o21ai_2
X_5097_ _5105_/CLK _5097_/D VGND VGND VPWR VPWR _5097_/Q sky130_fd_sc_hd__dfxtp_2
XTAP_TAPCELL_ROW_67_842 VGND VPWR sky130_fd_sc_hd__tapvpwrvgnd_1
XFILLER_83_110 VGND VGND VPWR VPWR sky130_fd_sc_hd__fill_2
XFILLER_44_508 VGND VGND VPWR VPWR sky130_fd_sc_hd__fill_2
X_4048_ _4047_/X _3992_/Y _4266_/S VGND VGND VPWR VPWR _4049_/B sky130_fd_sc_hd__mux2_1
XFILLER_71_349 VGND VGND VPWR VPWR sky130_fd_sc_hd__fill_1
XFILLER_83_187 VGND VGND VPWR VPWR sky130_fd_sc_hd__decap_3
XFILLER_12_427 VGND VGND VPWR VPWR sky130_fd_sc_hd__decap_3
XFILLER_24_298 VGND VGND VPWR VPWR sky130_fd_sc_hd__decap_3
XFILLER_33_57 VGND VGND VPWR VPWR sky130_fd_sc_hd__decap_3
XTAP_TAPCELL_ROW_22_411 VGND VPWR sky130_fd_sc_hd__tapvpwrvgnd_1
XFILLER_3_169 VGND VGND VPWR VPWR sky130_fd_sc_hd__fill_2
XFILLER_79_449 VGND VGND VPWR VPWR sky130_fd_sc_hd__decap_3
XFILLER_79_438 VGND VGND VPWR VPWR sky130_fd_sc_hd__decap_3
XFILLER_58_43 VGND VGND VPWR VPWR sky130_fd_sc_hd__decap_3
XFILLER_47_313 VGND VGND VPWR VPWR sky130_fd_sc_hd__decap_3
XFILLER_59_162 VGND VGND VPWR VPWR sky130_fd_sc_hd__decap_3
XFILLER_74_121 VGND VGND VPWR VPWR sky130_fd_sc_hd__decap_3
XFILLER_35_508 VGND VGND VPWR VPWR sky130_fd_sc_hd__fill_1
XFILLER_47_368 VGND VGND VPWR VPWR sky130_fd_sc_hd__decap_3
XFILLER_62_305 VGND VGND VPWR VPWR sky130_fd_sc_hd__decap_3
XFILLER_62_327 VGND VGND VPWR VPWR sky130_fd_sc_hd__decap_3
XFILLER_62_338 VGND VGND VPWR VPWR sky130_fd_sc_hd__decap_3
XFILLER_74_187 VGND VGND VPWR VPWR sky130_fd_sc_hd__fill_1
XFILLER_15_243 VGND VGND VPWR VPWR sky130_fd_sc_hd__decap_3
XFILLER_15_298 VGND VGND VPWR VPWR sky130_fd_sc_hd__decap_3
XFILLER_70_393 VGND VGND VPWR VPWR sky130_fd_sc_hd__decap_3
XFILLER_7_442 VGND VGND VPWR VPWR sky130_fd_sc_hd__decap_3
XFILLER_7_420 VGND VGND VPWR VPWR sky130_fd_sc_hd__decap_3
Xmax_cap117 _3175_/Y VGND VGND VPWR VPWR _3191_/B1 sky130_fd_sc_hd__buf_6
Xmax_cap139 _4015_/B VGND VGND VPWR VPWR _4174_/C sky130_fd_sc_hd__buf_4
Xmax_cap128 _3084_/B VGND VGND VPWR VPWR _3100_/A2 sky130_fd_sc_hd__buf_6
X_3350_ _5283_/Q _3366_/A _3350_/C VGND VGND VPWR VPWR _3350_/X sky130_fd_sc_hd__and3_2
X_5020_ _5114_/CLK _5020_/D VGND VGND VPWR VPWR _5020_/Q sky130_fd_sc_hd__dfxtp_2
X_3281_ _5145_/Q _3311_/S _3308_/B VGND VGND VPWR VPWR _3297_/B sky130_fd_sc_hd__and3_2
XFILLER_24_3 VGND VGND VPWR VPWR sky130_fd_sc_hd__decap_3
XFILLER_78_460 VGND VGND VPWR VPWR sky130_fd_sc_hd__decap_3
XFILLER_38_324 VGND VGND VPWR VPWR sky130_fd_sc_hd__decap_3
XTAP_TAPCELL_ROW_88_1033 VGND VPWR sky130_fd_sc_hd__tapvpwrvgnd_1
XFILLER_93_430 VGND VGND VPWR VPWR sky130_fd_sc_hd__decap_3
XFILLER_38_357 VGND VGND VPWR VPWR sky130_fd_sc_hd__decap_3
XFILLER_38_368 VGND VGND VPWR VPWR sky130_fd_sc_hd__decap_3
XFILLER_93_452 VGND VGND VPWR VPWR sky130_fd_sc_hd__decap_3
XTAP_TAPCELL_ROW_64_812 VGND VPWR sky130_fd_sc_hd__tapvpwrvgnd_1
XFILLER_0_72 VGND VGND VPWR VPWR sky130_fd_sc_hd__decap_3
XFILLER_0_94 VGND VGND VPWR VPWR sky130_fd_sc_hd__decap_3
XFILLER_34_552 VGND VGND VPWR VPWR sky130_fd_sc_hd__decap_3
XTAP_TAPCELL_ROW_36_547 VGND VPWR sky130_fd_sc_hd__tapvpwrvgnd_1
XFILLER_80_157 VGND VGND VPWR VPWR sky130_fd_sc_hd__decap_3
XFILLER_80_135 VGND VGND VPWR VPWR sky130_fd_sc_hd__decap_3
XFILLER_61_382 VGND VGND VPWR VPWR sky130_fd_sc_hd__decap_3
XFILLER_61_393 VGND VGND VPWR VPWR sky130_fd_sc_hd__decap_3
X_4804_ _5268_/Q _4847_/B VGND VGND VPWR VPWR _4804_/X sky130_fd_sc_hd__or2_2
XFILLER_21_257 VGND VGND VPWR VPWR sky130_fd_sc_hd__decap_3
X_4735_ _4733_/Y _4734_/X _4854_/B VGND VGND VPWR VPWR _4735_/X sky130_fd_sc_hd__a21o_2
X_2996_ _2908_/X _2993_/B _2993_/Y _4921_/Q VGND VGND VPWR VPWR _4921_/D sky130_fd_sc_hd__a22o_2
XFILLER_9_70 VGND VGND VPWR VPWR sky130_fd_sc_hd__decap_3
X_4666_ _4666_/A _4666_/B _4666_/C VGND VGND VPWR VPWR _4666_/X sky130_fd_sc_hd__or3_2
X_4597_ _4597_/A _4597_/B _4597_/C VGND VGND VPWR VPWR _4597_/X sky130_fd_sc_hd__and3_2
X_3617_ _4320_/A _4286_/A VGND VGND VPWR VPWR _4412_/S sky130_fd_sc_hd__nor2_2
X_3548_ _4437_/A _3548_/B VGND VGND VPWR VPWR _4225_/A sky130_fd_sc_hd__or2_2
XFILLER_0_106 VGND VGND VPWR VPWR sky130_fd_sc_hd__decap_3
XFILLER_88_224 VGND VGND VPWR VPWR sky130_fd_sc_hd__decap_3
XFILLER_0_128 VGND VGND VPWR VPWR sky130_fd_sc_hd__decap_3
X_3479_ _3479_/A _3479_/B VGND VGND VPWR VPWR _3479_/Y sky130_fd_sc_hd__nor2_2
XFILLER_69_460 VGND VGND VPWR VPWR sky130_fd_sc_hd__fill_2
X_5218_ _5253_/CLK _5218_/D VGND VGND VPWR VPWR _5218_/Q sky130_fd_sc_hd__dfxtp_2
XFILLER_76_419 VGND VGND VPWR VPWR sky130_fd_sc_hd__fill_1
X_5149_ _5270_/CLK _5149_/D VGND VGND VPWR VPWR _5149_/Q sky130_fd_sc_hd__dfxtp_2
XFILLER_84_430 VGND VGND VPWR VPWR sky130_fd_sc_hd__fill_2
XFILLER_84_474 VGND VGND VPWR VPWR sky130_fd_sc_hd__fill_2
XFILLER_84_463 VGND VGND VPWR VPWR sky130_fd_sc_hd__fill_2
XFILLER_71_113 VGND VGND VPWR VPWR sky130_fd_sc_hd__decap_3
XFILLER_71_157 VGND VGND VPWR VPWR sky130_fd_sc_hd__decap_3
XFILLER_12_246 VGND VGND VPWR VPWR sky130_fd_sc_hd__decap_3
XFILLER_60_88 VGND VGND VPWR VPWR sky130_fd_sc_hd__decap_3
XFILLER_4_445 VGND VGND VPWR VPWR sky130_fd_sc_hd__fill_1
XFILLER_69_64 VGND VGND VPWR VPWR sky130_fd_sc_hd__decap_3
XFILLER_79_202 VGND VGND VPWR VPWR sky130_fd_sc_hd__decap_3
XFILLER_67_408 VGND VGND VPWR VPWR sky130_fd_sc_hd__decap_3
XTAP_TAPCELL_ROW_7_272 VGND VPWR sky130_fd_sc_hd__tapvpwrvgnd_1
XFILLER_79_279 VGND VGND VPWR VPWR sky130_fd_sc_hd__fill_1
XFILLER_75_430 VGND VGND VPWR VPWR sky130_fd_sc_hd__decap_3
XFILLER_75_452 VGND VGND VPWR VPWR sky130_fd_sc_hd__fill_2
XFILLER_47_176 VGND VGND VPWR VPWR sky130_fd_sc_hd__decap_3
XFILLER_62_157 VGND VGND VPWR VPWR sky130_fd_sc_hd__decap_3
XFILLER_90_455 VGND VGND VPWR VPWR sky130_fd_sc_hd__fill_2
XTAP_TAPCELL_ROW_33_517 VGND VPWR sky130_fd_sc_hd__tapvpwrvgnd_1
XFILLER_43_382 VGND VGND VPWR VPWR sky130_fd_sc_hd__decap_3
XFILLER_43_393 VGND VGND VPWR VPWR sky130_fd_sc_hd__decap_3
X_2850_ _2855_/S _2850_/B VGND VGND VPWR VPWR _2850_/X sky130_fd_sc_hd__or2_2
XFILLER_93_6 VGND VGND VPWR VPWR sky130_fd_sc_hd__decap_3
X_2781_ _2832_/A _2781_/B VGND VGND VPWR VPWR _2781_/X sky130_fd_sc_hd__or2_2
XFILLER_11_290 VGND VGND VPWR VPWR sky130_fd_sc_hd__decap_3
X_4520_ _4493_/Y _4519_/X _4692_/A VGND VGND VPWR VPWR _5229_/D sky130_fd_sc_hd__a21oi_2
XTAP_TAPCELL_ROW_41_594 VGND VPWR sky130_fd_sc_hd__tapvpwrvgnd_1
X_4451_ _4241_/A _4449_/S _4265_/B VGND VGND VPWR VPWR _4451_/X sky130_fd_sc_hd__o21a_2
X_3402_ _3458_/A _3402_/B _3401_/X VGND VGND VPWR VPWR _3402_/X sky130_fd_sc_hd__or3b_2
X_4382_ _4382_/A _4382_/B VGND VGND VPWR VPWR _4502_/B sky130_fd_sc_hd__or2_2
X_3333_ _5164_/Q _3230_/B _3230_/Y _3332_/X VGND VGND VPWR VPWR _5164_/D sky130_fd_sc_hd__o22a_2
X_3264_ _3338_/B _3264_/B _3264_/C VGND VGND VPWR VPWR _5140_/D sky130_fd_sc_hd__and3_2
XPHY_EDGE_ROW_7_Right_7 VGND VGND VPWR VPWR sky130_fd_sc_hd__decap_3
X_5003_ clkload9/A _5003_/D VGND VGND VPWR VPWR _5003_/Q sky130_fd_sc_hd__dfxtp_2
XFILLER_78_290 VGND VGND VPWR VPWR sky130_fd_sc_hd__decap_3
XFILLER_66_441 VGND VGND VPWR VPWR sky130_fd_sc_hd__decap_3
X_3195_ _2905_/X _3193_/B _3193_/Y _5096_/Q VGND VGND VPWR VPWR _5096_/D sky130_fd_sc_hd__a22o_2
XFILLER_26_338 VGND VGND VPWR VPWR sky130_fd_sc_hd__fill_1
XFILLER_53_102 VGND VGND VPWR VPWR sky130_fd_sc_hd__decap_3
XFILLER_53_113 VGND VGND VPWR VPWR sky130_fd_sc_hd__decap_3
XFILLER_81_466 VGND VGND VPWR VPWR sky130_fd_sc_hd__decap_3
XFILLER_14_15 VGND VGND VPWR VPWR sky130_fd_sc_hd__decap_3
XFILLER_22_522 VGND VGND VPWR VPWR sky130_fd_sc_hd__decap_3
XFILLER_22_533 VGND VGND VPWR VPWR sky130_fd_sc_hd__decap_3
XFILLER_14_59 VGND VGND VPWR VPWR sky130_fd_sc_hd__decap_3
XFILLER_61_190 VGND VGND VPWR VPWR sky130_fd_sc_hd__decap_3
X_2979_ _2914_/X _2974_/B _2974_/Y _4907_/Q VGND VGND VPWR VPWR _4907_/D sky130_fd_sc_hd__a22o_2
XFILLER_5_209 VGND VGND VPWR VPWR sky130_fd_sc_hd__decap_3
X_4718_ input35/X _4694_/Y _4717_/X _3366_/A VGND VGND VPWR VPWR _5253_/D sky130_fd_sc_hd__o211a_2
XFILLER_30_47 VGND VGND VPWR VPWR sky130_fd_sc_hd__decap_3
X_4649_ _4437_/A _4642_/X _4648_/X _4203_/X VGND VGND VPWR VPWR _4649_/X sky130_fd_sc_hd__o211a_2
XFILLER_89_511 VGND VGND VPWR VPWR sky130_fd_sc_hd__fill_2
XFILLER_89_500 VGND VGND VPWR VPWR sky130_fd_sc_hd__decap_3
XFILLER_89_555 VGND VGND VPWR VPWR sky130_fd_sc_hd__decap_3
XFILLER_29_110 VGND VGND VPWR VPWR sky130_fd_sc_hd__fill_2
XFILLER_29_121 VGND VGND VPWR VPWR sky130_fd_sc_hd__fill_1
XFILLER_39_67 VGND VGND VPWR VPWR sky130_fd_sc_hd__fill_2
XTAP_TAPCELL_ROW_4_242 VGND VPWR sky130_fd_sc_hd__tapvpwrvgnd_1
XFILLER_76_227 VGND VGND VPWR VPWR sky130_fd_sc_hd__decap_3
XFILLER_57_441 VGND VGND VPWR VPWR sky130_fd_sc_hd__decap_3
XFILLER_57_452 VGND VGND VPWR VPWR sky130_fd_sc_hd__decap_3
XFILLER_69_290 VGND VGND VPWR VPWR sky130_fd_sc_hd__fill_2
XTAP_TAPCELL_ROW_75_918 VGND VPWR sky130_fd_sc_hd__tapvpwrvgnd_1
XFILLER_17_327 VGND VGND VPWR VPWR sky130_fd_sc_hd__decap_3
XFILLER_17_349 VGND VGND VPWR VPWR sky130_fd_sc_hd__decap_3
XFILLER_55_55 VGND VGND VPWR VPWR sky130_fd_sc_hd__fill_1
XFILLER_55_66 VGND VGND VPWR VPWR sky130_fd_sc_hd__fill_1
XFILLER_72_433 VGND VGND VPWR VPWR sky130_fd_sc_hd__decap_3
XFILLER_72_477 VGND VGND VPWR VPWR sky130_fd_sc_hd__decap_3
XFILLER_25_393 VGND VGND VPWR VPWR sky130_fd_sc_hd__decap_3
XFILLER_13_555 VGND VGND VPWR VPWR sky130_fd_sc_hd__decap_3
XFILLER_40_363 VGND VGND VPWR VPWR sky130_fd_sc_hd__fill_1
XFILLER_9_537 VGND VGND VPWR VPWR sky130_fd_sc_hd__decap_3
XTAP_TAPCELL_ROW_10_299 VGND VPWR sky130_fd_sc_hd__tapvpwrvgnd_1
XFILLER_4_253 VGND VGND VPWR VPWR sky130_fd_sc_hd__decap_3
XFILLER_20_80 VGND VGND VPWR VPWR sky130_fd_sc_hd__decap_3
XFILLER_67_249 VGND VGND VPWR VPWR sky130_fd_sc_hd__decap_3
XFILLER_48_452 VGND VGND VPWR VPWR sky130_fd_sc_hd__decap_3
XFILLER_63_422 VGND VGND VPWR VPWR sky130_fd_sc_hd__decap_3
XFILLER_75_271 VGND VGND VPWR VPWR sky130_fd_sc_hd__decap_3
XFILLER_35_146 VGND VGND VPWR VPWR sky130_fd_sc_hd__decap_3
XFILLER_63_455 VGND VGND VPWR VPWR sky130_fd_sc_hd__decap_3
XFILLER_75_293 VGND VGND VPWR VPWR sky130_fd_sc_hd__decap_3
XTAP_TAPCELL_ROW_46_642 VGND VPWR sky130_fd_sc_hd__tapvpwrvgnd_1
XFILLER_16_360 VGND VGND VPWR VPWR sky130_fd_sc_hd__decap_3
XFILLER_50_105 VGND VGND VPWR VPWR sky130_fd_sc_hd__fill_1
X_3951_ _5212_/Q _4854_/B _3949_/X _3950_/X VGND VGND VPWR VPWR _3952_/B sky130_fd_sc_hd__o2bb2a_2
XFILLER_16_371 VGND VGND VPWR VPWR sky130_fd_sc_hd__decap_3
X_2902_ _4692_/A _2902_/B VGND VGND VPWR VPWR _2902_/Y sky130_fd_sc_hd__nor2_4
XTAP_TAPCELL_ROW_18_377 VGND VPWR sky130_fd_sc_hd__tapvpwrvgnd_1
X_3882_ _4051_/A _4267_/S _4132_/B VGND VGND VPWR VPWR _3898_/D sky130_fd_sc_hd__or3_2
XFILLER_91_3 VGND VGND VPWR VPWR sky130_fd_sc_hd__fill_2
X_2833_ _4900_/Q _4884_/Q _5108_/Q _5092_/Q _2854_/S0 _5136_/Q VGND VGND VPWR VPWR
+ _2833_/X sky130_fd_sc_hd__mux4_2
X_2764_ _4956_/Q _4940_/Q _4924_/Q _4908_/Q _2818_/S0 _5136_/Q VGND VGND VPWR VPWR
+ _2764_/X sky130_fd_sc_hd__mux4_2
X_4503_ _4503_/A _4503_/B VGND VGND VPWR VPWR _4503_/Y sky130_fd_sc_hd__nand2_2
X_2695_ _3848_/A _2695_/B _4236_/B VGND VGND VPWR VPWR _2707_/C sky130_fd_sc_hd__nand3b_2
X_4434_ _4434_/A _4434_/B _4320_/Y VGND VGND VPWR VPWR _4434_/X sky130_fd_sc_hd__or3b_2
X_4365_ _4365_/A _4376_/A VGND VGND VPWR VPWR _4386_/B sky130_fd_sc_hd__nand2_2
XFILLER_58_205 VGND VGND VPWR VPWR sky130_fd_sc_hd__fill_1
X_3316_ _5259_/Q _3305_/B _3315_/X _3338_/B VGND VGND VPWR VPWR _5154_/D sky130_fd_sc_hd__o211a_2
X_4296_ _4292_/X _4524_/A _4572_/S VGND VGND VPWR VPWR _4296_/X sky130_fd_sc_hd__mux2_1
XFILLER_86_536 VGND VGND VPWR VPWR sky130_fd_sc_hd__fill_1
XFILLER_39_430 VGND VGND VPWR VPWR sky130_fd_sc_hd__decap_3
XFILLER_39_452 VGND VGND VPWR VPWR sky130_fd_sc_hd__decap_3
X_3247_ _5283_/Q _3338_/B _3247_/C VGND VGND VPWR VPWR _3247_/X sky130_fd_sc_hd__and3_2
X_3178_ _2908_/X _3191_/A2 _3191_/B1 _5081_/Q VGND VGND VPWR VPWR _5081_/D sky130_fd_sc_hd__a22o_2
XTAP_TAPCELL_ROW_1_212 VGND VPWR sky130_fd_sc_hd__tapvpwrvgnd_1
XFILLER_54_433 VGND VGND VPWR VPWR sky130_fd_sc_hd__fill_1
XFILLER_54_455 VGND VGND VPWR VPWR sky130_fd_sc_hd__decap_3
XFILLER_25_36 VGND VGND VPWR VPWR sky130_fd_sc_hd__decap_3
XFILLER_54_477 VGND VGND VPWR VPWR sky130_fd_sc_hd__decap_3
XFILLER_41_116 VGND VGND VPWR VPWR sky130_fd_sc_hd__decap_3
XTAP_TAPCELL_ROW_80_965 VGND VPWR sky130_fd_sc_hd__tapvpwrvgnd_1
XFILLER_22_374 VGND VGND VPWR VPWR sky130_fd_sc_hd__decap_3
XFILLER_10_536 VGND VGND VPWR VPWR sky130_fd_sc_hd__decap_3
XFILLER_41_35 VGND VGND VPWR VPWR sky130_fd_sc_hd__decap_3
XFILLER_41_68 VGND VGND VPWR VPWR sky130_fd_sc_hd__fill_1
XFILLER_89_374 VGND VGND VPWR VPWR sky130_fd_sc_hd__decap_3
XFILLER_2_29 VGND VGND VPWR VPWR sky130_fd_sc_hd__decap_3
XFILLER_49_216 VGND VGND VPWR VPWR sky130_fd_sc_hd__decap_3
XFILLER_66_43 VGND VGND VPWR VPWR sky130_fd_sc_hd__decap_3
XFILLER_92_506 VGND VGND VPWR VPWR sky130_fd_sc_hd__decap_3
XFILLER_66_65 VGND VGND VPWR VPWR sky130_fd_sc_hd__decap_3
XFILLER_17_113 VGND VGND VPWR VPWR sky130_fd_sc_hd__fill_2
XFILLER_45_444 VGND VGND VPWR VPWR sky130_fd_sc_hd__decap_3
XFILLER_45_455 VGND VGND VPWR VPWR sky130_fd_sc_hd__decap_3
XFILLER_57_293 VGND VGND VPWR VPWR sky130_fd_sc_hd__decap_3
XFILLER_32_105 VGND VGND VPWR VPWR sky130_fd_sc_hd__decap_3
XFILLER_60_436 VGND VGND VPWR VPWR sky130_fd_sc_hd__fill_1
XTAP_TAPCELL_ROW_43_612 VGND VPWR sky130_fd_sc_hd__tapvpwrvgnd_1
XFILLER_82_64 VGND VGND VPWR VPWR sky130_fd_sc_hd__decap_3
XFILLER_13_352 VGND VGND VPWR VPWR sky130_fd_sc_hd__decap_3
XTAP_TAPCELL_ROW_15_347 VGND VPWR sky130_fd_sc_hd__tapvpwrvgnd_1
XFILLER_9_312 VGND VGND VPWR VPWR sky130_fd_sc_hd__fill_1
XFILLER_5_551 VGND VGND VPWR VPWR sky130_fd_sc_hd__decap_3
X_2480_ _5171_/Q _3653_/A VGND VGND VPWR VPWR _2482_/A sky130_fd_sc_hd__nand2_2
XFILLER_68_503 VGND VGND VPWR VPWR sky130_fd_sc_hd__decap_3
X_4150_ _4149_/X _4049_/B _4267_/S VGND VGND VPWR VPWR _4150_/X sky130_fd_sc_hd__mux2_1
XTAP_TAPCELL_ROW_91_1062 VGND VPWR sky130_fd_sc_hd__tapvpwrvgnd_1
Xoutput90 _2878_/Y VGND VGND VPWR VPWR MEM_ADDR[8] sky130_fd_sc_hd__clkdlybuf4s25_1
X_3101_ _5193_/Q _5192_/Q _5188_/Q _5281_/D VGND VGND VPWR VPWR _3156_/B sky130_fd_sc_hd__nand4_2
X_4081_ _4080_/Y _4028_/Y _4266_/S VGND VGND VPWR VPWR _4081_/X sky130_fd_sc_hd__mux2_1
XFILLER_36_400 VGND VGND VPWR VPWR sky130_fd_sc_hd__decap_3
X_3032_ _2908_/X _3029_/B _3029_/Y _4953_/Q VGND VGND VPWR VPWR _4953_/D sky130_fd_sc_hd__a22o_2
XFILLER_36_433 VGND VGND VPWR VPWR sky130_fd_sc_hd__decap_3
XFILLER_48_293 VGND VGND VPWR VPWR sky130_fd_sc_hd__decap_3
XFILLER_36_466 VGND VGND VPWR VPWR sky130_fd_sc_hd__decap_3
XFILLER_63_241 VGND VGND VPWR VPWR sky130_fd_sc_hd__decap_3
XFILLER_91_550 VGND VGND VPWR VPWR sky130_fd_sc_hd__decap_3
XFILLER_23_116 VGND VGND VPWR VPWR sky130_fd_sc_hd__decap_3
X_4983_ _5010_/CLK _4983_/D VGND VGND VPWR VPWR _4983_/Q sky130_fd_sc_hd__dfxtp_2
X_3934_ _3934_/A _3934_/B VGND VGND VPWR VPWR _3934_/Y sky130_fd_sc_hd__nor2_2
X_3865_ _4318_/A _4393_/D _3866_/B VGND VGND VPWR VPWR _3865_/X sky130_fd_sc_hd__mux2_1
XFILLER_31_193 VGND VGND VPWR VPWR sky130_fd_sc_hd__decap_3
X_2816_ _2832_/A _2813_/X _5138_/Q VGND VGND VPWR VPWR _2816_/X sky130_fd_sc_hd__o21a_2
X_3796_ _3892_/A _3892_/B _3795_/X VGND VGND VPWR VPWR _3797_/B sky130_fd_sc_hd__a21oi_2
X_2747_ _2832_/A _2746_/X _2435_/Y VGND VGND VPWR VPWR _2747_/X sky130_fd_sc_hd__o21a_2
X_2678_ _2673_/X _2674_/X _2677_/X _2433_/Y VGND VGND VPWR VPWR _4350_/B sky130_fd_sc_hd__a22oi_2
X_4417_ _4299_/X _4302_/X _4422_/S VGND VGND VPWR VPWR _4666_/A sky130_fd_sc_hd__mux2_1
X_4348_ _4348_/A _4348_/B VGND VGND VPWR VPWR _4353_/A sky130_fd_sc_hd__xnor2_2
X_4279_ _4286_/A _4286_/B VGND VGND VPWR VPWR _4287_/A sky130_fd_sc_hd__nor2_2
XFILLER_27_411 VGND VGND VPWR VPWR sky130_fd_sc_hd__decap_3
XFILLER_86_377 VGND VGND VPWR VPWR sky130_fd_sc_hd__decap_3
XFILLER_27_422 VGND VGND VPWR VPWR sky130_fd_sc_hd__decap_3
XFILLER_36_35 VGND VGND VPWR VPWR sky130_fd_sc_hd__decap_3
XFILLER_54_230 VGND VGND VPWR VPWR sky130_fd_sc_hd__decap_3
XFILLER_27_466 VGND VGND VPWR VPWR sky130_fd_sc_hd__decap_3
XFILLER_27_499 VGND VGND VPWR VPWR sky130_fd_sc_hd__decap_3
XFILLER_14_138 VGND VGND VPWR VPWR sky130_fd_sc_hd__fill_2
XFILLER_52_23 VGND VGND VPWR VPWR sky130_fd_sc_hd__decap_3
XTAP_TAPCELL_ROW_12_317 VGND VPWR sky130_fd_sc_hd__tapvpwrvgnd_1
XFILLER_6_315 VGND VGND VPWR VPWR sky130_fd_sc_hd__decap_3
XFILLER_10_399 VGND VGND VPWR VPWR sky130_fd_sc_hd__decap_3
XFILLER_6_348 VGND VGND VPWR VPWR sky130_fd_sc_hd__decap_3
XTAP_TAPCELL_ROW_20_394 VGND VPWR sky130_fd_sc_hd__tapvpwrvgnd_1
XFILLER_2_521 VGND VGND VPWR VPWR sky130_fd_sc_hd__decap_3
XFILLER_2_554 VGND VGND VPWR VPWR sky130_fd_sc_hd__decap_3
XFILLER_77_311 VGND VGND VPWR VPWR sky130_fd_sc_hd__decap_3
XFILLER_77_31 VGND VGND VPWR VPWR sky130_fd_sc_hd__fill_1
XFILLER_77_86 VGND VGND VPWR VPWR sky130_fd_sc_hd__decap_3
XFILLER_77_75 VGND VGND VPWR VPWR sky130_fd_sc_hd__decap_3
XFILLER_18_400 VGND VGND VPWR VPWR sky130_fd_sc_hd__fill_1
XFILLER_37_219 VGND VGND VPWR VPWR sky130_fd_sc_hd__decap_3
XFILLER_18_477 VGND VGND VPWR VPWR sky130_fd_sc_hd__decap_3
XFILLER_73_550 VGND VGND VPWR VPWR sky130_fd_sc_hd__decap_3
XFILLER_93_63 VGND VGND VPWR VPWR sky130_fd_sc_hd__decap_3
XTAP_TAPCELL_ROW_28_472 VGND VPWR sky130_fd_sc_hd__tapvpwrvgnd_1
XFILLER_93_85 VGND VGND VPWR VPWR sky130_fd_sc_hd__decap_3
XFILLER_33_447 VGND VGND VPWR VPWR sky130_fd_sc_hd__fill_1
XFILLER_33_458 VGND VGND VPWR VPWR sky130_fd_sc_hd__decap_3
XFILLER_20_108 VGND VGND VPWR VPWR sky130_fd_sc_hd__decap_3
XFILLER_60_299 VGND VGND VPWR VPWR sky130_fd_sc_hd__decap_3
X_3650_ _3648_/X _3649_/X _3733_/S VGND VGND VPWR VPWR _3650_/X sky130_fd_sc_hd__mux2_1
X_3581_ _4397_/B _3701_/A _3874_/S VGND VGND VPWR VPWR _3581_/X sky130_fd_sc_hd__mux2_1
X_2601_ _2601_/A _4413_/S VGND VGND VPWR VPWR _2601_/Y sky130_fd_sc_hd__nor2_2
X_2532_ _5163_/Q _3825_/B VGND VGND VPWR VPWR _2630_/B sky130_fd_sc_hd__nor2_2
X_5251_ _5251_/CLK _5251_/D VGND VGND VPWR VPWR _5251_/Q sky130_fd_sc_hd__dfxtp_2
X_4202_ _4115_/B _4199_/X _4201_/X VGND VGND VPWR VPWR _4207_/B sky130_fd_sc_hd__a21bo_2
X_2463_ _2463_/A _2463_/B VGND VGND VPWR VPWR _2463_/Y sky130_fd_sc_hd__nor2_2
X_5182_ _5253_/CLK _5182_/D VGND VGND VPWR VPWR _5182_/Q sky130_fd_sc_hd__dfxtp_2
XFILLER_87_119 VGND VGND VPWR VPWR sky130_fd_sc_hd__decap_3
XFILLER_68_333 VGND VGND VPWR VPWR sky130_fd_sc_hd__decap_3
X_4133_ _4051_/A _4131_/X _4132_/X VGND VGND VPWR VPWR _4138_/B sky130_fd_sc_hd__o21a_2
X_4064_ _4062_/X _4063_/Y _4168_/A VGND VGND VPWR VPWR _4064_/X sky130_fd_sc_hd__o21a_2
XFILLER_83_314 VGND VGND VPWR VPWR sky130_fd_sc_hd__decap_3
X_3015_ _2911_/X _3011_/B _3011_/Y _4938_/Q VGND VGND VPWR VPWR _4938_/D sky130_fd_sc_hd__a22o_2
XFILLER_83_347 VGND VGND VPWR VPWR sky130_fd_sc_hd__decap_3
XTAP_TAPCELL_ROW_54_718 VGND VPWR sky130_fd_sc_hd__tapvpwrvgnd_1
XFILLER_24_436 VGND VGND VPWR VPWR sky130_fd_sc_hd__decap_3
XFILLER_36_274 VGND VGND VPWR VPWR sky130_fd_sc_hd__decap_3
XFILLER_36_296 VGND VGND VPWR VPWR sky130_fd_sc_hd__decap_3
XFILLER_51_211 VGND VGND VPWR VPWR sky130_fd_sc_hd__fill_2
XFILLER_24_447 VGND VGND VPWR VPWR sky130_fd_sc_hd__decap_3
XFILLER_91_391 VGND VGND VPWR VPWR sky130_fd_sc_hd__fill_1
X_4966_ clkload7/A _4966_/D VGND VGND VPWR VPWR _4966_/Q sky130_fd_sc_hd__dfxtp_2
XFILLER_32_480 VGND VGND VPWR VPWR sky130_fd_sc_hd__fill_2
X_4897_ _5105_/CLK _4897_/D VGND VGND VPWR VPWR _4897_/Q sky130_fd_sc_hd__dfxtp_2
X_3917_ _3919_/S _3917_/B VGND VGND VPWR VPWR _3917_/X sky130_fd_sc_hd__or2_2
XTAP_TAPCELL_ROW_62_795 VGND VPWR sky130_fd_sc_hd__tapvpwrvgnd_1
XFILLER_22_26 VGND VGND VPWR VPWR sky130_fd_sc_hd__fill_2
X_3848_ _3848_/A _3848_/B VGND VGND VPWR VPWR _3848_/Y sky130_fd_sc_hd__nor2_2
X_3779_ _3779_/A _3779_/B _3779_/C VGND VGND VPWR VPWR _3780_/D sky130_fd_sc_hd__or3_2
XFILLER_59_300 VGND VGND VPWR VPWR sky130_fd_sc_hd__decap_3
Xclkbuf_leaf_20_CLK clkload2/A VGND VGND VPWR VPWR _5233_/CLK sky130_fd_sc_hd__clkbuf_8
XFILLER_59_355 VGND VGND VPWR VPWR sky130_fd_sc_hd__decap_3
XFILLER_86_141 VGND VGND VPWR VPWR sky130_fd_sc_hd__fill_1
XFILLER_86_130 VGND VGND VPWR VPWR sky130_fd_sc_hd__fill_2
XFILLER_47_517 VGND VGND VPWR VPWR sky130_fd_sc_hd__decap_3
XFILLER_74_347 VGND VGND VPWR VPWR sky130_fd_sc_hd__decap_3
XFILLER_55_550 VGND VGND VPWR VPWR sky130_fd_sc_hd__decap_3
XFILLER_74_358 VGND VGND VPWR VPWR sky130_fd_sc_hd__decap_3
XFILLER_15_414 VGND VGND VPWR VPWR sky130_fd_sc_hd__decap_3
XFILLER_27_274 VGND VGND VPWR VPWR sky130_fd_sc_hd__decap_3
XFILLER_63_11 VGND VGND VPWR VPWR sky130_fd_sc_hd__decap_3
XFILLER_15_458 VGND VGND VPWR VPWR sky130_fd_sc_hd__decap_3
XFILLER_63_44 VGND VGND VPWR VPWR sky130_fd_sc_hd__fill_2
XFILLER_63_66 VGND VGND VPWR VPWR sky130_fd_sc_hd__decap_3
XTAP_TAPCELL_ROW_25_442 VGND VPWR sky130_fd_sc_hd__tapvpwrvgnd_1
XFILLER_42_299 VGND VGND VPWR VPWR sky130_fd_sc_hd__decap_3
XFILLER_10_141 VGND VGND VPWR VPWR sky130_fd_sc_hd__decap_3
XFILLER_10_152 VGND VGND VPWR VPWR sky130_fd_sc_hd__fill_2
XFILLER_6_101 VGND VGND VPWR VPWR sky130_fd_sc_hd__decap_3
XFILLER_6_178 VGND VGND VPWR VPWR sky130_fd_sc_hd__decap_3
XFILLER_88_52 VGND VGND VPWR VPWR sky130_fd_sc_hd__decap_3
XFILLER_69_119 VGND VGND VPWR VPWR sky130_fd_sc_hd__decap_3
Xclkbuf_leaf_11_CLK clkload1/A VGND VGND VPWR VPWR _5286_/CLK sky130_fd_sc_hd__clkbuf_8
XFILLER_88_96 VGND VGND VPWR VPWR sky130_fd_sc_hd__decap_3
XPHY_EDGE_ROW_0_Left_94 VGND VGND VPWR VPWR sky130_fd_sc_hd__decap_3
XFILLER_19_6 VGND VGND VPWR VPWR sky130_fd_sc_hd__decap_3
XFILLER_65_325 VGND VGND VPWR VPWR sky130_fd_sc_hd__fill_1
XFILLER_65_358 VGND VGND VPWR VPWR sky130_fd_sc_hd__decap_3
XFILLER_33_200 VGND VGND VPWR VPWR sky130_fd_sc_hd__fill_2
X_4820_ _5168_/Q _4820_/B VGND VGND VPWR VPWR _4821_/B sky130_fd_sc_hd__or2_2
X_4751_ _4749_/Y _4750_/X _4854_/B VGND VGND VPWR VPWR _4751_/X sky130_fd_sc_hd__a21o_2
X_4682_ _4681_/X _4628_/B _4682_/S VGND VGND VPWR VPWR _4682_/X sky130_fd_sc_hd__mux2_1
X_3702_ _4200_/C _4155_/A VGND VGND VPWR VPWR _4199_/C sky130_fd_sc_hd__nor2_2
X_3633_ _4899_/Q _4883_/Q _5107_/Q _5091_/Q _3706_/S0 _3706_/S1 VGND VGND VPWR VPWR
+ _3634_/B sky130_fd_sc_hd__mux4_2
X_3564_ _5158_/Q _3567_/S _3562_/X VGND VGND VPWR VPWR _4071_/A sky130_fd_sc_hd__o21a_2
X_3495_ _5181_/Q _3891_/A _5182_/Q VGND VGND VPWR VPWR _4437_/A sky130_fd_sc_hd__or3b_2
X_2515_ _2510_/X _2511_/X _2514_/X _2433_/Y VGND VGND VPWR VPWR _4376_/B sky130_fd_sc_hd__a22o_2
X_5234_ _5257_/CLK _5234_/D VGND VGND VPWR VPWR _5234_/Q sky130_fd_sc_hd__dfxtp_2
X_2446_ _5187_/Q _5186_/Q _5184_/Q _5185_/Q VGND VGND VPWR VPWR _2887_/A sky130_fd_sc_hd__or4b_2
XFILLER_88_439 VGND VGND VPWR VPWR sky130_fd_sc_hd__decap_3
XFILLER_88_428 VGND VGND VPWR VPWR sky130_fd_sc_hd__decap_3
X_5165_ _5271_/CLK _5165_/D VGND VGND VPWR VPWR _5165_/Q sky130_fd_sc_hd__dfxtp_2
XFILLER_29_528 VGND VGND VPWR VPWR sky130_fd_sc_hd__decap_3
XFILLER_68_141 VGND VGND VPWR VPWR sky130_fd_sc_hd__decap_3
X_4116_ _4114_/Y _4115_/X _4213_/A VGND VGND VPWR VPWR _4116_/Y sky130_fd_sc_hd__a21oi_2
X_5096_ _5099_/CLK _5096_/D VGND VGND VPWR VPWR _5096_/Q sky130_fd_sc_hd__dfxtp_2
XFILLER_83_122 VGND VGND VPWR VPWR sky130_fd_sc_hd__fill_2
XFILLER_17_26 VGND VGND VPWR VPWR sky130_fd_sc_hd__fill_1
X_4047_ _3600_/A _4393_/C _4449_/S VGND VGND VPWR VPWR _4047_/X sky130_fd_sc_hd__mux2_1
XFILLER_12_439 VGND VGND VPWR VPWR sky130_fd_sc_hd__decap_3
X_4949_ clkload6/A _4949_/D VGND VGND VPWR VPWR _4949_/Q sky130_fd_sc_hd__dfxtp_2
XTAP_TAPCELL_ROW_22_412 VGND VPWR sky130_fd_sc_hd__tapvpwrvgnd_1
XFILLER_20_472 VGND VGND VPWR VPWR sky130_fd_sc_hd__decap_3
XFILLER_20_483 VGND VGND VPWR VPWR sky130_fd_sc_hd__decap_3
XPHY_EDGE_ROW_18_Left_112 VGND VGND VPWR VPWR sky130_fd_sc_hd__decap_3
XFILLER_58_77 VGND VGND VPWR VPWR sky130_fd_sc_hd__decap_3
XFILLER_58_88 VGND VGND VPWR VPWR sky130_fd_sc_hd__decap_3
XFILLER_87_461 VGND VGND VPWR VPWR sky130_fd_sc_hd__decap_3
XFILLER_47_325 VGND VGND VPWR VPWR sky130_fd_sc_hd__decap_3
XFILLER_87_483 VGND VGND VPWR VPWR sky130_fd_sc_hd__decap_3
XFILLER_74_21 VGND VGND VPWR VPWR sky130_fd_sc_hd__decap_3
XFILLER_74_32 VGND VGND VPWR VPWR sky130_fd_sc_hd__decap_3
XPHY_EDGE_ROW_27_Left_121 VGND VGND VPWR VPWR sky130_fd_sc_hd__decap_3
XFILLER_74_54 VGND VGND VPWR VPWR sky130_fd_sc_hd__fill_1
XFILLER_74_65 VGND VGND VPWR VPWR sky130_fd_sc_hd__decap_3
XFILLER_15_222 VGND VGND VPWR VPWR sky130_fd_sc_hd__fill_2
XFILLER_55_391 VGND VGND VPWR VPWR sky130_fd_sc_hd__fill_1
XFILLER_70_372 VGND VGND VPWR VPWR sky130_fd_sc_hd__decap_3
Xclkbuf_leaf_0_CLK clkbuf_leaf_5_CLK/A VGND VGND VPWR VPWR clkload3/A sky130_fd_sc_hd__clkbuf_8
XFILLER_90_64 VGND VGND VPWR VPWR sky130_fd_sc_hd__fill_1
XFILLER_88_9 VGND VGND VPWR VPWR sky130_fd_sc_hd__decap_3
XFILLER_11_461 VGND VGND VPWR VPWR sky130_fd_sc_hd__decap_3
XPHY_EDGE_ROW_36_Left_130 VGND VGND VPWR VPWR sky130_fd_sc_hd__decap_3
Xmax_cap129 _3065_/Y VGND VGND VPWR VPWR _3066_/B sky130_fd_sc_hd__buf_6
Xmax_cap118 _2902_/Y VGND VGND VPWR VPWR _2942_/A2 sky130_fd_sc_hd__buf_6
XFILLER_7_487 VGND VGND VPWR VPWR sky130_fd_sc_hd__decap_3
X_3280_ _5144_/Q _3274_/X _3279_/X _3338_/B VGND VGND VPWR VPWR _5144_/D sky130_fd_sc_hd__o211a_2
XFILLER_17_3 VGND VGND VPWR VPWR sky130_fd_sc_hd__decap_3
XFILLER_65_122 VGND VGND VPWR VPWR sky130_fd_sc_hd__fill_1
XFILLER_19_550 VGND VGND VPWR VPWR sky130_fd_sc_hd__decap_3
XTAP_TAPCELL_ROW_88_1034 VGND VPWR sky130_fd_sc_hd__tapvpwrvgnd_1
XFILLER_93_442 VGND VGND VPWR VPWR sky130_fd_sc_hd__decap_3
XFILLER_53_317 VGND VGND VPWR VPWR sky130_fd_sc_hd__decap_3
XTAP_TAPCELL_ROW_64_813 VGND VPWR sky130_fd_sc_hd__tapvpwrvgnd_1
XFILLER_93_486 VGND VGND VPWR VPWR sky130_fd_sc_hd__decap_3
XTAP_TAPCELL_ROW_36_548 VGND VPWR sky130_fd_sc_hd__tapvpwrvgnd_1
XFILLER_21_214 VGND VGND VPWR VPWR sky130_fd_sc_hd__decap_3
XFILLER_21_225 VGND VGND VPWR VPWR sky130_fd_sc_hd__decap_3
X_4803_ _4814_/A _4803_/B VGND VGND VPWR VPWR _4803_/Y sky130_fd_sc_hd__xnor2_2
XTAP_TAPCELL_ROW_72_890 VGND VPWR sky130_fd_sc_hd__tapvpwrvgnd_1
X_4734_ _4734_/A _4734_/B VGND VGND VPWR VPWR _4734_/X sky130_fd_sc_hd__or2_2
X_2995_ _2905_/X _2993_/B _2993_/Y _4920_/Q VGND VGND VPWR VPWR _4920_/D sky130_fd_sc_hd__a22o_2
X_4665_ _4692_/A _4665_/B VGND VGND VPWR VPWR _5239_/D sky130_fd_sc_hd__nor2_2
X_4596_ _4296_/X _4312_/Y _4437_/X _4589_/X _4106_/Y VGND VGND VPWR VPWR _4597_/C
+ sky130_fd_sc_hd__o221a_2
X_3616_ _3616_/A VGND VGND VPWR VPWR _4011_/A sky130_fd_sc_hd__inv_2
X_3547_ _3919_/S _3543_/X _4535_/A _3546_/Y VGND VGND VPWR VPWR _3547_/X sky130_fd_sc_hd__a22o_2
XFILLER_88_203 VGND VGND VPWR VPWR sky130_fd_sc_hd__decap_3
X_3478_ _3476_/Y _3478_/B VGND VGND VPWR VPWR _3479_/B sky130_fd_sc_hd__nand2b_2
X_5217_ _5233_/CLK _5217_/D VGND VGND VPWR VPWR _5217_/Q sky130_fd_sc_hd__dfxtp_2
X_2429_ _3705_/A VGND VGND VPWR VPWR _3693_/A sky130_fd_sc_hd__inv_2
XFILLER_28_47 VGND VGND VPWR VPWR sky130_fd_sc_hd__fill_2
XFILLER_56_122 VGND VGND VPWR VPWR sky130_fd_sc_hd__decap_3
XFILLER_69_483 VGND VGND VPWR VPWR sky130_fd_sc_hd__decap_3
X_5148_ _5270_/CLK _5148_/D VGND VGND VPWR VPWR _5148_/Q sky130_fd_sc_hd__dfxtp_2
XFILLER_29_369 VGND VGND VPWR VPWR sky130_fd_sc_hd__decap_3
XFILLER_56_144 VGND VGND VPWR VPWR sky130_fd_sc_hd__decap_3
X_5079_ _5083_/CLK _5079_/D VGND VGND VPWR VPWR _5079_/Q sky130_fd_sc_hd__dfxtp_2
XFILLER_44_328 VGND VGND VPWR VPWR sky130_fd_sc_hd__decap_3
XFILLER_84_486 VGND VGND VPWR VPWR sky130_fd_sc_hd__decap_3
XFILLER_25_520 VGND VGND VPWR VPWR sky130_fd_sc_hd__decap_3
XFILLER_25_531 VGND VGND VPWR VPWR sky130_fd_sc_hd__fill_1
XFILLER_37_380 VGND VGND VPWR VPWR sky130_fd_sc_hd__decap_3
XFILLER_40_501 VGND VGND VPWR VPWR sky130_fd_sc_hd__fill_1
XFILLER_52_350 VGND VGND VPWR VPWR sky130_fd_sc_hd__decap_3
XFILLER_71_169 VGND VGND VPWR VPWR sky130_fd_sc_hd__decap_3
XFILLER_12_214 VGND VGND VPWR VPWR sky130_fd_sc_hd__decap_3
XFILLER_40_512 VGND VGND VPWR VPWR sky130_fd_sc_hd__decap_3
XFILLER_40_556 VGND VGND VPWR VPWR sky130_fd_sc_hd__fill_2
XFILLER_69_43 VGND VGND VPWR VPWR sky130_fd_sc_hd__decap_3
XFILLER_69_76 VGND VGND VPWR VPWR sky130_fd_sc_hd__decap_3
XFILLER_47_111 VGND VGND VPWR VPWR sky130_fd_sc_hd__fill_1
XTAP_TAPCELL_ROW_78_938 VGND VPWR sky130_fd_sc_hd__tapvpwrvgnd_1
XFILLER_75_486 VGND VGND VPWR VPWR sky130_fd_sc_hd__decap_3
XFILLER_16_531 VGND VGND VPWR VPWR sky130_fd_sc_hd__fill_1
XFILLER_28_380 VGND VGND VPWR VPWR sky130_fd_sc_hd__decap_3
XFILLER_62_136 VGND VGND VPWR VPWR sky130_fd_sc_hd__decap_3
XFILLER_43_361 VGND VGND VPWR VPWR sky130_fd_sc_hd__decap_3
XTAP_TAPCELL_ROW_33_518 VGND VPWR sky130_fd_sc_hd__tapvpwrvgnd_1
XFILLER_86_6 VGND VGND VPWR VPWR sky130_fd_sc_hd__decap_3
X_2780_ _4958_/Q _4942_/Q _4926_/Q _4910_/Q _2818_/S0 _5136_/Q VGND VGND VPWR VPWR
+ _2781_/B sky130_fd_sc_hd__mux4_2
Xclkbuf_2_1__f_CLK clkbuf_0_CLK/X VGND VGND VPWR VPWR clkload0/A sky130_fd_sc_hd__clkbuf_16
XTAP_TAPCELL_ROW_41_595 VGND VPWR sky130_fd_sc_hd__tapvpwrvgnd_1
X_4450_ _4448_/X _4449_/X _4515_/B VGND VGND VPWR VPWR _4450_/X sky130_fd_sc_hd__mux2_1
XFILLER_7_251 VGND VGND VPWR VPWR sky130_fd_sc_hd__decap_3
X_4381_ _4296_/X _4304_/X _4317_/X _4345_/X _4380_/X VGND VGND VPWR VPWR _4381_/X
+ sky130_fd_sc_hd__o2111a_2
X_3401_ _3400_/A _3400_/B _3400_/C VGND VGND VPWR VPWR _3401_/X sky130_fd_sc_hd__a21o_2
X_3332_ _5283_/Q _3338_/B _3332_/C VGND VGND VPWR VPWR _3332_/X sky130_fd_sc_hd__and3_2
X_3263_ _5140_/Q _3315_/B _3258_/Y VGND VGND VPWR VPWR _3264_/C sky130_fd_sc_hd__or3b_2
XFILLER_38_111 VGND VGND VPWR VPWR sky130_fd_sc_hd__decap_3
X_5002_ clkload9/A _5002_/D VGND VGND VPWR VPWR _5002_/Q sky130_fd_sc_hd__dfxtp_2
X_3194_ _2897_/X _3193_/B _3193_/Y _5095_/Q VGND VGND VPWR VPWR _5095_/D sky130_fd_sc_hd__a22o_2
XFILLER_38_133 VGND VGND VPWR VPWR sky130_fd_sc_hd__decap_3
XFILLER_38_144 VGND VGND VPWR VPWR sky130_fd_sc_hd__decap_3
XFILLER_66_453 VGND VGND VPWR VPWR sky130_fd_sc_hd__decap_3
XFILLER_66_475 VGND VGND VPWR VPWR sky130_fd_sc_hd__fill_1
XFILLER_66_486 VGND VGND VPWR VPWR sky130_fd_sc_hd__decap_3
XFILLER_19_391 VGND VGND VPWR VPWR sky130_fd_sc_hd__fill_1
XFILLER_53_136 VGND VGND VPWR VPWR sky130_fd_sc_hd__decap_3
XFILLER_34_350 VGND VGND VPWR VPWR sky130_fd_sc_hd__decap_3
XFILLER_53_169 VGND VGND VPWR VPWR sky130_fd_sc_hd__decap_3
XFILLER_14_27 VGND VGND VPWR VPWR sky130_fd_sc_hd__fill_1
XFILLER_14_38 VGND VGND VPWR VPWR sky130_fd_sc_hd__decap_3
XFILLER_22_545 VGND VGND VPWR VPWR sky130_fd_sc_hd__decap_3
X_2978_ _2911_/X _2974_/B _2974_/Y _4906_/Q VGND VGND VPWR VPWR _4906_/D sky130_fd_sc_hd__a22o_2
X_4717_ _5253_/Q _4725_/B VGND VGND VPWR VPWR _4717_/X sky130_fd_sc_hd__or2_2
XFILLER_30_26 VGND VGND VPWR VPWR sky130_fd_sc_hd__fill_2
X_4648_ _4572_/S _4524_/A _4312_/Y _4647_/X VGND VGND VPWR VPWR _4648_/X sky130_fd_sc_hd__o31a_2
X_4579_ _4236_/A _2630_/B _4684_/B1 _3726_/A VGND VGND VPWR VPWR _4579_/Y sky130_fd_sc_hd__a22oi_2
XFILLER_1_449 VGND VGND VPWR VPWR sky130_fd_sc_hd__decap_3
XFILLER_76_239 VGND VGND VPWR VPWR sky130_fd_sc_hd__fill_2
XTAP_TAPCELL_ROW_4_243 VGND VPWR sky130_fd_sc_hd__tapvpwrvgnd_1
XFILLER_44_114 VGND VGND VPWR VPWR sky130_fd_sc_hd__decap_3
XFILLER_72_445 VGND VGND VPWR VPWR sky130_fd_sc_hd__decap_3
XFILLER_25_361 VGND VGND VPWR VPWR sky130_fd_sc_hd__decap_3
XFILLER_32_309 VGND VGND VPWR VPWR sky130_fd_sc_hd__decap_3
XFILLER_72_489 VGND VGND VPWR VPWR sky130_fd_sc_hd__decap_3
XFILLER_40_342 VGND VGND VPWR VPWR sky130_fd_sc_hd__decap_3
XFILLER_9_505 VGND VGND VPWR VPWR sky130_fd_sc_hd__fill_2
XFILLER_4_221 VGND VGND VPWR VPWR sky130_fd_sc_hd__decap_3
XFILLER_4_243 VGND VGND VPWR VPWR sky130_fd_sc_hd__decap_3
XFILLER_4_276 VGND VGND VPWR VPWR sky130_fd_sc_hd__fill_1
XFILLER_67_217 VGND VGND VPWR VPWR sky130_fd_sc_hd__decap_3
XFILLER_67_228 VGND VGND VPWR VPWR sky130_fd_sc_hd__decap_3
XFILLER_48_464 VGND VGND VPWR VPWR sky130_fd_sc_hd__decap_3
XFILLER_48_486 VGND VGND VPWR VPWR sky130_fd_sc_hd__decap_3
XFILLER_75_250 VGND VGND VPWR VPWR sky130_fd_sc_hd__decap_3
XFILLER_35_125 VGND VGND VPWR VPWR sky130_fd_sc_hd__decap_3
XFILLER_63_434 VGND VGND VPWR VPWR sky130_fd_sc_hd__decap_3
XTAP_TAPCELL_ROW_46_643 VGND VPWR sky130_fd_sc_hd__tapvpwrvgnd_1
X_3950_ _4684_/B1 _3784_/X _3915_/Y _4854_/B VGND VGND VPWR VPWR _3950_/X sky130_fd_sc_hd__a31o_2
XFILLER_90_253 VGND VGND VPWR VPWR sky130_fd_sc_hd__decap_3
X_2901_ _3192_/A _3138_/A VGND VGND VPWR VPWR _2902_/B sky130_fd_sc_hd__nor2_4
X_3881_ _3975_/S _3881_/B VGND VGND VPWR VPWR _4132_/B sky130_fd_sc_hd__or2_2
XFILLER_31_375 VGND VGND VPWR VPWR sky130_fd_sc_hd__decap_3
X_2832_ _2832_/A _2832_/B VGND VGND VPWR VPWR _2832_/X sky130_fd_sc_hd__or2_2
XFILLER_84_3 VGND VGND VPWR VPWR sky130_fd_sc_hd__decap_3
X_2763_ _5116_/Q _5004_/Q _4988_/Q _4972_/Q _2818_/S0 _5136_/Q VGND VGND VPWR VPWR
+ _2763_/X sky130_fd_sc_hd__mux4_2
X_4502_ _4502_/A _4502_/B VGND VGND VPWR VPWR _4502_/Y sky130_fd_sc_hd__nor2_2
X_2694_ _2693_/B _2518_/Y _2889_/C _2506_/Y _2495_/Y VGND VGND VPWR VPWR _4236_/B
+ sky130_fd_sc_hd__a311o_2
XFILLER_6_72 VGND VGND VPWR VPWR sky130_fd_sc_hd__decap_3
X_4433_ _4323_/Y _4432_/X _4321_/Y VGND VGND VPWR VPWR _4434_/B sky130_fd_sc_hd__a21oi_2
X_4364_ _4365_/A _4376_/A VGND VGND VPWR VPWR _4364_/Y sky130_fd_sc_hd__nor2_2
X_4295_ _4293_/Y _4483_/B _4515_/B VGND VGND VPWR VPWR _4524_/A sky130_fd_sc_hd__mux2_1
X_3315_ _5154_/Q _3315_/B VGND VGND VPWR VPWR _3315_/X sky130_fd_sc_hd__or2_2
XFILLER_86_515 VGND VGND VPWR VPWR sky130_fd_sc_hd__decap_3
X_3246_ _5171_/Q _3229_/Y _4870_/B1 _3245_/X VGND VGND VPWR VPWR _5134_/D sky130_fd_sc_hd__o22a_2
XFILLER_39_442 VGND VGND VPWR VPWR sky130_fd_sc_hd__decap_3
XFILLER_26_103 VGND VGND VPWR VPWR sky130_fd_sc_hd__fill_1
XFILLER_39_464 VGND VGND VPWR VPWR sky130_fd_sc_hd__decap_3
XFILLER_39_486 VGND VGND VPWR VPWR sky130_fd_sc_hd__decap_3
XFILLER_54_401 VGND VGND VPWR VPWR sky130_fd_sc_hd__decap_3
XFILLER_54_412 VGND VGND VPWR VPWR sky130_fd_sc_hd__fill_2
X_3177_ _2905_/X _3191_/A2 _3191_/B1 _5080_/Q VGND VGND VPWR VPWR _5080_/D sky130_fd_sc_hd__a22o_2
XTAP_TAPCELL_ROW_1_213 VGND VPWR sky130_fd_sc_hd__tapvpwrvgnd_1
XFILLER_66_283 VGND VGND VPWR VPWR sky130_fd_sc_hd__decap_3
XFILLER_14_309 VGND VGND VPWR VPWR sky130_fd_sc_hd__decap_3
XFILLER_26_169 VGND VGND VPWR VPWR sky130_fd_sc_hd__decap_3
XFILLER_54_467 VGND VGND VPWR VPWR sky130_fd_sc_hd__decap_3
XFILLER_81_264 VGND VGND VPWR VPWR sky130_fd_sc_hd__decap_3
XFILLER_81_242 VGND VGND VPWR VPWR sky130_fd_sc_hd__decap_3
XFILLER_25_48 VGND VGND VPWR VPWR sky130_fd_sc_hd__decap_3
XFILLER_41_106 VGND VGND VPWR VPWR sky130_fd_sc_hd__decap_3
XTAP_TAPCELL_ROW_80_966 VGND VPWR sky130_fd_sc_hd__tapvpwrvgnd_1
XFILLER_1_257 VGND VGND VPWR VPWR sky130_fd_sc_hd__decap_3
XFILLER_89_353 VGND VGND VPWR VPWR sky130_fd_sc_hd__fill_2
XFILLER_49_239 VGND VGND VPWR VPWR sky130_fd_sc_hd__decap_3
XFILLER_77_526 VGND VGND VPWR VPWR sky130_fd_sc_hd__decap_3
XFILLER_92_518 VGND VGND VPWR VPWR sky130_fd_sc_hd__decap_3
XFILLER_17_158 VGND VGND VPWR VPWR sky130_fd_sc_hd__decap_3
XFILLER_45_467 VGND VGND VPWR VPWR sky130_fd_sc_hd__decap_3
XFILLER_60_404 VGND VGND VPWR VPWR sky130_fd_sc_hd__decap_3
XFILLER_72_253 VGND VGND VPWR VPWR sky130_fd_sc_hd__decap_3
XFILLER_32_128 VGND VGND VPWR VPWR sky130_fd_sc_hd__fill_1
XTAP_TAPCELL_ROW_43_613 VGND VPWR sky130_fd_sc_hd__tapvpwrvgnd_1
XFILLER_82_43 VGND VGND VPWR VPWR sky130_fd_sc_hd__decap_3
XTAP_TAPCELL_ROW_15_348 VGND VPWR sky130_fd_sc_hd__tapvpwrvgnd_1
XFILLER_82_76 VGND VGND VPWR VPWR sky130_fd_sc_hd__decap_3
XFILLER_13_386 VGND VGND VPWR VPWR sky130_fd_sc_hd__decap_3
XFILLER_15_81 VGND VGND VPWR VPWR sky130_fd_sc_hd__decap_3
XTAP_TAPCELL_ROW_51_690 VGND VPWR sky130_fd_sc_hd__tapvpwrvgnd_1
XFILLER_31_91 VGND VGND VPWR VPWR sky130_fd_sc_hd__fill_1
XTAP_TAPCELL_ROW_91_1063 VGND VPWR sky130_fd_sc_hd__tapvpwrvgnd_1
Xoutput80 _2892_/X VGND VGND VPWR VPWR MEM_ADDR[13] sky130_fd_sc_hd__clkdlybuf4s25_1
Xoutput91 _2881_/Y VGND VGND VPWR VPWR MEM_ADDR[9] sky130_fd_sc_hd__clkdlybuf4s25_1
X_3100_ _2950_/X _3100_/A2 _3084_/Y _5014_/Q VGND VGND VPWR VPWR _5014_/D sky130_fd_sc_hd__a22o_2
X_4080_ _3825_/B _4449_/S _4079_/Y VGND VGND VPWR VPWR _4080_/Y sky130_fd_sc_hd__o21ai_2
XFILLER_48_250 VGND VGND VPWR VPWR sky130_fd_sc_hd__fill_2
X_3031_ _2905_/X _3029_/B _3029_/Y _4952_/Q VGND VGND VPWR VPWR _4952_/D sky130_fd_sc_hd__a22o_2
XFILLER_36_445 VGND VGND VPWR VPWR sky130_fd_sc_hd__decap_3
XFILLER_63_264 VGND VGND VPWR VPWR sky130_fd_sc_hd__decap_3
XFILLER_23_128 VGND VGND VPWR VPWR sky130_fd_sc_hd__decap_3
XFILLER_36_489 VGND VGND VPWR VPWR sky130_fd_sc_hd__decap_3
XFILLER_51_415 VGND VGND VPWR VPWR sky130_fd_sc_hd__fill_1
X_4982_ clkload8/A _4982_/D VGND VGND VPWR VPWR _4982_/Q sky130_fd_sc_hd__dfxtp_2
X_3933_ _3888_/A _3892_/A _3619_/B VGND VGND VPWR VPWR _3934_/B sky130_fd_sc_hd__o21ai_2
XFILLER_31_150 VGND VGND VPWR VPWR sky130_fd_sc_hd__decap_3
X_3864_ _4025_/B VGND VGND VPWR VPWR _3864_/Y sky130_fd_sc_hd__inv_2
XFILLER_31_172 VGND VGND VPWR VPWR sky130_fd_sc_hd__decap_3
X_2815_ _5137_/Q _2815_/B VGND VGND VPWR VPWR _2815_/X sky130_fd_sc_hd__or2_2
X_3795_ _4286_/A _4320_/A VGND VGND VPWR VPWR _3795_/X sky130_fd_sc_hd__and2b_2
X_2746_ _4954_/Q _4938_/Q _4922_/Q _4906_/Q _2854_/S0 _2854_/S1 VGND VGND VPWR VPWR
+ _2746_/X sky130_fd_sc_hd__mux4_2
X_2677_ _2675_/X _2676_/X _2677_/S VGND VGND VPWR VPWR _2677_/X sky130_fd_sc_hd__mux2_1
X_4416_ _4416_/A _4416_/B _4416_/C VGND VGND VPWR VPWR _4416_/X sky130_fd_sc_hd__and3_2
XFILLER_59_515 VGND VGND VPWR VPWR sky130_fd_sc_hd__fill_2
XFILLER_59_526 VGND VGND VPWR VPWR sky130_fd_sc_hd__decap_3
X_4347_ _4393_/B _4393_/C VGND VGND VPWR VPWR _4348_/B sky130_fd_sc_hd__xor2_2
XFILLER_86_312 VGND VGND VPWR VPWR sky130_fd_sc_hd__decap_3
X_4278_ _4854_/B _4278_/B VGND VGND VPWR VPWR _4278_/X sky130_fd_sc_hd__or2_2
XFILLER_74_518 VGND VGND VPWR VPWR sky130_fd_sc_hd__fill_2
XFILLER_74_529 VGND VGND VPWR VPWR sky130_fd_sc_hd__decap_3
X_3229_ _4275_/B _3229_/B VGND VGND VPWR VPWR _3229_/Y sky130_fd_sc_hd__nor2_4
XFILLER_86_389 VGND VGND VPWR VPWR sky130_fd_sc_hd__decap_3
XFILLER_27_434 VGND VGND VPWR VPWR sky130_fd_sc_hd__decap_3
XFILLER_36_25 VGND VGND VPWR VPWR sky130_fd_sc_hd__decap_3
XFILLER_36_47 VGND VGND VPWR VPWR sky130_fd_sc_hd__decap_3
XFILLER_54_253 VGND VGND VPWR VPWR sky130_fd_sc_hd__decap_3
XFILLER_82_551 VGND VGND VPWR VPWR sky130_fd_sc_hd__decap_3
XFILLER_42_448 VGND VGND VPWR VPWR sky130_fd_sc_hd__decap_3
XFILLER_22_150 VGND VGND VPWR VPWR sky130_fd_sc_hd__decap_3
XTAP_TAPCELL_ROW_12_318 VGND VPWR sky130_fd_sc_hd__tapvpwrvgnd_1
XFILLER_10_312 VGND VGND VPWR VPWR sky130_fd_sc_hd__fill_2
XFILLER_22_194 VGND VGND VPWR VPWR sky130_fd_sc_hd__fill_2
XFILLER_52_79 VGND VGND VPWR VPWR sky130_fd_sc_hd__decap_3
XTAP_TAPCELL_ROW_20_395 VGND VPWR sky130_fd_sc_hd__tapvpwrvgnd_1
XFILLER_2_500 VGND VGND VPWR VPWR sky130_fd_sc_hd__decap_3
XFILLER_2_533 VGND VGND VPWR VPWR sky130_fd_sc_hd__decap_3
XFILLER_89_172 VGND VGND VPWR VPWR sky130_fd_sc_hd__decap_3
XFILLER_77_323 VGND VGND VPWR VPWR sky130_fd_sc_hd__decap_3
XFILLER_92_315 VGND VGND VPWR VPWR sky130_fd_sc_hd__decap_3
XFILLER_92_304 VGND VGND VPWR VPWR sky130_fd_sc_hd__decap_3
XFILLER_93_75 VGND VGND VPWR VPWR sky130_fd_sc_hd__decap_3
XFILLER_93_53 VGND VGND VPWR VPWR sky130_fd_sc_hd__decap_3
XFILLER_18_489 VGND VGND VPWR VPWR sky130_fd_sc_hd__decap_3
XFILLER_33_426 VGND VGND VPWR VPWR sky130_fd_sc_hd__decap_3
XFILLER_93_97 VGND VGND VPWR VPWR sky130_fd_sc_hd__decap_3
XFILLER_26_80 VGND VGND VPWR VPWR sky130_fd_sc_hd__decap_3
XFILLER_60_223 VGND VGND VPWR VPWR sky130_fd_sc_hd__decap_3
XFILLER_60_256 VGND VGND VPWR VPWR sky130_fd_sc_hd__decap_3
XFILLER_41_470 VGND VGND VPWR VPWR sky130_fd_sc_hd__decap_3
X_3580_ _4397_/D _4397_/C _3874_/S VGND VGND VPWR VPWR _3580_/X sky130_fd_sc_hd__mux2_1
X_2600_ _4732_/A _4320_/A VGND VGND VPWR VPWR _4413_/S sky130_fd_sc_hd__nor2_2
XFILLER_9_187 VGND VGND VPWR VPWR sky130_fd_sc_hd__decap_3
X_2531_ _5163_/Q _3825_/B VGND VGND VPWR VPWR _2531_/Y sky130_fd_sc_hd__nand2_2
X_5250_ _5254_/CLK _5250_/D VGND VGND VPWR VPWR _5250_/Q sky130_fd_sc_hd__dfxtp_2
X_4201_ _4631_/S _3689_/X _4200_/X _3677_/B VGND VGND VPWR VPWR _4201_/X sky130_fd_sc_hd__o211a_2
X_2462_ _5187_/Q _5185_/Q _5184_/Q _5186_/Q VGND VGND VPWR VPWR _2463_/B sky130_fd_sc_hd__nor4b_4
XFILLER_87_109 VGND VGND VPWR VPWR sky130_fd_sc_hd__decap_3
XFILLER_68_312 VGND VGND VPWR VPWR sky130_fd_sc_hd__decap_3
X_5181_ _5253_/CLK _5181_/D VGND VGND VPWR VPWR _5181_/Q sky130_fd_sc_hd__dfxtp_2
X_4132_ _4267_/S _4132_/B _4224_/B VGND VGND VPWR VPWR _4132_/X sky130_fd_sc_hd__or3_2
XFILLER_3_95 VGND VGND VPWR VPWR sky130_fd_sc_hd__decap_3
X_4063_ _4062_/B _4062_/C _4062_/A VGND VGND VPWR VPWR _4063_/Y sky130_fd_sc_hd__a21oi_2
X_3014_ _2908_/X _3011_/B _3011_/Y _4937_/Q VGND VGND VPWR VPWR _4937_/D sky130_fd_sc_hd__a22o_2
XFILLER_83_326 VGND VGND VPWR VPWR sky130_fd_sc_hd__decap_3
XFILLER_36_253 VGND VGND VPWR VPWR sky130_fd_sc_hd__decap_3
XFILLER_64_551 VGND VGND VPWR VPWR sky130_fd_sc_hd__decap_3
XTAP_TAPCELL_ROW_54_719 VGND VPWR sky130_fd_sc_hd__tapvpwrvgnd_1
XFILLER_24_459 VGND VGND VPWR VPWR sky130_fd_sc_hd__decap_3
X_4965_ clkload6/A _4965_/D VGND VGND VPWR VPWR _4965_/Q sky130_fd_sc_hd__dfxtp_2
X_3916_ _3536_/X _3539_/Y _3919_/S VGND VGND VPWR VPWR _3916_/X sky130_fd_sc_hd__mux2_1
X_4896_ _5103_/CLK _4896_/D VGND VGND VPWR VPWR _4896_/Q sky130_fd_sc_hd__dfxtp_2
X_3847_ _3848_/B VGND VGND VPWR VPWR _3847_/Y sky130_fd_sc_hd__inv_2
X_3778_ _3848_/A _3778_/B _3958_/A _3778_/D VGND VGND VPWR VPWR _3780_/C sky130_fd_sc_hd__or4_2
XFILLER_3_308 VGND VGND VPWR VPWR sky130_fd_sc_hd__fill_2
X_2729_ _2832_/A _2728_/X _2435_/Y VGND VGND VPWR VPWR _2729_/X sky130_fd_sc_hd__o21a_2
XFILLER_0_9 VGND VGND VPWR VPWR sky130_fd_sc_hd__decap_3
XFILLER_59_323 VGND VGND VPWR VPWR sky130_fd_sc_hd__decap_3
XFILLER_59_367 VGND VGND VPWR VPWR sky130_fd_sc_hd__decap_3
XFILLER_86_153 VGND VGND VPWR VPWR sky130_fd_sc_hd__decap_3
XPHY_EDGE_ROW_29_Right_29 VGND VGND VPWR VPWR sky130_fd_sc_hd__decap_3
XFILLER_86_197 VGND VGND VPWR VPWR sky130_fd_sc_hd__decap_3
XFILLER_86_186 VGND VGND VPWR VPWR sky130_fd_sc_hd__fill_1
XFILLER_27_220 VGND VGND VPWR VPWR sky130_fd_sc_hd__decap_3
XFILLER_27_253 VGND VGND VPWR VPWR sky130_fd_sc_hd__decap_3
XFILLER_82_392 VGND VGND VPWR VPWR sky130_fd_sc_hd__decap_3
XFILLER_30_407 VGND VGND VPWR VPWR sky130_fd_sc_hd__decap_3
XFILLER_63_78 VGND VGND VPWR VPWR sky130_fd_sc_hd__decap_3
XTAP_TAPCELL_ROW_25_443 VGND VPWR sky130_fd_sc_hd__tapvpwrvgnd_1
XFILLER_8_29 VGND VGND VPWR VPWR sky130_fd_sc_hd__fill_2
XFILLER_8_18 VGND VGND VPWR VPWR sky130_fd_sc_hd__decap_3
XPHY_EDGE_ROW_38_Right_38 VGND VGND VPWR VPWR sky130_fd_sc_hd__decap_3
XFILLER_10_186 VGND VGND VPWR VPWR sky130_fd_sc_hd__decap_3
XFILLER_2_352 VGND VGND VPWR VPWR sky130_fd_sc_hd__decap_3
XFILLER_77_131 VGND VGND VPWR VPWR sky130_fd_sc_hd__decap_3
XFILLER_38_518 VGND VGND VPWR VPWR sky130_fd_sc_hd__decap_3
XPHY_EDGE_ROW_47_Right_47 VGND VGND VPWR VPWR sky130_fd_sc_hd__decap_3
XFILLER_77_153 VGND VGND VPWR VPWR sky130_fd_sc_hd__decap_3
XFILLER_65_337 VGND VGND VPWR VPWR sky130_fd_sc_hd__decap_3
XFILLER_92_112 VGND VGND VPWR VPWR sky130_fd_sc_hd__decap_3
XFILLER_77_175 VGND VGND VPWR VPWR sky130_fd_sc_hd__decap_3
XFILLER_18_253 VGND VGND VPWR VPWR sky130_fd_sc_hd__decap_3
XFILLER_73_370 VGND VGND VPWR VPWR sky130_fd_sc_hd__decap_3
XFILLER_80_318 VGND VGND VPWR VPWR sky130_fd_sc_hd__fill_1
XFILLER_18_297 VGND VGND VPWR VPWR sky130_fd_sc_hd__decap_3
XFILLER_61_532 VGND VGND VPWR VPWR sky130_fd_sc_hd__decap_3
XFILLER_61_554 VGND VGND VPWR VPWR sky130_fd_sc_hd__decap_3
XFILLER_73_381 VGND VGND VPWR VPWR sky130_fd_sc_hd__decap_3
X_4750_ _4750_/A _4750_/B VGND VGND VPWR VPWR _4750_/X sky130_fd_sc_hd__or2_2
XPHY_EDGE_ROW_56_Right_56 VGND VGND VPWR VPWR sky130_fd_sc_hd__decap_3
X_4681_ _4680_/Y _4653_/Y _4681_/S VGND VGND VPWR VPWR _4681_/X sky130_fd_sc_hd__mux2_1
X_3701_ _3701_/A _3785_/B VGND VGND VPWR VPWR _4155_/A sky130_fd_sc_hd__and2_2
X_3632_ _3666_/A VGND VGND VPWR VPWR _4212_/A sky130_fd_sc_hd__inv_2
X_3563_ _5158_/Q _3567_/S _3562_/X VGND VGND VPWR VPWR _4044_/S sky130_fd_sc_hd__o21ai_2
X_3494_ _3494_/A _3494_/B VGND VGND VPWR VPWR _5209_/D sky130_fd_sc_hd__nor2_2
X_2514_ _2512_/X _2513_/X _2677_/S VGND VGND VPWR VPWR _2514_/X sky130_fd_sc_hd__mux2_1
X_5233_ _5233_/CLK _5233_/D VGND VGND VPWR VPWR _5233_/Q sky130_fd_sc_hd__dfxtp_2
X_2445_ _5184_/Q _2463_/A _5185_/Q VGND VGND VPWR VPWR _2894_/A sky130_fd_sc_hd__and3b_2
XPHY_EDGE_ROW_65_Right_65 VGND VGND VPWR VPWR sky130_fd_sc_hd__decap_3
XFILLER_68_120 VGND VGND VPWR VPWR sky130_fd_sc_hd__decap_3
XFILLER_68_131 VGND VGND VPWR VPWR sky130_fd_sc_hd__decap_3
X_5164_ _5271_/CLK _5164_/D VGND VGND VPWR VPWR _5164_/Q sky130_fd_sc_hd__dfxtp_2
XFILLER_68_153 VGND VGND VPWR VPWR sky130_fd_sc_hd__decap_3
X_4115_ _4199_/D _4115_/B VGND VGND VPWR VPWR _4115_/X sky130_fd_sc_hd__or2_2
XFILLER_68_197 VGND VGND VPWR VPWR sky130_fd_sc_hd__decap_3
X_5095_ _5105_/CLK _5095_/D VGND VGND VPWR VPWR _5095_/Q sky130_fd_sc_hd__dfxtp_2
XFILLER_56_348 VGND VGND VPWR VPWR sky130_fd_sc_hd__decap_3
X_4046_ _4070_/A _4044_/X _4045_/X _3963_/A VGND VGND VPWR VPWR _4055_/B sky130_fd_sc_hd__a22oi_2
XTAP_TAPCELL_ROW_39_568 VGND VPWR sky130_fd_sc_hd__tapvpwrvgnd_1
XFILLER_71_318 VGND VGND VPWR VPWR sky130_fd_sc_hd__decap_3
XFILLER_83_178 VGND VGND VPWR VPWR sky130_fd_sc_hd__decap_3
XFILLER_83_167 VGND VGND VPWR VPWR sky130_fd_sc_hd__fill_1
XFILLER_52_554 VGND VGND VPWR VPWR sky130_fd_sc_hd__decap_3
XFILLER_64_392 VGND VGND VPWR VPWR sky130_fd_sc_hd__decap_3
XPHY_EDGE_ROW_74_Right_74 VGND VGND VPWR VPWR sky130_fd_sc_hd__decap_3
XFILLER_24_289 VGND VGND VPWR VPWR sky130_fd_sc_hd__decap_3
X_4948_ _5008_/CLK _4948_/D VGND VGND VPWR VPWR _4948_/Q sky130_fd_sc_hd__dfxtp_2
XTAP_TAPCELL_ROW_22_413 VGND VPWR sky130_fd_sc_hd__tapvpwrvgnd_1
X_4879_ _5215_/CLK _4879_/D VGND VGND VPWR VPWR _4879_/Q sky130_fd_sc_hd__dfxtp_2
XFILLER_20_495 VGND VGND VPWR VPWR sky130_fd_sc_hd__decap_3
XTAP_TAPCELL_ROW_30_490 VGND VPWR sky130_fd_sc_hd__tapvpwrvgnd_1
XPHY_EDGE_ROW_83_Right_83 VGND VGND VPWR VPWR sky130_fd_sc_hd__decap_3
XFILLER_79_407 VGND VGND VPWR VPWR sky130_fd_sc_hd__fill_2
XFILLER_79_429 VGND VGND VPWR VPWR sky130_fd_sc_hd__decap_3
XFILLER_47_304 VGND VGND VPWR VPWR sky130_fd_sc_hd__decap_3
XFILLER_59_153 VGND VGND VPWR VPWR sky130_fd_sc_hd__decap_3
XFILLER_59_175 VGND VGND VPWR VPWR sky130_fd_sc_hd__decap_3
XFILLER_74_112 VGND VGND VPWR VPWR sky130_fd_sc_hd__decap_3
XFILLER_87_495 VGND VGND VPWR VPWR sky130_fd_sc_hd__decap_3
XFILLER_28_551 VGND VGND VPWR VPWR sky130_fd_sc_hd__decap_3
XFILLER_74_156 VGND VGND VPWR VPWR sky130_fd_sc_hd__fill_2
XFILLER_15_201 VGND VGND VPWR VPWR sky130_fd_sc_hd__decap_3
XFILLER_55_370 VGND VGND VPWR VPWR sky130_fd_sc_hd__decap_3
XFILLER_62_318 VGND VGND VPWR VPWR sky130_fd_sc_hd__decap_3
XFILLER_74_44 VGND VGND VPWR VPWR sky130_fd_sc_hd__decap_3
XFILLER_74_77 VGND VGND VPWR VPWR sky130_fd_sc_hd__decap_3
XFILLER_15_234 VGND VGND VPWR VPWR sky130_fd_sc_hd__decap_3
XFILLER_74_88 VGND VGND VPWR VPWR sky130_fd_sc_hd__decap_3
XPHY_EDGE_ROW_92_Right_92 VGND VGND VPWR VPWR sky130_fd_sc_hd__decap_3
XFILLER_70_340 VGND VGND VPWR VPWR sky130_fd_sc_hd__decap_3
XFILLER_15_289 VGND VGND VPWR VPWR sky130_fd_sc_hd__decap_3
XFILLER_70_384 VGND VGND VPWR VPWR sky130_fd_sc_hd__decap_3
XFILLER_30_248 VGND VGND VPWR VPWR sky130_fd_sc_hd__decap_3
Xmax_cap108 _3230_/Y VGND VGND VPWR VPWR _4870_/B1 sky130_fd_sc_hd__buf_6
XFILLER_7_466 VGND VGND VPWR VPWR sky130_fd_sc_hd__decap_3
Xmax_cap119 _3975_/S VGND VGND VPWR VPWR _4266_/S sky130_fd_sc_hd__buf_4
XFILLER_31_6 VGND VGND VPWR VPWR sky130_fd_sc_hd__decap_3
XFILLER_78_451 VGND VGND VPWR VPWR sky130_fd_sc_hd__decap_3
XFILLER_38_315 VGND VGND VPWR VPWR sky130_fd_sc_hd__decap_3
XFILLER_65_101 VGND VGND VPWR VPWR sky130_fd_sc_hd__decap_3
XFILLER_93_421 VGND VGND VPWR VPWR sky130_fd_sc_hd__decap_3
XFILLER_78_495 VGND VGND VPWR VPWR sky130_fd_sc_hd__decap_3
XFILLER_38_348 VGND VGND VPWR VPWR sky130_fd_sc_hd__decap_3
XFILLER_65_145 VGND VGND VPWR VPWR sky130_fd_sc_hd__decap_3
XTAP_TAPCELL_ROW_88_1035 VGND VPWR sky130_fd_sc_hd__tapvpwrvgnd_1
XFILLER_53_329 VGND VGND VPWR VPWR sky130_fd_sc_hd__decap_3
XFILLER_65_178 VGND VGND VPWR VPWR sky130_fd_sc_hd__decap_3
XTAP_TAPCELL_ROW_64_814 VGND VPWR sky130_fd_sc_hd__tapvpwrvgnd_1
XFILLER_93_498 VGND VGND VPWR VPWR sky130_fd_sc_hd__decap_3
XFILLER_0_63 VGND VGND VPWR VPWR sky130_fd_sc_hd__decap_3
XFILLER_0_85 VGND VGND VPWR VPWR sky130_fd_sc_hd__decap_3
XFILLER_34_521 VGND VGND VPWR VPWR sky130_fd_sc_hd__fill_2
XFILLER_46_392 VGND VGND VPWR VPWR sky130_fd_sc_hd__fill_2
XFILLER_80_126 VGND VGND VPWR VPWR sky130_fd_sc_hd__decap_3
XFILLER_61_340 VGND VGND VPWR VPWR sky130_fd_sc_hd__decap_3
XFILLER_61_362 VGND VGND VPWR VPWR sky130_fd_sc_hd__decap_3
X_4802_ _4793_/B _4795_/B _4793_/A VGND VGND VPWR VPWR _4803_/B sky130_fd_sc_hd__a21bo_2
X_2994_ _2897_/X _2992_/Y _2993_/Y _4919_/Q VGND VGND VPWR VPWR _4919_/D sky130_fd_sc_hd__a22o_2
X_4733_ _4734_/A _4734_/B VGND VGND VPWR VPWR _4733_/Y sky130_fd_sc_hd__nand2_2
X_4664_ _5239_/Q _4854_/B _4541_/X _4663_/X VGND VGND VPWR VPWR _4665_/B sky130_fd_sc_hd__o2bb2a_2
X_4595_ _4666_/A _4595_/B _4595_/C VGND VGND VPWR VPWR _4597_/B sky130_fd_sc_hd__or3_2
X_3615_ _4529_/S _3615_/B VGND VGND VPWR VPWR _3616_/A sky130_fd_sc_hd__or2_2
X_3546_ _4320_/A _3866_/B _3919_/S VGND VGND VPWR VPWR _3546_/Y sky130_fd_sc_hd__a21oi_2
XFILLER_0_119 VGND VGND VPWR VPWR sky130_fd_sc_hd__decap_3
X_5216_ _5216_/CLK _5216_/D VGND VGND VPWR VPWR _5216_/Q sky130_fd_sc_hd__dfxtp_2
X_3477_ _5169_/Q _5150_/Q VGND VGND VPWR VPWR _3478_/B sky130_fd_sc_hd__nand2_2
X_2428_ _3884_/D VGND VGND VPWR VPWR _3891_/A sky130_fd_sc_hd__inv_2
XFILLER_29_326 VGND VGND VPWR VPWR sky130_fd_sc_hd__fill_1
XFILLER_29_337 VGND VGND VPWR VPWR sky130_fd_sc_hd__decap_3
X_5147_ _5270_/CLK _5147_/D VGND VGND VPWR VPWR _5147_/Q sky130_fd_sc_hd__dfxtp_2
XFILLER_56_156 VGND VGND VPWR VPWR sky130_fd_sc_hd__fill_1
X_5078_ _5102_/CLK _5078_/D VGND VGND VPWR VPWR _5078_/Q sky130_fd_sc_hd__dfxtp_2
XFILLER_84_454 VGND VGND VPWR VPWR sky130_fd_sc_hd__decap_3
XFILLER_56_189 VGND VGND VPWR VPWR sky130_fd_sc_hd__decap_3
X_4029_ _4028_/Y _3974_/X _4266_/S VGND VGND VPWR VPWR _4029_/X sky130_fd_sc_hd__mux2_1
XFILLER_4_414 VGND VGND VPWR VPWR sky130_fd_sc_hd__decap_3
XFILLER_79_215 VGND VGND VPWR VPWR sky130_fd_sc_hd__decap_3
XFILLER_69_88 VGND VGND VPWR VPWR sky130_fd_sc_hd__decap_3
XFILLER_75_410 VGND VGND VPWR VPWR sky130_fd_sc_hd__fill_2
XFILLER_75_421 VGND VGND VPWR VPWR sky130_fd_sc_hd__decap_3
XTAP_TAPCELL_ROW_78_939 VGND VPWR sky130_fd_sc_hd__tapvpwrvgnd_1
XFILLER_87_270 VGND VGND VPWR VPWR sky130_fd_sc_hd__decap_3
XFILLER_75_465 VGND VGND VPWR VPWR sky130_fd_sc_hd__decap_3
XFILLER_75_498 VGND VGND VPWR VPWR sky130_fd_sc_hd__decap_3
XFILLER_28_392 VGND VGND VPWR VPWR sky130_fd_sc_hd__decap_3
XFILLER_31_502 VGND VGND VPWR VPWR sky130_fd_sc_hd__fill_2
XFILLER_43_340 VGND VGND VPWR VPWR sky130_fd_sc_hd__decap_3
XFILLER_43_373 VGND VGND VPWR VPWR sky130_fd_sc_hd__decap_3
XFILLER_70_181 VGND VGND VPWR VPWR sky130_fd_sc_hd__decap_3
XTAP_TAPCELL_ROW_33_519 VGND VPWR sky130_fd_sc_hd__tapvpwrvgnd_1
XFILLER_11_281 VGND VGND VPWR VPWR sky130_fd_sc_hd__decap_3
XFILLER_79_6 VGND VGND VPWR VPWR sky130_fd_sc_hd__fill_2
X_4380_ _4397_/C _4375_/X _4379_/X _3782_/A _4338_/X VGND VGND VPWR VPWR _4380_/X
+ sky130_fd_sc_hd__o311a_2
X_3400_ _3400_/A _3400_/B _3400_/C VGND VGND VPWR VPWR _3402_/B sky130_fd_sc_hd__and3_2
X_3331_ _5163_/Q _3230_/B _3230_/Y _3330_/X VGND VGND VPWR VPWR _5163_/D sky130_fd_sc_hd__o22a_2
X_3262_ _3315_/B _3267_/B _5261_/Q _5189_/Q VGND VGND VPWR VPWR _3264_/B sky130_fd_sc_hd__a2bb2o_2
X_5001_ clkload3/A _5001_/D VGND VGND VPWR VPWR _5001_/Q sky130_fd_sc_hd__dfxtp_2
X_3193_ _3494_/A _3193_/B VGND VGND VPWR VPWR _3193_/Y sky130_fd_sc_hd__nor2_4
XFILLER_85_218 VGND VGND VPWR VPWR sky130_fd_sc_hd__fill_1
XFILLER_38_123 VGND VGND VPWR VPWR sky130_fd_sc_hd__fill_2
XFILLER_66_432 VGND VGND VPWR VPWR sky130_fd_sc_hd__decap_3
XFILLER_26_329 VGND VGND VPWR VPWR sky130_fd_sc_hd__decap_3
XTAP_TAPCELL_ROW_49_663 VGND VPWR sky130_fd_sc_hd__tapvpwrvgnd_1
XFILLER_81_402 VGND VGND VPWR VPWR sky130_fd_sc_hd__decap_3
XFILLER_81_446 VGND VGND VPWR VPWR sky130_fd_sc_hd__fill_2
XFILLER_53_159 VGND VGND VPWR VPWR sky130_fd_sc_hd__fill_1
XFILLER_34_362 VGND VGND VPWR VPWR sky130_fd_sc_hd__fill_2
XFILLER_34_395 VGND VGND VPWR VPWR sky130_fd_sc_hd__decap_3
XFILLER_22_557 VGND VGND VPWR VPWR sky130_fd_sc_hd__fill_1
XFILLER_61_181 VGND VGND VPWR VPWR sky130_fd_sc_hd__decap_3
X_2977_ _2908_/X _2974_/B _2974_/Y _4905_/Q VGND VGND VPWR VPWR _4905_/D sky130_fd_sc_hd__a22o_2
X_4716_ input34/X _4694_/Y _4715_/X _3366_/A VGND VGND VPWR VPWR _5252_/D sky130_fd_sc_hd__o211a_2
X_4647_ _4647_/A _4647_/B _4647_/C VGND VGND VPWR VPWR _4647_/X sky130_fd_sc_hd__and3_2
X_4578_ _4578_/A VGND VGND VPWR VPWR _4578_/Y sky130_fd_sc_hd__inv_2
X_3529_ _5111_/Q _4999_/Q _4983_/Q _4967_/Q _3732_/S0 _3732_/S1 VGND VGND VPWR VPWR
+ _3529_/X sky130_fd_sc_hd__mux4_2
XPHY_EDGE_ROW_55_Left_149 VGND VGND VPWR VPWR sky130_fd_sc_hd__decap_3
XFILLER_29_145 VGND VGND VPWR VPWR sky130_fd_sc_hd__decap_3
XFILLER_57_432 VGND VGND VPWR VPWR sky130_fd_sc_hd__decap_3
XFILLER_69_281 VGND VGND VPWR VPWR sky130_fd_sc_hd__decap_3
XTAP_TAPCELL_ROW_4_244 VGND VPWR sky130_fd_sc_hd__tapvpwrvgnd_1
XFILLER_55_46 VGND VGND VPWR VPWR sky130_fd_sc_hd__decap_3
XFILLER_72_424 VGND VGND VPWR VPWR sky130_fd_sc_hd__fill_1
XFILLER_84_284 VGND VGND VPWR VPWR sky130_fd_sc_hd__decap_3
XFILLER_72_457 VGND VGND VPWR VPWR sky130_fd_sc_hd__decap_3
XTAP_TAPCELL_ROW_83_986 VGND VPWR sky130_fd_sc_hd__tapvpwrvgnd_1
XFILLER_13_524 VGND VGND VPWR VPWR sky130_fd_sc_hd__fill_2
XFILLER_25_384 VGND VGND VPWR VPWR sky130_fd_sc_hd__fill_1
XPHY_EDGE_ROW_64_Left_158 VGND VGND VPWR VPWR sky130_fd_sc_hd__decap_3
XFILLER_13_546 VGND VGND VPWR VPWR sky130_fd_sc_hd__decap_3
XFILLER_71_45 VGND VGND VPWR VPWR sky130_fd_sc_hd__decap_3
XFILLER_9_517 VGND VGND VPWR VPWR sky130_fd_sc_hd__fill_1
XFILLER_40_398 VGND VGND VPWR VPWR sky130_fd_sc_hd__decap_3
XFILLER_4_200 VGND VGND VPWR VPWR sky130_fd_sc_hd__decap_3
XPHY_EDGE_ROW_73_Left_167 VGND VGND VPWR VPWR sky130_fd_sc_hd__decap_3
XFILLER_20_71 VGND VGND VPWR VPWR sky130_fd_sc_hd__decap_3
XFILLER_0_494 VGND VGND VPWR VPWR sky130_fd_sc_hd__decap_3
XFILLER_48_421 VGND VGND VPWR VPWR sky130_fd_sc_hd__decap_3
XFILLER_48_432 VGND VGND VPWR VPWR sky130_fd_sc_hd__decap_3
XFILLER_75_262 VGND VGND VPWR VPWR sky130_fd_sc_hd__fill_1
XTAP_TAPCELL_ROW_85_1005 VGND VPWR sky130_fd_sc_hd__tapvpwrvgnd_1
XFILLER_48_498 VGND VGND VPWR VPWR sky130_fd_sc_hd__decap_3
XFILLER_75_284 VGND VGND VPWR VPWR sky130_fd_sc_hd__decap_3
XPHY_EDGE_ROW_82_Left_176 VGND VGND VPWR VPWR sky130_fd_sc_hd__decap_3
XFILLER_16_351 VGND VGND VPWR VPWR sky130_fd_sc_hd__decap_3
XFILLER_63_479 VGND VGND VPWR VPWR sky130_fd_sc_hd__decap_3
X_2900_ _5191_/Q _5190_/Q VGND VGND VPWR VPWR _3138_/A sky130_fd_sc_hd__nand2b_2
XTAP_TAPCELL_ROW_18_368 VGND VPWR sky130_fd_sc_hd__tapvpwrvgnd_1
XFILLER_31_343 VGND VGND VPWR VPWR sky130_fd_sc_hd__decap_3
X_3880_ _3817_/B _4449_/S _3879_/Y VGND VGND VPWR VPWR _3881_/B sky130_fd_sc_hd__a21o_2
XFILLER_31_387 VGND VGND VPWR VPWR sky130_fd_sc_hd__decap_3
X_2831_ _5076_/Q _5060_/Q _5044_/Q _5028_/Q _2854_/S0 _5136_/Q VGND VGND VPWR VPWR
+ _2832_/B sky130_fd_sc_hd__mux4_2
X_2762_ _5137_/Q _2759_/X _5138_/Q VGND VGND VPWR VPWR _2762_/X sky130_fd_sc_hd__o21a_2
XFILLER_77_3 VGND VGND VPWR VPWR sky130_fd_sc_hd__decap_3
X_4501_ _4595_/B _4501_/B VGND VGND VPWR VPWR _4501_/X sky130_fd_sc_hd__or2_2
X_4432_ _4331_/Y _4431_/X _4325_/C VGND VGND VPWR VPWR _4432_/X sky130_fd_sc_hd__a21o_2
X_2693_ _4659_/S _2693_/B VGND VGND VPWR VPWR _3842_/A sky130_fd_sc_hd__nand2_2
XPHY_EDGE_ROW_91_Left_185 VGND VGND VPWR VPWR sky130_fd_sc_hd__decap_3
X_4363_ _4361_/Y _4386_/A VGND VGND VPWR VPWR _4367_/A sky130_fd_sc_hd__and2b_2
X_4294_ _4378_/A _4449_/S _4242_/B VGND VGND VPWR VPWR _4483_/B sky130_fd_sc_hd__a21o_2
X_3314_ _5258_/Q _3305_/B _3313_/X _3338_/B VGND VGND VPWR VPWR _5153_/D sky130_fd_sc_hd__o211a_2
XFILLER_86_505 VGND VGND VPWR VPWR sky130_fd_sc_hd__fill_2
X_3245_ _5283_/Q _3338_/B input7/X VGND VGND VPWR VPWR _3245_/X sky130_fd_sc_hd__and3_2
X_3176_ _2897_/X _3191_/A2 _3191_/B1 _5079_/Q VGND VGND VPWR VPWR _5079_/D sky130_fd_sc_hd__a22o_2
XTAP_TAPCELL_ROW_1_214 VGND VPWR sky130_fd_sc_hd__tapvpwrvgnd_1
XFILLER_39_498 VGND VGND VPWR VPWR sky130_fd_sc_hd__decap_3
XFILLER_54_446 VGND VGND VPWR VPWR sky130_fd_sc_hd__decap_3
XFILLER_25_27 VGND VGND VPWR VPWR sky130_fd_sc_hd__decap_3
XFILLER_81_254 VGND VGND VPWR VPWR sky130_fd_sc_hd__fill_2
XFILLER_81_298 VGND VGND VPWR VPWR sky130_fd_sc_hd__decap_3
XFILLER_81_276 VGND VGND VPWR VPWR sky130_fd_sc_hd__decap_3
XFILLER_34_192 VGND VGND VPWR VPWR sky130_fd_sc_hd__decap_3
XFILLER_62_490 VGND VGND VPWR VPWR sky130_fd_sc_hd__decap_3
XFILLER_22_354 VGND VGND VPWR VPWR sky130_fd_sc_hd__decap_3
XFILLER_22_365 VGND VGND VPWR VPWR sky130_fd_sc_hd__decap_3
XFILLER_1_225 VGND VGND VPWR VPWR sky130_fd_sc_hd__decap_3
XFILLER_9_6 VGND VGND VPWR VPWR sky130_fd_sc_hd__decap_3
XFILLER_89_321 VGND VGND VPWR VPWR sky130_fd_sc_hd__decap_3
XFILLER_1_236 VGND VGND VPWR VPWR sky130_fd_sc_hd__fill_1
XFILLER_49_207 VGND VGND VPWR VPWR sky130_fd_sc_hd__decap_3
XFILLER_89_387 VGND VGND VPWR VPWR sky130_fd_sc_hd__decap_3
XFILLER_77_538 VGND VGND VPWR VPWR sky130_fd_sc_hd__fill_2
XFILLER_45_435 VGND VGND VPWR VPWR sky130_fd_sc_hd__fill_1
XFILLER_57_284 VGND VGND VPWR VPWR sky130_fd_sc_hd__decap_3
XFILLER_72_221 VGND VGND VPWR VPWR sky130_fd_sc_hd__fill_1
XFILLER_45_479 VGND VGND VPWR VPWR sky130_fd_sc_hd__decap_3
XFILLER_60_416 VGND VGND VPWR VPWR sky130_fd_sc_hd__decap_3
XFILLER_60_427 VGND VGND VPWR VPWR sky130_fd_sc_hd__decap_3
XTAP_TAPCELL_ROW_43_614 VGND VPWR sky130_fd_sc_hd__tapvpwrvgnd_1
XFILLER_82_55 VGND VGND VPWR VPWR sky130_fd_sc_hd__decap_3
XFILLER_13_310 VGND VGND VPWR VPWR sky130_fd_sc_hd__decap_3
XFILLER_13_343 VGND VGND VPWR VPWR sky130_fd_sc_hd__decap_3
XFILLER_25_181 VGND VGND VPWR VPWR sky130_fd_sc_hd__decap_3
XFILLER_53_490 VGND VGND VPWR VPWR sky130_fd_sc_hd__decap_3
XFILLER_15_60 VGND VGND VPWR VPWR sky130_fd_sc_hd__decap_3
XFILLER_15_93 VGND VGND VPWR VPWR sky130_fd_sc_hd__fill_2
XFILLER_40_195 VGND VGND VPWR VPWR sky130_fd_sc_hd__fill_1
XFILLER_9_369 VGND VGND VPWR VPWR sky130_fd_sc_hd__decap_3
XFILLER_5_542 VGND VGND VPWR VPWR sky130_fd_sc_hd__decap_3
Xoutput70 _5146_/Q VGND VGND VPWR VPWR INSTR_ADDR[9] sky130_fd_sc_hd__clkdlybuf4s25_1
XTAP_TAPCELL_ROW_91_1064 VGND VPWR sky130_fd_sc_hd__tapvpwrvgnd_1
Xoutput81 _2894_/X VGND VGND VPWR VPWR MEM_ADDR[14] sky130_fd_sc_hd__clkdlybuf4s25_1
Xoutput92 _2722_/X VGND VGND VPWR VPWR MEM_STR_DATA[0] sky130_fd_sc_hd__clkdlybuf4s25_1
X_3030_ _2897_/X _3028_/Y _3029_/Y _4951_/Q VGND VGND VPWR VPWR _4951_/D sky130_fd_sc_hd__a22o_2
XFILLER_83_508 VGND VGND VPWR VPWR sky130_fd_sc_hd__decap_3
XFILLER_36_424 VGND VGND VPWR VPWR sky130_fd_sc_hd__fill_1
XFILLER_36_457 VGND VGND VPWR VPWR sky130_fd_sc_hd__decap_3
XFILLER_51_427 VGND VGND VPWR VPWR sky130_fd_sc_hd__decap_3
XFILLER_63_276 VGND VGND VPWR VPWR sky130_fd_sc_hd__decap_3
XFILLER_63_287 VGND VGND VPWR VPWR sky130_fd_sc_hd__fill_1
X_4981_ _5177_/CLK _4981_/D VGND VGND VPWR VPWR _4981_/Q sky130_fd_sc_hd__dfxtp_2
X_3932_ _4070_/A _3929_/X _3931_/Y _3963_/A _3927_/X VGND VGND VPWR VPWR _3932_/X
+ sky130_fd_sc_hd__a32o_2
X_3863_ _3860_/X _3862_/X _3969_/S VGND VGND VPWR VPWR _4025_/B sky130_fd_sc_hd__mux2_1
XFILLER_31_162 VGND VGND VPWR VPWR sky130_fd_sc_hd__decap_3
X_2814_ _4898_/Q _4882_/Q _5106_/Q _5090_/Q _2851_/S0 _2854_/S1 VGND VGND VPWR VPWR
+ _2815_/B sky130_fd_sc_hd__mux4_2
X_3794_ _3817_/B _4286_/B VGND VGND VPWR VPWR _3892_/B sky130_fd_sc_hd__nand2_2
X_2745_ _5137_/Q _2745_/B VGND VGND VPWR VPWR _2745_/X sky130_fd_sc_hd__or2_2
XFILLER_8_380 VGND VGND VPWR VPWR sky130_fd_sc_hd__decap_3
X_2676_ _5121_/Q _5009_/Q _4993_/Q _4977_/Q _2676_/S0 _2676_/S1 VGND VGND VPWR VPWR
+ _2676_/X sky130_fd_sc_hd__mux4_2
X_4415_ _3889_/B _4021_/B _3894_/X _2601_/Y _4414_/X VGND VGND VPWR VPWR _4416_/C
+ sky130_fd_sc_hd__o221a_2
X_4346_ _4393_/A _4346_/B VGND VGND VPWR VPWR _4348_/A sky130_fd_sc_hd__xnor2_2
XFILLER_59_505 VGND VGND VPWR VPWR sky130_fd_sc_hd__fill_1
X_4277_ _5226_/Q _4854_/B VGND VGND VPWR VPWR _4277_/Y sky130_fd_sc_hd__nand2_2
XFILLER_86_357 VGND VGND VPWR VPWR sky130_fd_sc_hd__decap_3
XFILLER_86_324 VGND VGND VPWR VPWR sky130_fd_sc_hd__fill_1
XFILLER_27_402 VGND VGND VPWR VPWR sky130_fd_sc_hd__decap_3
X_3228_ _5282_/Q _5285_/Q _5280_/Q _5281_/Q VGND VGND VPWR VPWR _3229_/B sky130_fd_sc_hd__or4_2
XFILLER_86_368 VGND VGND VPWR VPWR sky130_fd_sc_hd__decap_3
XFILLER_39_284 VGND VGND VPWR VPWR sky130_fd_sc_hd__fill_2
XFILLER_54_221 VGND VGND VPWR VPWR sky130_fd_sc_hd__decap_3
X_3159_ _2905_/X _3173_/A2 _3157_/Y _5064_/Q VGND VGND VPWR VPWR _5064_/D sky130_fd_sc_hd__a22o_2
XTAP_TAPCELL_ROW_57_739 VGND VPWR sky130_fd_sc_hd__tapvpwrvgnd_1
XFILLER_36_59 VGND VGND VPWR VPWR sky130_fd_sc_hd__decap_3
XFILLER_14_118 VGND VGND VPWR VPWR sky130_fd_sc_hd__decap_3
XFILLER_14_129 VGND VGND VPWR VPWR sky130_fd_sc_hd__decap_3
XFILLER_54_298 VGND VGND VPWR VPWR sky130_fd_sc_hd__decap_3
XTAP_TAPCELL_ROW_12_319 VGND VPWR sky130_fd_sc_hd__tapvpwrvgnd_1
XFILLER_10_346 VGND VGND VPWR VPWR sky130_fd_sc_hd__decap_3
XFILLER_10_368 VGND VGND VPWR VPWR sky130_fd_sc_hd__decap_3
XFILLER_6_306 VGND VGND VPWR VPWR sky130_fd_sc_hd__fill_2
XFILLER_6_339 VGND VGND VPWR VPWR sky130_fd_sc_hd__decap_3
XTAP_TAPCELL_ROW_20_396 VGND VPWR sky130_fd_sc_hd__tapvpwrvgnd_1
XFILLER_2_512 VGND VGND VPWR VPWR sky130_fd_sc_hd__decap_3
XFILLER_2_545 VGND VGND VPWR VPWR sky130_fd_sc_hd__decap_3
XFILLER_7_3 VGND VGND VPWR VPWR sky130_fd_sc_hd__decap_3
XFILLER_77_55 VGND VGND VPWR VPWR sky130_fd_sc_hd__fill_1
XFILLER_77_22 VGND VGND VPWR VPWR sky130_fd_sc_hd__decap_3
XFILLER_89_195 VGND VGND VPWR VPWR sky130_fd_sc_hd__fill_1
XFILLER_77_66 VGND VGND VPWR VPWR sky130_fd_sc_hd__decap_3
XFILLER_77_346 VGND VGND VPWR VPWR sky130_fd_sc_hd__decap_3
XFILLER_77_335 VGND VGND VPWR VPWR sky130_fd_sc_hd__fill_1
XFILLER_65_519 VGND VGND VPWR VPWR sky130_fd_sc_hd__decap_3
XFILLER_77_379 VGND VGND VPWR VPWR sky130_fd_sc_hd__decap_3
XFILLER_18_424 VGND VGND VPWR VPWR sky130_fd_sc_hd__decap_3
XFILLER_45_221 VGND VGND VPWR VPWR sky130_fd_sc_hd__decap_3
XFILLER_45_243 VGND VGND VPWR VPWR sky130_fd_sc_hd__decap_3
XFILLER_33_405 VGND VGND VPWR VPWR sky130_fd_sc_hd__decap_3
XTAP_TAPCELL_ROW_28_463 VGND VPWR sky130_fd_sc_hd__tapvpwrvgnd_1
XFILLER_26_490 VGND VGND VPWR VPWR sky130_fd_sc_hd__decap_3
XFILLER_33_449 VGND VGND VPWR VPWR sky130_fd_sc_hd__decap_3
XFILLER_60_235 VGND VGND VPWR VPWR sky130_fd_sc_hd__decap_3
XFILLER_41_482 VGND VGND VPWR VPWR sky130_fd_sc_hd__decap_3
XFILLER_42_80 VGND VGND VPWR VPWR sky130_fd_sc_hd__decap_3
XFILLER_9_144 VGND VGND VPWR VPWR sky130_fd_sc_hd__decap_3
X_2530_ _5163_/Q _3825_/B VGND VGND VPWR VPWR _2630_/A sky130_fd_sc_hd__and2_2
X_2461_ _3363_/C _2459_/Y _3590_/B VGND VGND VPWR VPWR _2461_/X sky130_fd_sc_hd__a21o_2
X_4200_ _4200_/A _4200_/B _4200_/C _4200_/D VGND VGND VPWR VPWR _4200_/X sky130_fd_sc_hd__or4_2
X_5180_ _5253_/CLK _5180_/D VGND VGND VPWR VPWR _5180_/Q sky130_fd_sc_hd__dfxtp_2
XFILLER_3_63 VGND VGND VPWR VPWR sky130_fd_sc_hd__decap_3
XFILLER_68_324 VGND VGND VPWR VPWR sky130_fd_sc_hd__decap_3
X_4131_ _4130_/X _4029_/X _4267_/S VGND VGND VPWR VPWR _4131_/X sky130_fd_sc_hd__mux2_1
XFILLER_56_519 VGND VGND VPWR VPWR sky130_fd_sc_hd__decap_3
XFILLER_68_357 VGND VGND VPWR VPWR sky130_fd_sc_hd__decap_3
XFILLER_68_379 VGND VGND VPWR VPWR sky130_fd_sc_hd__fill_2
X_4062_ _4062_/A _4062_/B _4062_/C VGND VGND VPWR VPWR _4062_/X sky130_fd_sc_hd__and3_2
XFILLER_83_305 VGND VGND VPWR VPWR sky130_fd_sc_hd__decap_3
X_3013_ _2905_/X _3011_/B _3011_/Y _4936_/Q VGND VGND VPWR VPWR _4936_/D sky130_fd_sc_hd__a22o_2
XFILLER_24_416 VGND VGND VPWR VPWR sky130_fd_sc_hd__decap_3
XFILLER_24_427 VGND VGND VPWR VPWR sky130_fd_sc_hd__decap_3
XFILLER_36_265 VGND VGND VPWR VPWR sky130_fd_sc_hd__decap_3
XFILLER_51_202 VGND VGND VPWR VPWR sky130_fd_sc_hd__decap_3
XFILLER_51_235 VGND VGND VPWR VPWR sky130_fd_sc_hd__decap_3
X_4964_ _5008_/CLK _4964_/D VGND VGND VPWR VPWR _4964_/Q sky130_fd_sc_hd__dfxtp_2
X_3915_ _4261_/A _3915_/B VGND VGND VPWR VPWR _3915_/Y sky130_fd_sc_hd__nand2b_2
X_4895_ _5215_/CLK _4895_/D VGND VGND VPWR VPWR _4895_/Q sky130_fd_sc_hd__dfxtp_2
XTAP_TAPCELL_ROW_62_786 VGND VPWR sky130_fd_sc_hd__tapvpwrvgnd_1
X_3846_ _5170_/Q _4378_/B _3845_/X VGND VGND VPWR VPWR _3848_/B sky130_fd_sc_hd__o21ba_2
X_3777_ _3772_/X _4345_/A _3777_/C _3777_/D VGND VGND VPWR VPWR _3782_/B sky130_fd_sc_hd__and4b_2
X_2728_ _4952_/Q _4936_/Q _4920_/Q _4904_/Q _2818_/S0 _5136_/Q VGND VGND VPWR VPWR
+ _2728_/X sky130_fd_sc_hd__mux4_2
X_2659_ _4898_/Q _4882_/Q _5106_/Q _5090_/Q _2672_/S0 _2672_/S1 VGND VGND VPWR VPWR
+ _2660_/B sky130_fd_sc_hd__mux4_2
XFILLER_59_346 VGND VGND VPWR VPWR sky130_fd_sc_hd__decap_3
X_4329_ _3852_/A _4328_/X _4397_/C VGND VGND VPWR VPWR _4329_/X sky130_fd_sc_hd__a21o_2
XFILLER_86_121 VGND VGND VPWR VPWR sky130_fd_sc_hd__decap_3
XFILLER_47_508 VGND VGND VPWR VPWR sky130_fd_sc_hd__decap_3
XFILLER_74_316 VGND VGND VPWR VPWR sky130_fd_sc_hd__decap_3
XFILLER_67_390 VGND VGND VPWR VPWR sky130_fd_sc_hd__fill_2
XFILLER_27_265 VGND VGND VPWR VPWR sky130_fd_sc_hd__decap_3
XFILLER_42_202 VGND VGND VPWR VPWR sky130_fd_sc_hd__fill_1
XFILLER_70_500 VGND VGND VPWR VPWR sky130_fd_sc_hd__fill_2
XFILLER_82_371 VGND VGND VPWR VPWR sky130_fd_sc_hd__decap_3
XFILLER_15_449 VGND VGND VPWR VPWR sky130_fd_sc_hd__decap_3
XFILLER_42_224 VGND VGND VPWR VPWR sky130_fd_sc_hd__decap_3
XFILLER_42_246 VGND VGND VPWR VPWR sky130_fd_sc_hd__decap_3
XFILLER_63_57 VGND VGND VPWR VPWR sky130_fd_sc_hd__decap_3
XFILLER_70_533 VGND VGND VPWR VPWR sky130_fd_sc_hd__fill_2
XFILLER_70_544 VGND VGND VPWR VPWR sky130_fd_sc_hd__fill_1
XFILLER_70_555 VGND VGND VPWR VPWR sky130_fd_sc_hd__decap_3
XFILLER_30_419 VGND VGND VPWR VPWR sky130_fd_sc_hd__fill_1
XFILLER_6_136 VGND VGND VPWR VPWR sky130_fd_sc_hd__decap_3
XFILLER_6_147 VGND VGND VPWR VPWR sky130_fd_sc_hd__decap_3
XFILLER_12_83 VGND VGND VPWR VPWR sky130_fd_sc_hd__fill_1
XFILLER_88_32 VGND VGND VPWR VPWR sky130_fd_sc_hd__decap_3
XFILLER_26_9 VGND VGND VPWR VPWR sky130_fd_sc_hd__decap_3
XFILLER_77_165 VGND VGND VPWR VPWR sky130_fd_sc_hd__decap_3
XFILLER_77_187 VGND VGND VPWR VPWR sky130_fd_sc_hd__fill_2
XFILLER_46_552 VGND VGND VPWR VPWR sky130_fd_sc_hd__decap_3
XFILLER_65_349 VGND VGND VPWR VPWR sky130_fd_sc_hd__decap_3
XFILLER_92_146 VGND VGND VPWR VPWR sky130_fd_sc_hd__fill_1
XFILLER_33_213 VGND VGND VPWR VPWR sky130_fd_sc_hd__decap_3
XFILLER_73_393 VGND VGND VPWR VPWR sky130_fd_sc_hd__decap_3
XFILLER_33_246 VGND VGND VPWR VPWR sky130_fd_sc_hd__decap_3
XFILLER_33_279 VGND VGND VPWR VPWR sky130_fd_sc_hd__fill_1
X_3700_ _3701_/A _3785_/B VGND VGND VPWR VPWR _4200_/C sky130_fd_sc_hd__nor2_2
XFILLER_41_290 VGND VGND VPWR VPWR sky130_fd_sc_hd__decap_3
X_4680_ _4362_/A _4638_/S _3855_/Y VGND VGND VPWR VPWR _4680_/Y sky130_fd_sc_hd__o21ai_2
X_3631_ _3631_/A _3631_/B VGND VGND VPWR VPWR _3666_/A sky130_fd_sc_hd__nor2_2
X_3562_ _3562_/A _4281_/A VGND VGND VPWR VPWR _3562_/X sky130_fd_sc_hd__or2_2
X_2513_ _5123_/Q _5011_/Q _4995_/Q _4979_/Q _2676_/S0 _2676_/S1 VGND VGND VPWR VPWR
+ _2513_/X sky130_fd_sc_hd__mux4_2
XFILLER_5_180 VGND VGND VPWR VPWR sky130_fd_sc_hd__decap_3
X_3493_ _5209_/Q _4854_/B _3458_/A _3492_/Y VGND VGND VPWR VPWR _3494_/B sky130_fd_sc_hd__o2bb2a_2
X_5232_ _5241_/CLK _5232_/D VGND VGND VPWR VPWR _5232_/Q sky130_fd_sc_hd__dfxtp_2
X_2444_ _5187_/Q _5186_/Q VGND VGND VPWR VPWR _2463_/A sky130_fd_sc_hd__nor2_2
X_5163_ _5270_/CLK _5163_/D VGND VGND VPWR VPWR _5163_/Q sky130_fd_sc_hd__dfxtp_2
XFILLER_29_519 VGND VGND VPWR VPWR sky130_fd_sc_hd__decap_3
X_4114_ _4199_/D _4115_/B VGND VGND VPWR VPWR _4114_/Y sky130_fd_sc_hd__nand2_2
XFILLER_68_165 VGND VGND VPWR VPWR sky130_fd_sc_hd__fill_1
X_5094_ _5107_/CLK _5094_/D VGND VGND VPWR VPWR _5094_/Q sky130_fd_sc_hd__dfxtp_2
XTAP_TAPCELL_ROW_67_834 VGND VPWR sky130_fd_sc_hd__tapvpwrvgnd_1
XFILLER_83_113 VGND VGND VPWR VPWR sky130_fd_sc_hd__decap_3
XFILLER_37_530 VGND VGND VPWR VPWR sky130_fd_sc_hd__decap_3
X_4045_ _4071_/A _3925_/X _3960_/Y VGND VGND VPWR VPWR _4045_/X sky130_fd_sc_hd__o21a_2
XTAP_TAPCELL_ROW_39_569 VGND VPWR sky130_fd_sc_hd__tapvpwrvgnd_1
XFILLER_52_533 VGND VGND VPWR VPWR sky130_fd_sc_hd__fill_2
XFILLER_24_279 VGND VGND VPWR VPWR sky130_fd_sc_hd__decap_3
X_4947_ clkload7/A _4947_/D VGND VGND VPWR VPWR _4947_/Q sky130_fd_sc_hd__dfxtp_2
XTAP_TAPCELL_ROW_22_414 VGND VPWR sky130_fd_sc_hd__tapvpwrvgnd_1
X_4878_ _5102_/CLK _4878_/D VGND VGND VPWR VPWR _4878_/Q sky130_fd_sc_hd__dfxtp_2
X_3829_ _5161_/Q _3829_/B VGND VGND VPWR VPWR _3829_/X sky130_fd_sc_hd__and2b_2
XTAP_TAPCELL_ROW_30_491 VGND VPWR sky130_fd_sc_hd__tapvpwrvgnd_1
XFILLER_58_35 VGND VGND VPWR VPWR sky130_fd_sc_hd__fill_2
XFILLER_58_46 VGND VGND VPWR VPWR sky130_fd_sc_hd__decap_3
XFILLER_87_452 VGND VGND VPWR VPWR sky130_fd_sc_hd__decap_3
XFILLER_87_441 VGND VGND VPWR VPWR sky130_fd_sc_hd__decap_3
XFILLER_47_316 VGND VGND VPWR VPWR sky130_fd_sc_hd__decap_3
XFILLER_59_165 VGND VGND VPWR VPWR sky130_fd_sc_hd__decap_3
XFILLER_28_530 VGND VGND VPWR VPWR sky130_fd_sc_hd__fill_2
XFILLER_74_124 VGND VGND VPWR VPWR sky130_fd_sc_hd__decap_3
XFILLER_43_500 VGND VGND VPWR VPWR sky130_fd_sc_hd__decap_3
XFILLER_15_213 VGND VGND VPWR VPWR sky130_fd_sc_hd__decap_3
XFILLER_55_393 VGND VGND VPWR VPWR sky130_fd_sc_hd__decap_3
XFILLER_70_330 VGND VGND VPWR VPWR sky130_fd_sc_hd__decap_3
XFILLER_15_246 VGND VGND VPWR VPWR sky130_fd_sc_hd__decap_3
XFILLER_70_352 VGND VGND VPWR VPWR sky130_fd_sc_hd__decap_3
XFILLER_70_396 VGND VGND VPWR VPWR sky130_fd_sc_hd__decap_3
XFILLER_23_290 VGND VGND VPWR VPWR sky130_fd_sc_hd__decap_3
XFILLER_11_452 VGND VGND VPWR VPWR sky130_fd_sc_hd__decap_3
XFILLER_7_423 VGND VGND VPWR VPWR sky130_fd_sc_hd__fill_1
XFILLER_7_412 VGND VGND VPWR VPWR sky130_fd_sc_hd__decap_3
XFILLER_11_496 VGND VGND VPWR VPWR sky130_fd_sc_hd__decap_3
XFILLER_23_93 VGND VGND VPWR VPWR sky130_fd_sc_hd__decap_3
XFILLER_7_445 VGND VGND VPWR VPWR sky130_fd_sc_hd__decap_3
Xmax_cap109 _3229_/Y VGND VGND VPWR VPWR _4868_/A2 sky130_fd_sc_hd__buf_6
XFILLER_2_172 VGND VGND VPWR VPWR sky130_fd_sc_hd__decap_3
XFILLER_78_430 VGND VGND VPWR VPWR sky130_fd_sc_hd__decap_3
XFILLER_24_6 VGND VGND VPWR VPWR sky130_fd_sc_hd__fill_1
XFILLER_78_463 VGND VGND VPWR VPWR sky130_fd_sc_hd__decap_3
XFILLER_38_327 VGND VGND VPWR VPWR sky130_fd_sc_hd__fill_1
XFILLER_65_113 VGND VGND VPWR VPWR sky130_fd_sc_hd__decap_3
XTAP_TAPCELL_ROW_88_1036 VGND VPWR sky130_fd_sc_hd__tapvpwrvgnd_1
XFILLER_93_455 VGND VGND VPWR VPWR sky130_fd_sc_hd__decap_3
XFILLER_93_433 VGND VGND VPWR VPWR sky130_fd_sc_hd__decap_3
XFILLER_93_477 VGND VGND VPWR VPWR sky130_fd_sc_hd__decap_3
XFILLER_0_75 VGND VGND VPWR VPWR sky130_fd_sc_hd__fill_1
XFILLER_34_533 VGND VGND VPWR VPWR sky130_fd_sc_hd__fill_1
XTAP_TAPCELL_ROW_36_539 VGND VPWR sky130_fd_sc_hd__tapvpwrvgnd_1
XFILLER_80_138 VGND VGND VPWR VPWR sky130_fd_sc_hd__fill_2
XFILLER_0_97 VGND VGND VPWR VPWR sky130_fd_sc_hd__decap_3
XFILLER_34_555 VGND VGND VPWR VPWR sky130_fd_sc_hd__decap_3
XFILLER_21_205 VGND VGND VPWR VPWR sky130_fd_sc_hd__decap_3
XFILLER_61_385 VGND VGND VPWR VPWR sky130_fd_sc_hd__decap_3
XFILLER_61_396 VGND VGND VPWR VPWR sky130_fd_sc_hd__decap_3
X_4801_ _4814_/A VGND VGND VPWR VPWR _4801_/Y sky130_fd_sc_hd__inv_2
X_2993_ _3494_/A _2993_/B VGND VGND VPWR VPWR _2993_/Y sky130_fd_sc_hd__nor2_4
XTAP_TAPCELL_ROW_72_881 VGND VPWR sky130_fd_sc_hd__tapvpwrvgnd_1
XFILLER_14_290 VGND VGND VPWR VPWR sky130_fd_sc_hd__decap_3
X_4732_ _4732_/A _4732_/B VGND VGND VPWR VPWR _4734_/B sky130_fd_sc_hd__xor2_2
X_4663_ _4437_/A _4656_/X _4662_/X _4226_/Y VGND VGND VPWR VPWR _4663_/X sky130_fd_sc_hd__o211a_2
XFILLER_9_73 VGND VGND VPWR VPWR sky130_fd_sc_hd__fill_1
X_3614_ _4393_/D _3793_/B VGND VGND VPWR VPWR _3615_/B sky130_fd_sc_hd__and2_2
X_4594_ _4594_/A _4594_/B _4594_/C VGND VGND VPWR VPWR _4597_/A sky130_fd_sc_hd__and3_2
X_3545_ _4320_/A _4638_/S VGND VGND VPWR VPWR _3545_/Y sky130_fd_sc_hd__nand2_2
XFILLER_0_109 VGND VGND VPWR VPWR sky130_fd_sc_hd__decap_3
X_3476_ _5169_/Q _5150_/Q VGND VGND VPWR VPWR _3476_/Y sky130_fd_sc_hd__nor2_2
X_5215_ _5215_/CLK _5215_/D VGND VGND VPWR VPWR _5215_/Q sky130_fd_sc_hd__dfxtp_2
X_2427_ _5183_/Q VGND VGND VPWR VPWR _3773_/A sky130_fd_sc_hd__inv_2
XFILLER_88_227 VGND VGND VPWR VPWR sky130_fd_sc_hd__fill_1
XFILLER_69_452 VGND VGND VPWR VPWR sky130_fd_sc_hd__decap_3
XFILLER_69_474 VGND VGND VPWR VPWR sky130_fd_sc_hd__decap_3
XFILLER_69_496 VGND VGND VPWR VPWR sky130_fd_sc_hd__decap_3
X_5146_ _5208_/CLK _5146_/D VGND VGND VPWR VPWR _5146_/Q sky130_fd_sc_hd__dfxtp_2
XFILLER_29_349 VGND VGND VPWR VPWR sky130_fd_sc_hd__decap_3
X_5077_ _5215_/CLK _5077_/D VGND VGND VPWR VPWR _5077_/Q sky130_fd_sc_hd__dfxtp_2
XFILLER_25_500 VGND VGND VPWR VPWR sky130_fd_sc_hd__decap_3
XFILLER_44_319 VGND VGND VPWR VPWR sky130_fd_sc_hd__decap_3
X_4028_ _4393_/C _4449_/S _4027_/Y VGND VGND VPWR VPWR _4028_/Y sky130_fd_sc_hd__o21ai_2
XFILLER_84_477 VGND VGND VPWR VPWR sky130_fd_sc_hd__decap_3
XFILLER_25_511 VGND VGND VPWR VPWR sky130_fd_sc_hd__decap_3
XFILLER_37_371 VGND VGND VPWR VPWR sky130_fd_sc_hd__decap_3
XFILLER_37_393 VGND VGND VPWR VPWR sky130_fd_sc_hd__decap_3
XFILLER_71_116 VGND VGND VPWR VPWR sky130_fd_sc_hd__decap_3
XFILLER_52_330 VGND VGND VPWR VPWR sky130_fd_sc_hd__fill_2
XFILLER_12_249 VGND VGND VPWR VPWR sky130_fd_sc_hd__decap_3
XFILLER_79_205 VGND VGND VPWR VPWR sky130_fd_sc_hd__fill_2
XFILLER_69_67 VGND VGND VPWR VPWR sky130_fd_sc_hd__decap_3
XTAP_TAPCELL_ROW_7_264 VGND VPWR sky130_fd_sc_hd__tapvpwrvgnd_1
XFILLER_47_113 VGND VGND VPWR VPWR sky130_fd_sc_hd__decap_3
XFILLER_75_433 VGND VGND VPWR VPWR sky130_fd_sc_hd__fill_2
XFILLER_16_500 VGND VGND VPWR VPWR sky130_fd_sc_hd__fill_1
XFILLER_16_522 VGND VGND VPWR VPWR sky130_fd_sc_hd__decap_3
XFILLER_16_533 VGND VGND VPWR VPWR sky130_fd_sc_hd__fill_1
XFILLER_18_82 VGND VGND VPWR VPWR sky130_fd_sc_hd__fill_2
XFILLER_28_371 VGND VGND VPWR VPWR sky130_fd_sc_hd__decap_3
XFILLER_16_555 VGND VGND VPWR VPWR sky130_fd_sc_hd__decap_3
XFILLER_43_352 VGND VGND VPWR VPWR sky130_fd_sc_hd__decap_3
XFILLER_31_514 VGND VGND VPWR VPWR sky130_fd_sc_hd__decap_3
XFILLER_43_385 VGND VGND VPWR VPWR sky130_fd_sc_hd__decap_3
XFILLER_31_547 VGND VGND VPWR VPWR sky130_fd_sc_hd__decap_3
XFILLER_34_81 VGND VGND VPWR VPWR sky130_fd_sc_hd__decap_3
XFILLER_43_396 VGND VGND VPWR VPWR sky130_fd_sc_hd__decap_3
XFILLER_93_9 VGND VGND VPWR VPWR sky130_fd_sc_hd__decap_3
XFILLER_11_293 VGND VGND VPWR VPWR sky130_fd_sc_hd__decap_3
Xwire151 _3741_/A VGND VGND VPWR VPWR _4390_/A sky130_fd_sc_hd__buf_4
X_3330_ _5283_/Q _3338_/B _3330_/C VGND VGND VPWR VPWR _3330_/X sky130_fd_sc_hd__and3_2
XFILLER_3_492 VGND VGND VPWR VPWR sky130_fd_sc_hd__decap_3
X_5000_ _5118_/CLK _5000_/D VGND VGND VPWR VPWR _5000_/Q sky130_fd_sc_hd__dfxtp_2
X_3261_ _5140_/Q _5139_/Q _3311_/S VGND VGND VPWR VPWR _3267_/B sky130_fd_sc_hd__and3_2
XFILLER_22_3 VGND VGND VPWR VPWR sky130_fd_sc_hd__decap_3
XFILLER_66_400 VGND VGND VPWR VPWR sky130_fd_sc_hd__decap_3
X_3192_ _3192_/A _3192_/B VGND VGND VPWR VPWR _3192_/Y sky130_fd_sc_hd__nor2_4
XFILLER_66_444 VGND VGND VPWR VPWR sky130_fd_sc_hd__decap_3
XFILLER_78_293 VGND VGND VPWR VPWR sky130_fd_sc_hd__decap_3
XFILLER_53_105 VGND VGND VPWR VPWR sky130_fd_sc_hd__decap_3
XFILLER_66_477 VGND VGND VPWR VPWR sky130_fd_sc_hd__decap_3
XTAP_TAPCELL_ROW_49_664 VGND VPWR sky130_fd_sc_hd__tapvpwrvgnd_1
XFILLER_19_382 VGND VGND VPWR VPWR sky130_fd_sc_hd__decap_3
XFILLER_19_393 VGND VGND VPWR VPWR sky130_fd_sc_hd__decap_3
XFILLER_53_116 VGND VGND VPWR VPWR sky130_fd_sc_hd__decap_3
XFILLER_81_425 VGND VGND VPWR VPWR sky130_fd_sc_hd__decap_3
XFILLER_81_469 VGND VGND VPWR VPWR sky130_fd_sc_hd__decap_3
XFILLER_14_18 VGND VGND VPWR VPWR sky130_fd_sc_hd__decap_3
XFILLER_22_525 VGND VGND VPWR VPWR sky130_fd_sc_hd__fill_1
XFILLER_34_374 VGND VGND VPWR VPWR sky130_fd_sc_hd__fill_1
XFILLER_14_29 VGND VGND VPWR VPWR sky130_fd_sc_hd__decap_3
XFILLER_22_536 VGND VGND VPWR VPWR sky130_fd_sc_hd__decap_3
XFILLER_61_193 VGND VGND VPWR VPWR sky130_fd_sc_hd__fill_2
X_2976_ _2905_/X _2974_/B _2974_/Y _4904_/Q VGND VGND VPWR VPWR _4904_/D sky130_fd_sc_hd__a22o_2
X_4715_ _5252_/Q _4725_/B VGND VGND VPWR VPWR _4715_/X sky130_fd_sc_hd__or2_2
X_4646_ _4207_/A _4261_/C _4686_/B1 _3780_/A _4644_/X VGND VGND VPWR VPWR _4647_/C
+ sky130_fd_sc_hd__o221a_2
X_4577_ _4629_/B _4500_/Y _4682_/S VGND VGND VPWR VPWR _4578_/A sky130_fd_sc_hd__mux2_1
XFILLER_89_503 VGND VGND VPWR VPWR sky130_fd_sc_hd__fill_1
X_3528_ _3693_/A _3525_/X _5134_/Q VGND VGND VPWR VPWR _3528_/X sky130_fd_sc_hd__o21a_2
X_3459_ _3451_/Y _3458_/X _3494_/A VGND VGND VPWR VPWR _5204_/D sky130_fd_sc_hd__a21oi_2
XFILLER_57_411 VGND VGND VPWR VPWR sky130_fd_sc_hd__decap_3
XFILLER_57_444 VGND VGND VPWR VPWR sky130_fd_sc_hd__decap_3
X_5129_ clkload4/A _5129_/D VGND VGND VPWR VPWR _5129_/Q sky130_fd_sc_hd__dfxtp_2
XFILLER_57_455 VGND VGND VPWR VPWR sky130_fd_sc_hd__decap_3
XFILLER_84_241 VGND VGND VPWR VPWR sky130_fd_sc_hd__decap_3
XFILLER_44_138 VGND VGND VPWR VPWR sky130_fd_sc_hd__fill_2
XFILLER_72_414 VGND VGND VPWR VPWR sky130_fd_sc_hd__fill_1
XFILLER_72_436 VGND VGND VPWR VPWR sky130_fd_sc_hd__decap_3
XTAP_TAPCELL_ROW_83_987 VGND VPWR sky130_fd_sc_hd__tapvpwrvgnd_1
XFILLER_25_396 VGND VGND VPWR VPWR sky130_fd_sc_hd__decap_3
XFILLER_40_322 VGND VGND VPWR VPWR sky130_fd_sc_hd__fill_1
XFILLER_52_193 VGND VGND VPWR VPWR sky130_fd_sc_hd__decap_3
XFILLER_71_57 VGND VGND VPWR VPWR sky130_fd_sc_hd__decap_3
XFILLER_4_212 VGND VGND VPWR VPWR sky130_fd_sc_hd__decap_3
XFILLER_20_50 VGND VGND VPWR VPWR sky130_fd_sc_hd__decap_3
XFILLER_4_256 VGND VGND VPWR VPWR sky130_fd_sc_hd__decap_3
XFILLER_20_83 VGND VGND VPWR VPWR sky130_fd_sc_hd__fill_1
XFILLER_48_411 VGND VGND VPWR VPWR sky130_fd_sc_hd__decap_3
XFILLER_48_455 VGND VGND VPWR VPWR sky130_fd_sc_hd__decap_3
XFILLER_48_477 VGND VGND VPWR VPWR sky130_fd_sc_hd__decap_3
XFILLER_35_105 VGND VGND VPWR VPWR sky130_fd_sc_hd__decap_3
XFILLER_63_425 VGND VGND VPWR VPWR sky130_fd_sc_hd__decap_3
XFILLER_75_274 VGND VGND VPWR VPWR sky130_fd_sc_hd__decap_3
XFILLER_75_296 VGND VGND VPWR VPWR sky130_fd_sc_hd__decap_3
XTAP_TAPCELL_ROW_85_1006 VGND VPWR sky130_fd_sc_hd__tapvpwrvgnd_1
XTAP_TAPCELL_ROW_46_634 VGND VPWR sky130_fd_sc_hd__tapvpwrvgnd_1
XFILLER_90_200 VGND VGND VPWR VPWR sky130_fd_sc_hd__fill_2
XFILLER_63_458 VGND VGND VPWR VPWR sky130_fd_sc_hd__decap_3
XFILLER_16_363 VGND VGND VPWR VPWR sky130_fd_sc_hd__fill_1
XFILLER_16_374 VGND VGND VPWR VPWR sky130_fd_sc_hd__decap_3
XTAP_TAPCELL_ROW_18_369 VGND VPWR sky130_fd_sc_hd__tapvpwrvgnd_1
X_2830_ _2857_/A _4820_/B VGND VGND VPWR VPWR _2830_/X sky130_fd_sc_hd__and2_2
XFILLER_31_366 VGND VGND VPWR VPWR sky130_fd_sc_hd__decap_3
X_2761_ _2832_/A _2761_/B VGND VGND VPWR VPWR _2761_/X sky130_fd_sc_hd__or2_2
XFILLER_61_90 VGND VGND VPWR VPWR sky130_fd_sc_hd__decap_3
X_4500_ _4501_/B VGND VGND VPWR VPWR _4500_/Y sky130_fd_sc_hd__inv_2
X_2692_ _4659_/S _2693_/B VGND VGND VPWR VPWR _3779_/A sky130_fd_sc_hd__and2_2
X_4431_ _4377_/Y _4382_/B _4397_/C _4397_/D VGND VGND VPWR VPWR _4431_/X sky130_fd_sc_hd__a211o_2
XFILLER_6_85 VGND VGND VPWR VPWR sky130_fd_sc_hd__fill_2
X_4362_ _4362_/A _4376_/B VGND VGND VPWR VPWR _4386_/A sky130_fd_sc_hd__nand2_2
X_4293_ _3642_/A _4449_/S _4241_/Y VGND VGND VPWR VPWR _4293_/Y sky130_fd_sc_hd__o21ai_2
X_3313_ _5153_/Q _3315_/B VGND VGND VPWR VPWR _3313_/X sky130_fd_sc_hd__or2_2
X_3244_ _5170_/Q _4868_/A2 _4870_/B1 _3243_/X VGND VGND VPWR VPWR _5133_/D sky130_fd_sc_hd__o22a_2
XFILLER_39_433 VGND VGND VPWR VPWR sky130_fd_sc_hd__decap_3
XFILLER_39_455 VGND VGND VPWR VPWR sky130_fd_sc_hd__decap_3
XFILLER_66_241 VGND VGND VPWR VPWR sky130_fd_sc_hd__decap_3
X_3175_ _4692_/A _3175_/B VGND VGND VPWR VPWR _3175_/Y sky130_fd_sc_hd__nor2_4
XTAP_TAPCELL_ROW_1_215 VGND VPWR sky130_fd_sc_hd__tapvpwrvgnd_1
XFILLER_54_458 VGND VGND VPWR VPWR sky130_fd_sc_hd__decap_3
XFILLER_25_39 VGND VGND VPWR VPWR sky130_fd_sc_hd__decap_3
XFILLER_41_119 VGND VGND VPWR VPWR sky130_fd_sc_hd__decap_3
XTAP_TAPCELL_ROW_80_957 VGND VPWR sky130_fd_sc_hd__tapvpwrvgnd_1
XFILLER_22_377 VGND VGND VPWR VPWR sky130_fd_sc_hd__decap_3
XFILLER_10_539 VGND VGND VPWR VPWR sky130_fd_sc_hd__decap_3
XFILLER_41_38 VGND VGND VPWR VPWR sky130_fd_sc_hd__decap_3
X_2959_ _2914_/X _2970_/A2 _2954_/Y _4891_/Q VGND VGND VPWR VPWR _4891_/D sky130_fd_sc_hd__a22o_2
X_4629_ _4682_/S _4629_/B VGND VGND VPWR VPWR _4629_/Y sky130_fd_sc_hd__nand2_2
XFILLER_49_219 VGND VGND VPWR VPWR sky130_fd_sc_hd__decap_3
XFILLER_89_377 VGND VGND VPWR VPWR sky130_fd_sc_hd__fill_1
XFILLER_66_24 VGND VGND VPWR VPWR sky130_fd_sc_hd__decap_3
XFILLER_66_68 VGND VGND VPWR VPWR sky130_fd_sc_hd__decap_3
XFILLER_92_509 VGND VGND VPWR VPWR sky130_fd_sc_hd__decap_3
XFILLER_57_296 VGND VGND VPWR VPWR sky130_fd_sc_hd__decap_3
XFILLER_45_447 VGND VGND VPWR VPWR sky130_fd_sc_hd__fill_1
XFILLER_45_458 VGND VGND VPWR VPWR sky130_fd_sc_hd__decap_3
XFILLER_82_12 VGND VGND VPWR VPWR sky130_fd_sc_hd__decap_3
XFILLER_32_108 VGND VGND VPWR VPWR sky130_fd_sc_hd__decap_3
XFILLER_72_266 VGND VGND VPWR VPWR sky130_fd_sc_hd__decap_3
XFILLER_72_288 VGND VGND VPWR VPWR sky130_fd_sc_hd__fill_2
XFILLER_15_50 VGND VGND VPWR VPWR sky130_fd_sc_hd__fill_1
XFILLER_82_67 VGND VGND VPWR VPWR sky130_fd_sc_hd__decap_3
XFILLER_13_355 VGND VGND VPWR VPWR sky130_fd_sc_hd__decap_3
XFILLER_9_337 VGND VGND VPWR VPWR sky130_fd_sc_hd__decap_3
XFILLER_31_60 VGND VGND VPWR VPWR sky130_fd_sc_hd__decap_3
XFILLER_5_554 VGND VGND VPWR VPWR sky130_fd_sc_hd__decap_3
Xclkbuf_leaf_41_CLK clkbuf_leaf_5_CLK/A VGND VGND VPWR VPWR _5010_/CLK sky130_fd_sc_hd__clkbuf_8
Xoutput60 _5151_/Q VGND VGND VPWR VPWR INSTR_ADDR[14] sky130_fd_sc_hd__clkdlybuf4s25_1
XFILLER_68_506 VGND VGND VPWR VPWR sky130_fd_sc_hd__decap_3
Xoutput71 _2453_/X VGND VGND VPWR VPWR INVALID_MEM sky130_fd_sc_hd__clkdlybuf4s25_1
Xoutput82 _2702_/Y VGND VGND VPWR VPWR MEM_ADDR[15] sky130_fd_sc_hd__clkdlybuf4s25_1
Xoutput93 _2812_/X VGND VGND VPWR VPWR MEM_STR_DATA[10] sky130_fd_sc_hd__clkdlybuf4s25_1
XTAP_TAPCELL_ROW_91_1065 VGND VPWR sky130_fd_sc_hd__tapvpwrvgnd_1
XFILLER_0_281 VGND VGND VPWR VPWR sky130_fd_sc_hd__decap_3
XFILLER_76_550 VGND VGND VPWR VPWR sky130_fd_sc_hd__decap_3
XFILLER_36_403 VGND VGND VPWR VPWR sky130_fd_sc_hd__decap_3
XFILLER_36_436 VGND VGND VPWR VPWR sky130_fd_sc_hd__decap_3
XFILLER_48_296 VGND VGND VPWR VPWR sky130_fd_sc_hd__decap_3
XFILLER_63_244 VGND VGND VPWR VPWR sky130_fd_sc_hd__decap_3
XFILLER_91_553 VGND VGND VPWR VPWR sky130_fd_sc_hd__decap_3
XFILLER_23_119 VGND VGND VPWR VPWR sky130_fd_sc_hd__decap_3
X_4980_ _5008_/CLK _4980_/D VGND VGND VPWR VPWR _4980_/Q sky130_fd_sc_hd__dfxtp_2
XFILLER_44_480 VGND VGND VPWR VPWR sky130_fd_sc_hd__decap_3
X_3931_ _4016_/A _3931_/B VGND VGND VPWR VPWR _3931_/Y sky130_fd_sc_hd__nand2_2
X_3862_ _3825_/B _3866_/B _3861_/Y VGND VGND VPWR VPWR _3862_/X sky130_fd_sc_hd__o21a_2
X_2813_ _5074_/Q _5058_/Q _5042_/Q _5026_/Q _2851_/S0 _2854_/S1 VGND VGND VPWR VPWR
+ _2813_/X sky130_fd_sc_hd__mux4_2
XFILLER_31_196 VGND VGND VPWR VPWR sky130_fd_sc_hd__decap_3
X_3793_ _3828_/B _3793_/B VGND VGND VPWR VPWR _3793_/Y sky130_fd_sc_hd__nor2_2
X_2744_ _5114_/Q _5002_/Q _4986_/Q _4970_/Q _2818_/S0 _2854_/S1 VGND VGND VPWR VPWR
+ _2745_/B sky130_fd_sc_hd__mux4_2
X_2675_ _4961_/Q _4945_/Q _4929_/Q _4913_/Q _2676_/S0 _2676_/S1 VGND VGND VPWR VPWR
+ _2675_/X sky130_fd_sc_hd__mux4_2
XFILLER_8_392 VGND VGND VPWR VPWR sky130_fd_sc_hd__fill_2
X_4414_ _3747_/A _3619_/B _3778_/D _2599_/Y VGND VGND VPWR VPWR _4414_/X sky130_fd_sc_hd__o22a_2
Xclkbuf_leaf_32_CLK clkload0/A VGND VGND VPWR VPWR _5103_/CLK sky130_fd_sc_hd__clkbuf_8
X_4345_ _4345_/A _4345_/B _4345_/C VGND VGND VPWR VPWR _4345_/X sky130_fd_sc_hd__and3_2
X_4276_ _2705_/B _4259_/X _4274_/X _4275_/X _3366_/A VGND VGND VPWR VPWR _5225_/D
+ sky130_fd_sc_hd__o311a_2
XFILLER_67_550 VGND VGND VPWR VPWR sky130_fd_sc_hd__decap_3
X_3227_ _2950_/X _3227_/A2 _3211_/Y _5126_/Q VGND VGND VPWR VPWR _5126_/D sky130_fd_sc_hd__a22o_2
XFILLER_27_425 VGND VGND VPWR VPWR sky130_fd_sc_hd__decap_3
XFILLER_54_200 VGND VGND VPWR VPWR sky130_fd_sc_hd__fill_1
X_3158_ _2897_/X _3173_/A2 _3157_/Y _5063_/Q VGND VGND VPWR VPWR _5063_/D sky130_fd_sc_hd__a22o_2
XFILLER_27_469 VGND VGND VPWR VPWR sky130_fd_sc_hd__decap_3
XFILLER_36_38 VGND VGND VPWR VPWR sky130_fd_sc_hd__decap_3
XFILLER_54_233 VGND VGND VPWR VPWR sky130_fd_sc_hd__fill_2
XFILLER_42_417 VGND VGND VPWR VPWR sky130_fd_sc_hd__decap_3
X_3089_ _2914_/X _3100_/A2 _3084_/Y _5003_/Q VGND VGND VPWR VPWR _5003_/D sky130_fd_sc_hd__a22o_2
XFILLER_35_491 VGND VGND VPWR VPWR sky130_fd_sc_hd__decap_3
XFILLER_22_130 VGND VGND VPWR VPWR sky130_fd_sc_hd__decap_3
XFILLER_22_141 VGND VGND VPWR VPWR sky130_fd_sc_hd__decap_3
XFILLER_52_26 VGND VGND VPWR VPWR sky130_fd_sc_hd__fill_2
XFILLER_50_472 VGND VGND VPWR VPWR sky130_fd_sc_hd__decap_3
XFILLER_10_358 VGND VGND VPWR VPWR sky130_fd_sc_hd__decap_3
XFILLER_6_318 VGND VGND VPWR VPWR sky130_fd_sc_hd__decap_3
XFILLER_2_524 VGND VGND VPWR VPWR sky130_fd_sc_hd__decap_3
Xclkbuf_leaf_23_CLK clkload0/A VGND VGND VPWR VPWR _5215_/CLK sky130_fd_sc_hd__clkbuf_8
XFILLER_2_557 VGND VGND VPWR VPWR sky130_fd_sc_hd__fill_1
XFILLER_77_314 VGND VGND VPWR VPWR sky130_fd_sc_hd__decap_3
XFILLER_77_89 VGND VGND VPWR VPWR sky130_fd_sc_hd__decap_3
XFILLER_73_520 VGND VGND VPWR VPWR sky130_fd_sc_hd__decap_3
XFILLER_73_553 VGND VGND VPWR VPWR sky130_fd_sc_hd__decap_3
XFILLER_93_66 VGND VGND VPWR VPWR sky130_fd_sc_hd__decap_3
XTAP_TAPCELL_ROW_28_464 VGND VPWR sky130_fd_sc_hd__tapvpwrvgnd_1
XFILLER_93_88 VGND VGND VPWR VPWR sky130_fd_sc_hd__decap_3
XFILLER_26_71 VGND VGND VPWR VPWR sky130_fd_sc_hd__decap_3
XFILLER_60_214 VGND VGND VPWR VPWR sky130_fd_sc_hd__decap_3
XFILLER_13_141 VGND VGND VPWR VPWR sky130_fd_sc_hd__fill_2
XFILLER_41_461 VGND VGND VPWR VPWR sky130_fd_sc_hd__decap_3
XFILLER_5_340 VGND VGND VPWR VPWR sky130_fd_sc_hd__decap_3
Xclkbuf_leaf_14_CLK clkload1/A VGND VGND VPWR VPWR _5208_/CLK sky130_fd_sc_hd__clkbuf_8
X_2460_ _5183_/Q _5182_/Q _5181_/Q VGND VGND VPWR VPWR _3590_/B sky130_fd_sc_hd__or3_2
XFILLER_5_384 VGND VGND VPWR VPWR sky130_fd_sc_hd__decap_3
X_4130_ _4129_/Y _4080_/Y _4266_/S VGND VGND VPWR VPWR _4130_/X sky130_fd_sc_hd__mux2_1
XFILLER_68_336 VGND VGND VPWR VPWR sky130_fd_sc_hd__fill_1
X_4061_ _4011_/A _4011_/B _3740_/B _3615_/B VGND VGND VPWR VPWR _4062_/C sky130_fd_sc_hd__a211o_2
X_3012_ _2897_/X _3011_/B _3011_/Y _4935_/Q VGND VGND VPWR VPWR _4935_/D sky130_fd_sc_hd__a22o_2
XFILLER_83_317 VGND VGND VPWR VPWR sky130_fd_sc_hd__decap_3
XFILLER_64_531 VGND VGND VPWR VPWR sky130_fd_sc_hd__fill_1
XFILLER_76_380 VGND VGND VPWR VPWR sky130_fd_sc_hd__decap_3
XFILLER_36_277 VGND VGND VPWR VPWR sky130_fd_sc_hd__fill_2
XFILLER_17_491 VGND VGND VPWR VPWR sky130_fd_sc_hd__fill_1
XFILLER_24_439 VGND VGND VPWR VPWR sky130_fd_sc_hd__decap_3
XFILLER_36_299 VGND VGND VPWR VPWR sky130_fd_sc_hd__fill_2
X_4963_ clkload7/A _4963_/D VGND VGND VPWR VPWR _4963_/Q sky130_fd_sc_hd__dfxtp_2
X_3914_ _4692_/A _3914_/B VGND VGND VPWR VPWR _5211_/D sky130_fd_sc_hd__nor2_2
XFILLER_32_472 VGND VGND VPWR VPWR sky130_fd_sc_hd__decap_3
X_4894_ _5101_/CLK _4894_/D VGND VGND VPWR VPWR _4894_/Q sky130_fd_sc_hd__dfxtp_2
XTAP_TAPCELL_ROW_62_787 VGND VPWR sky130_fd_sc_hd__tapvpwrvgnd_1
X_3845_ _3815_/Y _3844_/A _3844_/B _2495_/Y VGND VGND VPWR VPWR _3845_/X sky130_fd_sc_hd__o31a_2
X_3776_ _3776_/A _3776_/B _4173_/A _3838_/A VGND VGND VPWR VPWR _3776_/X sky130_fd_sc_hd__or4_2
X_2727_ _5137_/Q _2727_/B VGND VGND VPWR VPWR _2727_/X sky130_fd_sc_hd__or2_2
X_2658_ _5074_/Q _5058_/Q _5042_/Q _5026_/Q _2672_/S0 _2672_/S1 VGND VGND VPWR VPWR
+ _2658_/X sky130_fd_sc_hd__mux4_2
X_2589_ _2589_/A _2589_/B VGND VGND VPWR VPWR _3820_/A sky130_fd_sc_hd__nor2_2
XFILLER_59_314 VGND VGND VPWR VPWR sky130_fd_sc_hd__decap_3
X_4328_ _4362_/A _4378_/B _4376_/A VGND VGND VPWR VPWR _4328_/X sky130_fd_sc_hd__a21o_2
XFILLER_59_358 VGND VGND VPWR VPWR sky130_fd_sc_hd__decap_3
XFILLER_74_306 VGND VGND VPWR VPWR sky130_fd_sc_hd__fill_2
X_4259_ _4687_/S _3654_/B _4257_/Y _4258_/X _4168_/A VGND VGND VPWR VPWR _4259_/X
+ sky130_fd_sc_hd__o311a_2
XFILLER_27_200 VGND VGND VPWR VPWR sky130_fd_sc_hd__decap_3
XFILLER_55_520 VGND VGND VPWR VPWR sky130_fd_sc_hd__decap_3
XFILLER_55_553 VGND VGND VPWR VPWR sky130_fd_sc_hd__decap_3
XFILLER_15_417 VGND VGND VPWR VPWR sky130_fd_sc_hd__decap_3
XFILLER_27_277 VGND VGND VPWR VPWR sky130_fd_sc_hd__decap_3
XFILLER_63_14 VGND VGND VPWR VPWR sky130_fd_sc_hd__fill_2
XFILLER_82_383 VGND VGND VPWR VPWR sky130_fd_sc_hd__decap_3
XFILLER_63_69 VGND VGND VPWR VPWR sky130_fd_sc_hd__decap_3
XFILLER_50_291 VGND VGND VPWR VPWR sky130_fd_sc_hd__decap_3
XFILLER_6_104 VGND VGND VPWR VPWR sky130_fd_sc_hd__decap_3
XFILLER_12_62 VGND VGND VPWR VPWR sky130_fd_sc_hd__decap_3
XFILLER_88_22 VGND VGND VPWR VPWR sky130_fd_sc_hd__decap_3
XFILLER_88_55 VGND VGND VPWR VPWR sky130_fd_sc_hd__decap_3
XFILLER_77_122 VGND VGND VPWR VPWR sky130_fd_sc_hd__decap_3
XFILLER_19_9 VGND VGND VPWR VPWR sky130_fd_sc_hd__decap_3
XFILLER_46_531 VGND VGND VPWR VPWR sky130_fd_sc_hd__fill_1
XFILLER_80_309 VGND VGND VPWR VPWR sky130_fd_sc_hd__decap_3
XFILLER_33_225 VGND VGND VPWR VPWR sky130_fd_sc_hd__decap_3
Xclkbuf_leaf_3_CLK clkbuf_leaf_5_CLK/A VGND VGND VPWR VPWR _5008_/CLK sky130_fd_sc_hd__clkbuf_8
XFILLER_14_472 VGND VGND VPWR VPWR sky130_fd_sc_hd__decap_3
XFILLER_14_494 VGND VGND VPWR VPWR sky130_fd_sc_hd__fill_1
X_3630_ _4376_/A _3630_/B VGND VGND VPWR VPWR _3631_/B sky130_fd_sc_hd__and2_2
X_3561_ _3961_/S _3561_/B VGND VGND VPWR VPWR _3561_/Y sky130_fd_sc_hd__nand2_2
X_2512_ _4963_/Q _4947_/Q _4931_/Q _4915_/Q _2676_/S0 _2676_/S1 VGND VGND VPWR VPWR
+ _2512_/X sky130_fd_sc_hd__mux4_2
X_3492_ _3492_/A _3492_/B VGND VGND VPWR VPWR _3492_/Y sky130_fd_sc_hd__xnor2_2
X_5231_ _5241_/CLK _5231_/D VGND VGND VPWR VPWR _5231_/Q sky130_fd_sc_hd__dfxtp_2
X_2443_ _3773_/A _5182_/Q _3884_/D _5181_/Q VGND VGND VPWR VPWR _2443_/X sky130_fd_sc_hd__or4b_2
X_5162_ _5271_/CLK _5162_/D VGND VGND VPWR VPWR _5162_/Q sky130_fd_sc_hd__dfxtp_2
X_4113_ _4090_/A _4090_/B _3726_/A VGND VGND VPWR VPWR _4115_/B sky130_fd_sc_hd__a21o_2
X_5093_ _5109_/CLK _5093_/D VGND VGND VPWR VPWR _5093_/Q sky130_fd_sc_hd__dfxtp_2
XTAP_TAPCELL_ROW_67_835 VGND VPWR sky130_fd_sc_hd__tapvpwrvgnd_1
XFILLER_49_391 VGND VGND VPWR VPWR sky130_fd_sc_hd__fill_1
XFILLER_56_339 VGND VGND VPWR VPWR sky130_fd_sc_hd__decap_3
X_4044_ _3926_/X _3929_/B _4044_/S VGND VGND VPWR VPWR _4044_/X sky130_fd_sc_hd__mux2_1
XFILLER_83_169 VGND VGND VPWR VPWR sky130_fd_sc_hd__decap_3
XFILLER_83_158 VGND VGND VPWR VPWR sky130_fd_sc_hd__decap_3
XFILLER_52_512 VGND VGND VPWR VPWR sky130_fd_sc_hd__fill_1
XFILLER_24_258 VGND VGND VPWR VPWR sky130_fd_sc_hd__decap_3
XFILLER_33_28 VGND VGND VPWR VPWR sky130_fd_sc_hd__decap_3
X_4946_ _4994_/CLK _4946_/D VGND VGND VPWR VPWR _4946_/Q sky130_fd_sc_hd__dfxtp_2
XTAP_TAPCELL_ROW_22_415 VGND VPWR sky130_fd_sc_hd__tapvpwrvgnd_1
X_4877_ _5101_/CLK _4877_/D VGND VGND VPWR VPWR _4877_/Q sky130_fd_sc_hd__dfxtp_2
XFILLER_20_475 VGND VGND VPWR VPWR sky130_fd_sc_hd__fill_1
X_3828_ _5160_/Q _3828_/B VGND VGND VPWR VPWR _3828_/Y sky130_fd_sc_hd__nor2_2
XFILLER_20_486 VGND VGND VPWR VPWR sky130_fd_sc_hd__decap_3
X_3759_ _4732_/A _4286_/A _4309_/S VGND VGND VPWR VPWR _3975_/S sky130_fd_sc_hd__mux2_1
XFILLER_59_111 VGND VGND VPWR VPWR sky130_fd_sc_hd__fill_1
XFILLER_87_420 VGND VGND VPWR VPWR sky130_fd_sc_hd__fill_1
XFILLER_59_144 VGND VGND VPWR VPWR sky130_fd_sc_hd__decap_3
XFILLER_87_464 VGND VGND VPWR VPWR sky130_fd_sc_hd__fill_1
XFILLER_47_328 VGND VGND VPWR VPWR sky130_fd_sc_hd__decap_3
XFILLER_87_486 VGND VGND VPWR VPWR sky130_fd_sc_hd__decap_3
XFILLER_28_542 VGND VGND VPWR VPWR sky130_fd_sc_hd__decap_3
XFILLER_74_24 VGND VGND VPWR VPWR sky130_fd_sc_hd__decap_3
XFILLER_55_361 VGND VGND VPWR VPWR sky130_fd_sc_hd__decap_3
XFILLER_62_309 VGND VGND VPWR VPWR sky130_fd_sc_hd__decap_3
XFILLER_74_35 VGND VGND VPWR VPWR sky130_fd_sc_hd__decap_3
XFILLER_74_68 VGND VGND VPWR VPWR sky130_fd_sc_hd__decap_3
XFILLER_15_225 VGND VGND VPWR VPWR sky130_fd_sc_hd__decap_3
XFILLER_70_375 VGND VGND VPWR VPWR sky130_fd_sc_hd__decap_3
XFILLER_11_442 VGND VGND VPWR VPWR sky130_fd_sc_hd__decap_3
XFILLER_30_239 VGND VGND VPWR VPWR sky130_fd_sc_hd__decap_3
XPHY_EDGE_ROW_4_Left_98 VGND VGND VPWR VPWR sky130_fd_sc_hd__decap_3
XFILLER_11_464 VGND VGND VPWR VPWR sky130_fd_sc_hd__decap_3
XFILLER_11_475 VGND VGND VPWR VPWR sky130_fd_sc_hd__decap_3
XFILLER_78_442 VGND VGND VPWR VPWR sky130_fd_sc_hd__decap_3
XFILLER_19_520 VGND VGND VPWR VPWR sky130_fd_sc_hd__decap_3
XTAP_TAPCELL_ROW_88_1037 VGND VPWR sky130_fd_sc_hd__tapvpwrvgnd_1
XFILLER_93_445 VGND VGND VPWR VPWR sky130_fd_sc_hd__decap_3
XFILLER_0_21 VGND VGND VPWR VPWR sky130_fd_sc_hd__decap_3
XFILLER_0_32 VGND VGND VPWR VPWR sky130_fd_sc_hd__decap_3
XFILLER_19_553 VGND VGND VPWR VPWR sky130_fd_sc_hd__decap_3
XFILLER_34_501 VGND VGND VPWR VPWR sky130_fd_sc_hd__decap_3
XFILLER_65_169 VGND VGND VPWR VPWR sky130_fd_sc_hd__decap_3
XTAP_TAPCELL_ROW_64_805 VGND VPWR sky130_fd_sc_hd__tapvpwrvgnd_1
XFILLER_93_489 VGND VGND VPWR VPWR sky130_fd_sc_hd__decap_3
XFILLER_61_353 VGND VGND VPWR VPWR sky130_fd_sc_hd__decap_3
X_4800_ _4800_/A _4800_/B VGND VGND VPWR VPWR _4814_/A sky130_fd_sc_hd__and2_2
XFILLER_21_217 VGND VGND VPWR VPWR sky130_fd_sc_hd__decap_3
XFILLER_21_228 VGND VGND VPWR VPWR sky130_fd_sc_hd__decap_3
X_2992_ _3028_/B _3192_/B VGND VGND VPWR VPWR _2992_/Y sky130_fd_sc_hd__nor2_4
XTAP_TAPCELL_ROW_72_882 VGND VPWR sky130_fd_sc_hd__tapvpwrvgnd_1
XFILLER_9_30 VGND VGND VPWR VPWR sky130_fd_sc_hd__decap_3
X_4731_ _4732_/A _4732_/B VGND VGND VPWR VPWR _4731_/X sky130_fd_sc_hd__and2_2
X_4662_ _4572_/S _4312_/Y _4551_/A _4661_/X VGND VGND VPWR VPWR _4662_/X sky130_fd_sc_hd__o31a_2
X_3613_ _4393_/D _3793_/B VGND VGND VPWR VPWR _4529_/S sky130_fd_sc_hd__nor2_2
X_4593_ _4199_/D _4261_/C _4686_/B1 _3776_/B _4592_/Y VGND VGND VPWR VPWR _4594_/C
+ sky130_fd_sc_hd__o221a_2
X_3544_ _3817_/B _3866_/B VGND VGND VPWR VPWR _4535_/A sky130_fd_sc_hd__or2_2
X_3475_ _3472_/A _3472_/B _3472_/C _3469_/A VGND VGND VPWR VPWR _3479_/A sky130_fd_sc_hd__o31a_2
XFILLER_88_206 VGND VGND VPWR VPWR sky130_fd_sc_hd__decap_3
X_5214_ _5215_/CLK _5214_/D VGND VGND VPWR VPWR _5214_/Q sky130_fd_sc_hd__dfxtp_2
X_2426_ _5189_/Q VGND VGND VPWR VPWR _3310_/S sky130_fd_sc_hd__inv_2
XFILLER_88_239 VGND VGND VPWR VPWR sky130_fd_sc_hd__decap_3
XFILLER_69_486 VGND VGND VPWR VPWR sky130_fd_sc_hd__decap_3
X_5145_ _5208_/CLK _5145_/D VGND VGND VPWR VPWR _5145_/Q sky130_fd_sc_hd__dfxtp_2
XFILLER_56_125 VGND VGND VPWR VPWR sky130_fd_sc_hd__decap_3
X_5076_ _5233_/CLK _5076_/D VGND VGND VPWR VPWR _5076_/Q sky130_fd_sc_hd__dfxtp_2
X_4027_ _4346_/B _4449_/S VGND VGND VPWR VPWR _4027_/Y sky130_fd_sc_hd__nand2_2
XFILLER_84_489 VGND VGND VPWR VPWR sky130_fd_sc_hd__decap_3
XFILLER_25_523 VGND VGND VPWR VPWR sky130_fd_sc_hd__decap_3
XFILLER_37_383 VGND VGND VPWR VPWR sky130_fd_sc_hd__decap_3
XFILLER_52_353 VGND VGND VPWR VPWR sky130_fd_sc_hd__fill_1
XFILLER_64_180 VGND VGND VPWR VPWR sky130_fd_sc_hd__fill_2
XFILLER_12_217 VGND VGND VPWR VPWR sky130_fd_sc_hd__decap_3
XFILLER_40_515 VGND VGND VPWR VPWR sky130_fd_sc_hd__decap_3
X_4929_ clkload3/A _4929_/D VGND VGND VPWR VPWR _4929_/Q sky130_fd_sc_hd__dfxtp_2
XFILLER_60_26 VGND VGND VPWR VPWR sky130_fd_sc_hd__fill_2
XFILLER_4_405 VGND VGND VPWR VPWR sky130_fd_sc_hd__decap_3
XFILLER_69_46 VGND VGND VPWR VPWR sky130_fd_sc_hd__decap_3
XFILLER_69_79 VGND VGND VPWR VPWR sky130_fd_sc_hd__decap_3
XTAP_TAPCELL_ROW_7_265 VGND VPWR sky130_fd_sc_hd__tapvpwrvgnd_1
XFILLER_75_401 VGND VGND VPWR VPWR sky130_fd_sc_hd__decap_3
XFILLER_87_261 VGND VGND VPWR VPWR sky130_fd_sc_hd__decap_3
XFILLER_85_12 VGND VGND VPWR VPWR sky130_fd_sc_hd__decap_3
XFILLER_75_489 VGND VGND VPWR VPWR sky130_fd_sc_hd__decap_3
XFILLER_28_361 VGND VGND VPWR VPWR sky130_fd_sc_hd__decap_3
XFILLER_28_383 VGND VGND VPWR VPWR sky130_fd_sc_hd__decap_3
XFILLER_62_139 VGND VGND VPWR VPWR sky130_fd_sc_hd__fill_1
XFILLER_43_320 VGND VGND VPWR VPWR sky130_fd_sc_hd__decap_3
XFILLER_43_364 VGND VGND VPWR VPWR sky130_fd_sc_hd__decap_3
XFILLER_70_150 VGND VGND VPWR VPWR sky130_fd_sc_hd__decap_3
XFILLER_34_60 VGND VGND VPWR VPWR sky130_fd_sc_hd__fill_1
XFILLER_11_250 VGND VGND VPWR VPWR sky130_fd_sc_hd__decap_3
XFILLER_86_9 VGND VGND VPWR VPWR sky130_fd_sc_hd__decap_3
XTAP_TAPCELL_ROW_41_587 VGND VPWR sky130_fd_sc_hd__tapvpwrvgnd_1
Xwire163 _2463_/B VGND VGND VPWR VPWR _4854_/A sky130_fd_sc_hd__clkbuf_4
XFILLER_7_254 VGND VGND VPWR VPWR sky130_fd_sc_hd__decap_3
XFILLER_50_81 VGND VGND VPWR VPWR sky130_fd_sc_hd__decap_3
X_3260_ _5139_/Q _3311_/S _3259_/X _3338_/B VGND VGND VPWR VPWR _5139_/D sky130_fd_sc_hd__o211a_2
XFILLER_66_412 VGND VGND VPWR VPWR sky130_fd_sc_hd__decap_3
X_3191_ _2950_/X _3191_/A2 _3191_/B1 _5094_/Q VGND VGND VPWR VPWR _5094_/D sky130_fd_sc_hd__a22o_2
XFILLER_15_3 VGND VGND VPWR VPWR sky130_fd_sc_hd__decap_3
XFILLER_38_136 VGND VGND VPWR VPWR sky130_fd_sc_hd__decap_3
XTAP_TAPCELL_ROW_77_930 VGND VPWR sky130_fd_sc_hd__tapvpwrvgnd_1
XFILLER_38_147 VGND VGND VPWR VPWR sky130_fd_sc_hd__fill_1
XFILLER_66_456 VGND VGND VPWR VPWR sky130_fd_sc_hd__decap_3
XTAP_TAPCELL_ROW_49_665 VGND VPWR sky130_fd_sc_hd__tapvpwrvgnd_1
XFILLER_93_253 VGND VGND VPWR VPWR sky130_fd_sc_hd__fill_1
XFILLER_53_139 VGND VGND VPWR VPWR sky130_fd_sc_hd__decap_3
XFILLER_66_489 VGND VGND VPWR VPWR sky130_fd_sc_hd__decap_3
XFILLER_61_150 VGND VGND VPWR VPWR sky130_fd_sc_hd__decap_3
XFILLER_22_548 VGND VGND VPWR VPWR sky130_fd_sc_hd__decap_3
XFILLER_61_172 VGND VGND VPWR VPWR sky130_fd_sc_hd__decap_3
XTAP_TAPCELL_ROW_32_510 VGND VPWR sky130_fd_sc_hd__tapvpwrvgnd_1
X_4714_ input48/X _4694_/Y _4713_/X _3366_/A VGND VGND VPWR VPWR _5251_/D sky130_fd_sc_hd__o211a_2
X_2975_ _2897_/X _2974_/B _2974_/Y _4903_/Q VGND VGND VPWR VPWR _4903_/D sky130_fd_sc_hd__a22o_2
XFILLER_30_29 VGND VGND VPWR VPWR sky130_fd_sc_hd__fill_1
X_4645_ _3567_/S _2521_/B _3778_/D _2518_/Y _4643_/Y VGND VGND VPWR VPWR _4647_/B
+ sky130_fd_sc_hd__o221a_2
X_4576_ _4575_/A _4543_/A _4681_/S VGND VGND VPWR VPWR _4629_/B sky130_fd_sc_hd__mux2_1
X_3527_ _3705_/A _3527_/B VGND VGND VPWR VPWR _3527_/X sky130_fd_sc_hd__or2_2
X_3458_ _3458_/A _3458_/B _3457_/X VGND VGND VPWR VPWR _3458_/X sky130_fd_sc_hd__or3b_2
X_3389_ _5158_/Q _5139_/Q VGND VGND VPWR VPWR _3393_/A sky130_fd_sc_hd__nand2_2
XFILLER_57_423 VGND VGND VPWR VPWR sky130_fd_sc_hd__decap_3
XFILLER_69_272 VGND VGND VPWR VPWR sky130_fd_sc_hd__decap_3
X_5128_ _5176_/CLK _5128_/D VGND VGND VPWR VPWR _5128_/Q sky130_fd_sc_hd__dfxtp_4
XTAP_TAPCELL_ROW_4_235 VGND VPWR sky130_fd_sc_hd__tapvpwrvgnd_1
XFILLER_72_404 VGND VGND VPWR VPWR sky130_fd_sc_hd__decap_3
XFILLER_84_253 VGND VGND VPWR VPWR sky130_fd_sc_hd__decap_3
XFILLER_44_117 VGND VGND VPWR VPWR sky130_fd_sc_hd__fill_2
XFILLER_55_37 VGND VGND VPWR VPWR sky130_fd_sc_hd__decap_3
X_5059_ _5110_/CLK _5059_/D VGND VGND VPWR VPWR _5059_/Q sky130_fd_sc_hd__dfxtp_2
XFILLER_25_320 VGND VGND VPWR VPWR sky130_fd_sc_hd__decap_3
XFILLER_72_448 VGND VGND VPWR VPWR sky130_fd_sc_hd__decap_3
XFILLER_25_364 VGND VGND VPWR VPWR sky130_fd_sc_hd__decap_3
XTAP_TAPCELL_ROW_83_988 VGND VPWR sky130_fd_sc_hd__tapvpwrvgnd_1
XFILLER_71_36 VGND VGND VPWR VPWR sky130_fd_sc_hd__decap_3
XFILLER_80_492 VGND VGND VPWR VPWR sky130_fd_sc_hd__decap_3
XFILLER_40_345 VGND VGND VPWR VPWR sky130_fd_sc_hd__fill_1
XFILLER_40_378 VGND VGND VPWR VPWR sky130_fd_sc_hd__decap_3
XFILLER_4_224 VGND VGND VPWR VPWR sky130_fd_sc_hd__fill_1
XFILLER_4_246 VGND VGND VPWR VPWR sky130_fd_sc_hd__decap_3
XFILLER_0_474 VGND VGND VPWR VPWR sky130_fd_sc_hd__fill_2
XFILLER_0_485 VGND VGND VPWR VPWR sky130_fd_sc_hd__decap_3
XFILLER_29_71 VGND VGND VPWR VPWR sky130_fd_sc_hd__fill_1
XFILLER_48_467 VGND VGND VPWR VPWR sky130_fd_sc_hd__decap_3
XFILLER_75_253 VGND VGND VPWR VPWR sky130_fd_sc_hd__decap_3
XTAP_TAPCELL_ROW_74_900 VGND VPWR sky130_fd_sc_hd__tapvpwrvgnd_1
XFILLER_48_489 VGND VGND VPWR VPWR sky130_fd_sc_hd__decap_3
XFILLER_63_437 VGND VGND VPWR VPWR sky130_fd_sc_hd__decap_3
XTAP_TAPCELL_ROW_85_1007 VGND VPWR sky130_fd_sc_hd__tapvpwrvgnd_1
XFILLER_16_342 VGND VGND VPWR VPWR sky130_fd_sc_hd__decap_3
XTAP_TAPCELL_ROW_46_635 VGND VPWR sky130_fd_sc_hd__tapvpwrvgnd_1
XFILLER_90_256 VGND VGND VPWR VPWR sky130_fd_sc_hd__fill_2
XFILLER_90_234 VGND VGND VPWR VPWR sky130_fd_sc_hd__fill_1
XFILLER_31_301 VGND VGND VPWR VPWR sky130_fd_sc_hd__decap_3
XFILLER_31_378 VGND VGND VPWR VPWR sky130_fd_sc_hd__decap_3
XFILLER_84_6 VGND VGND VPWR VPWR sky130_fd_sc_hd__decap_3
X_2760_ _5068_/Q _5052_/Q _5036_/Q _5020_/Q _2854_/S0 _2854_/S1 VGND VGND VPWR VPWR
+ _2761_/B sky130_fd_sc_hd__mux4_2
XFILLER_8_530 VGND VGND VPWR VPWR sky130_fd_sc_hd__fill_2
X_2691_ _4659_/S _2890_/A VGND VGND VPWR VPWR _2691_/Y sky130_fd_sc_hd__nand2_2
XFILLER_8_552 VGND VGND VPWR VPWR sky130_fd_sc_hd__decap_3
X_4430_ _4397_/C _4397_/D _4429_/X _4377_/Y VGND VGND VPWR VPWR _4430_/X sky130_fd_sc_hd__o31a_2
XFILLER_6_75 VGND VGND VPWR VPWR sky130_fd_sc_hd__decap_3
X_4361_ _4362_/A _4376_/B VGND VGND VPWR VPWR _4361_/Y sky130_fd_sc_hd__nor2_2
X_4292_ _4290_/Y _4291_/X _4515_/B VGND VGND VPWR VPWR _4292_/X sky130_fd_sc_hd__mux2_1
X_3312_ _3338_/B _3312_/B VGND VGND VPWR VPWR _5152_/D sky130_fd_sc_hd__and2_2
X_3243_ _5283_/Q _3338_/B input6/X VGND VGND VPWR VPWR _3243_/X sky130_fd_sc_hd__and3_2
XFILLER_86_518 VGND VGND VPWR VPWR sky130_fd_sc_hd__decap_3
XFILLER_66_220 VGND VGND VPWR VPWR sky130_fd_sc_hd__decap_3
XFILLER_39_445 VGND VGND VPWR VPWR sky130_fd_sc_hd__decap_3
XFILLER_39_467 VGND VGND VPWR VPWR sky130_fd_sc_hd__decap_3
X_3174_ _3192_/A _3174_/B VGND VGND VPWR VPWR _3175_/B sky130_fd_sc_hd__nor2_4
XFILLER_39_489 VGND VGND VPWR VPWR sky130_fd_sc_hd__decap_3
XFILLER_66_286 VGND VGND VPWR VPWR sky130_fd_sc_hd__decap_3
XFILLER_26_139 VGND VGND VPWR VPWR sky130_fd_sc_hd__fill_1
XFILLER_81_245 VGND VGND VPWR VPWR sky130_fd_sc_hd__decap_3
XFILLER_81_223 VGND VGND VPWR VPWR sky130_fd_sc_hd__fill_1
XFILLER_41_109 VGND VGND VPWR VPWR sky130_fd_sc_hd__decap_3
XFILLER_81_267 VGND VGND VPWR VPWR sky130_fd_sc_hd__decap_3
XFILLER_22_312 VGND VGND VPWR VPWR sky130_fd_sc_hd__decap_3
XFILLER_34_183 VGND VGND VPWR VPWR sky130_fd_sc_hd__fill_1
XTAP_TAPCELL_ROW_80_958 VGND VPWR sky130_fd_sc_hd__tapvpwrvgnd_1
XFILLER_22_345 VGND VGND VPWR VPWR sky130_fd_sc_hd__fill_1
X_2958_ _2911_/X _2970_/A2 _2954_/Y _4890_/Q VGND VGND VPWR VPWR _4890_/D sky130_fd_sc_hd__a22o_2
X_4628_ _4682_/S _4628_/B VGND VGND VPWR VPWR _4628_/X sky130_fd_sc_hd__or2_2
X_2889_ _4191_/C _2894_/A _2889_/C VGND VGND VPWR VPWR _2889_/X sky130_fd_sc_hd__and3b_2
X_4559_ _3363_/A _4213_/A _4559_/S VGND VGND VPWR VPWR _4559_/X sky130_fd_sc_hd__mux2_1
XFILLER_77_529 VGND VGND VPWR VPWR sky130_fd_sc_hd__decap_3
XFILLER_85_551 VGND VGND VPWR VPWR sky130_fd_sc_hd__decap_3
XFILLER_60_407 VGND VGND VPWR VPWR sky130_fd_sc_hd__decap_3
XFILLER_72_256 VGND VGND VPWR VPWR sky130_fd_sc_hd__fill_2
XFILLER_82_46 VGND VGND VPWR VPWR sky130_fd_sc_hd__decap_3
XFILLER_13_301 VGND VGND VPWR VPWR sky130_fd_sc_hd__decap_3
XFILLER_25_172 VGND VGND VPWR VPWR sky130_fd_sc_hd__decap_3
XFILLER_53_481 VGND VGND VPWR VPWR sky130_fd_sc_hd__fill_2
XFILLER_82_79 VGND VGND VPWR VPWR sky130_fd_sc_hd__decap_3
XFILLER_15_84 VGND VGND VPWR VPWR sky130_fd_sc_hd__decap_3
XFILLER_40_120 VGND VGND VPWR VPWR sky130_fd_sc_hd__decap_3
XFILLER_13_389 VGND VGND VPWR VPWR sky130_fd_sc_hd__decap_3
XTAP_TAPCELL_ROW_51_682 VGND VPWR sky130_fd_sc_hd__tapvpwrvgnd_1
XFILLER_40_197 VGND VGND VPWR VPWR sky130_fd_sc_hd__fill_2
XFILLER_31_72 VGND VGND VPWR VPWR sky130_fd_sc_hd__decap_3
XFILLER_5_533 VGND VGND VPWR VPWR sky130_fd_sc_hd__decap_3
Xoutput50 _2706_/X VGND VGND VPWR VPWR DEVICES_LDH sky130_fd_sc_hd__clkdlybuf4s25_1
Xoutput61 _5152_/Q VGND VGND VPWR VPWR INSTR_ADDR[15] sky130_fd_sc_hd__clkdlybuf4s25_1
Xoutput72 _2700_/X VGND VGND VPWR VPWR MAIN_LDH sky130_fd_sc_hd__clkdlybuf4s25_1
Xoutput83 _2863_/Y VGND VGND VPWR VPWR MEM_ADDR[1] sky130_fd_sc_hd__clkdlybuf4s25_1
Xoutput94 _2821_/X VGND VGND VPWR VPWR MEM_STR_DATA[11] sky130_fd_sc_hd__clkdlybuf4s25_1
XTAP_TAPCELL_ROW_91_1066 VGND VPWR sky130_fd_sc_hd__tapvpwrvgnd_1
XFILLER_0_271 VGND VGND VPWR VPWR sky130_fd_sc_hd__decap_3
XFILLER_48_253 VGND VGND VPWR VPWR sky130_fd_sc_hd__decap_3
XTAP_TAPCELL_ROW_59_760 VGND VPWR sky130_fd_sc_hd__tapvpwrvgnd_1
XFILLER_36_448 VGND VGND VPWR VPWR sky130_fd_sc_hd__fill_1
XFILLER_16_150 VGND VGND VPWR VPWR sky130_fd_sc_hd__fill_1
XFILLER_63_267 VGND VGND VPWR VPWR sky130_fd_sc_hd__decap_3
X_3930_ _3565_/X _3573_/X _3956_/S VGND VGND VPWR VPWR _3931_/B sky130_fd_sc_hd__mux2_1
XFILLER_44_492 VGND VGND VPWR VPWR sky130_fd_sc_hd__decap_3
X_3861_ _4397_/B _3866_/B VGND VGND VPWR VPWR _3861_/Y sky130_fd_sc_hd__nand2b_2
XFILLER_31_153 VGND VGND VPWR VPWR sky130_fd_sc_hd__decap_3
XFILLER_31_175 VGND VGND VPWR VPWR sky130_fd_sc_hd__decap_3
X_3792_ _4079_/A _3792_/B VGND VGND VPWR VPWR _4084_/B sky130_fd_sc_hd__nor2_2
X_2812_ _2857_/A _4799_/B VGND VGND VPWR VPWR _2812_/X sky130_fd_sc_hd__and2_2
XFILLER_82_3 VGND VGND VPWR VPWR sky130_fd_sc_hd__decap_3
X_2743_ _2741_/X _2742_/X _2855_/S VGND VGND VPWR VPWR _2743_/X sky130_fd_sc_hd__mux2_1
X_2674_ _2660_/A _2671_/X _5130_/Q VGND VGND VPWR VPWR _2674_/X sky130_fd_sc_hd__o21a_2
X_4413_ _3567_/S _2443_/X _4413_/S VGND VGND VPWR VPWR _4416_/B sky130_fd_sc_hd__mux2_1
X_4344_ _3567_/S _2860_/B _4341_/X _4343_/X VGND VGND VPWR VPWR _4345_/C sky130_fd_sc_hd__o211a_2
XFILLER_59_529 VGND VGND VPWR VPWR sky130_fd_sc_hd__decap_3
X_4275_ _5225_/Q _4275_/B VGND VGND VPWR VPWR _4275_/X sky130_fd_sc_hd__or2_2
XFILLER_86_315 VGND VGND VPWR VPWR sky130_fd_sc_hd__decap_3
XFILLER_39_242 VGND VGND VPWR VPWR sky130_fd_sc_hd__decap_3
X_3226_ _2947_/X _3211_/B _3211_/Y _5125_/Q VGND VGND VPWR VPWR _5125_/D sky130_fd_sc_hd__a22o_2
XFILLER_39_275 VGND VGND VPWR VPWR sky130_fd_sc_hd__decap_3
X_3157_ _4692_/A _3157_/B VGND VGND VPWR VPWR _3157_/Y sky130_fd_sc_hd__nor2_4
XPHY_EDGE_ROW_6_Left_100 VGND VGND VPWR VPWR sky130_fd_sc_hd__decap_3
XFILLER_82_521 VGND VGND VPWR VPWR sky130_fd_sc_hd__decap_3
XFILLER_27_437 VGND VGND VPWR VPWR sky130_fd_sc_hd__fill_2
XFILLER_82_554 VGND VGND VPWR VPWR sky130_fd_sc_hd__decap_3
XFILLER_14_109 VGND VGND VPWR VPWR sky130_fd_sc_hd__decap_3
XFILLER_42_407 VGND VGND VPWR VPWR sky130_fd_sc_hd__fill_1
X_3088_ _2911_/X _3100_/A2 _3084_/Y _5002_/Q VGND VGND VPWR VPWR _5002_/D sky130_fd_sc_hd__a22o_2
XFILLER_22_153 VGND VGND VPWR VPWR sky130_fd_sc_hd__decap_3
XTAP_TAPCELL_ROW_20_387 VGND VPWR sky130_fd_sc_hd__tapvpwrvgnd_1
XFILLER_2_503 VGND VGND VPWR VPWR sky130_fd_sc_hd__decap_3
XFILLER_2_536 VGND VGND VPWR VPWR sky130_fd_sc_hd__decap_3
XFILLER_89_175 VGND VGND VPWR VPWR sky130_fd_sc_hd__decap_3
XFILLER_77_57 VGND VGND VPWR VPWR sky130_fd_sc_hd__decap_3
XFILLER_77_337 VGND VGND VPWR VPWR sky130_fd_sc_hd__decap_3
XFILLER_77_326 VGND VGND VPWR VPWR sky130_fd_sc_hd__decap_3
XFILLER_92_307 VGND VGND VPWR VPWR sky130_fd_sc_hd__fill_1
XFILLER_45_201 VGND VGND VPWR VPWR sky130_fd_sc_hd__decap_3
XFILLER_93_12 VGND VGND VPWR VPWR sky130_fd_sc_hd__fill_2
XFILLER_92_318 VGND VGND VPWR VPWR sky130_fd_sc_hd__fill_2
XFILLER_73_532 VGND VGND VPWR VPWR sky130_fd_sc_hd__decap_3
XTAP_TAPCELL_ROW_56_730 VGND VPWR sky130_fd_sc_hd__tapvpwrvgnd_1
XFILLER_26_50 VGND VGND VPWR VPWR sky130_fd_sc_hd__decap_3
XTAP_TAPCELL_ROW_28_465 VGND VPWR sky130_fd_sc_hd__tapvpwrvgnd_1
XFILLER_93_78 VGND VGND VPWR VPWR sky130_fd_sc_hd__decap_3
XFILLER_26_83 VGND VGND VPWR VPWR sky130_fd_sc_hd__fill_1
XFILLER_33_429 VGND VGND VPWR VPWR sky130_fd_sc_hd__decap_3
XFILLER_60_226 VGND VGND VPWR VPWR sky130_fd_sc_hd__decap_3
XFILLER_26_94 VGND VGND VPWR VPWR sky130_fd_sc_hd__decap_3
XFILLER_60_259 VGND VGND VPWR VPWR sky130_fd_sc_hd__decap_3
XFILLER_41_473 VGND VGND VPWR VPWR sky130_fd_sc_hd__decap_3
XFILLER_9_113 VGND VGND VPWR VPWR sky130_fd_sc_hd__decap_3
XFILLER_41_495 VGND VGND VPWR VPWR sky130_fd_sc_hd__fill_1
XTAP_TAPCELL_ROW_11_310 VGND VPWR sky130_fd_sc_hd__tapvpwrvgnd_1
XFILLER_3_32 VGND VGND VPWR VPWR sky130_fd_sc_hd__decap_3
XFILLER_68_315 VGND VGND VPWR VPWR sky130_fd_sc_hd__decap_3
XPHY_EDGE_ROW_79_Left_173 VGND VGND VPWR VPWR sky130_fd_sc_hd__decap_3
XFILLER_3_98 VGND VGND VPWR VPWR sky130_fd_sc_hd__decap_3
XFILLER_49_540 VGND VGND VPWR VPWR sky130_fd_sc_hd__decap_3
XFILLER_49_551 VGND VGND VPWR VPWR sky130_fd_sc_hd__decap_3
X_4060_ _4191_/A _2873_/B _4055_/X _4059_/X VGND VGND VPWR VPWR _4060_/X sky130_fd_sc_hd__o211a_2
X_3011_ _3494_/A _3011_/B VGND VGND VPWR VPWR _3011_/Y sky130_fd_sc_hd__nor2_4
XFILLER_36_256 VGND VGND VPWR VPWR sky130_fd_sc_hd__decap_3
XFILLER_64_554 VGND VGND VPWR VPWR sky130_fd_sc_hd__decap_3
XFILLER_91_351 VGND VGND VPWR VPWR sky130_fd_sc_hd__fill_2
XFILLER_17_470 VGND VGND VPWR VPWR sky130_fd_sc_hd__decap_3
X_4962_ _5010_/CLK _4962_/D VGND VGND VPWR VPWR _4962_/Q sky130_fd_sc_hd__dfxtp_2
X_4893_ _5101_/CLK _4893_/D VGND VGND VPWR VPWR _4893_/Q sky130_fd_sc_hd__dfxtp_2
X_3913_ _5211_/Q _4854_/B _3911_/X _3912_/Y VGND VGND VPWR VPWR _3914_/B sky130_fd_sc_hd__o2bb2a_2
X_3844_ _3844_/A _3844_/B VGND VGND VPWR VPWR _3844_/Y sky130_fd_sc_hd__nor2_2
XTAP_TAPCELL_ROW_62_788 VGND VPWR sky130_fd_sc_hd__tapvpwrvgnd_1
XPHY_EDGE_ROW_88_Left_182 VGND VGND VPWR VPWR sky130_fd_sc_hd__decap_3
XFILLER_32_495 VGND VGND VPWR VPWR sky130_fd_sc_hd__decap_3
X_3775_ _3986_/A _3775_/B _3831_/A _4086_/A VGND VGND VPWR VPWR _3779_/C sky130_fd_sc_hd__or4_2
X_2726_ _5112_/Q _5000_/Q _4984_/Q _4968_/Q _2818_/S0 _5136_/Q VGND VGND VPWR VPWR
+ _2727_/B sky130_fd_sc_hd__mux4_2
XFILLER_8_190 VGND VGND VPWR VPWR sky130_fd_sc_hd__decap_3
X_2657_ _3776_/A _3776_/B VGND VGND VPWR VPWR _2684_/A sky130_fd_sc_hd__nand2_2
X_2588_ _5158_/Q _4357_/A VGND VGND VPWR VPWR _2589_/B sky130_fd_sc_hd__nor2_2
X_4327_ _4327_/A _4327_/B VGND VGND VPWR VPWR _4334_/B sky130_fd_sc_hd__or2_2
X_4258_ _4239_/A _4235_/B _4261_/A _3665_/B VGND VGND VPWR VPWR _4258_/X sky130_fd_sc_hd__a211o_2
XFILLER_86_156 VGND VGND VPWR VPWR sky130_fd_sc_hd__decap_3
X_3209_ _2950_/X _3193_/B _3193_/Y _5110_/Q VGND VGND VPWR VPWR _5110_/D sky130_fd_sc_hd__a22o_2
XFILLER_27_223 VGND VGND VPWR VPWR sky130_fd_sc_hd__fill_1
XFILLER_67_381 VGND VGND VPWR VPWR sky130_fd_sc_hd__decap_3
X_4189_ _4189_/A _4214_/B VGND VGND VPWR VPWR _4189_/Y sky130_fd_sc_hd__nand2_2
XFILLER_27_256 VGND VGND VPWR VPWR sky130_fd_sc_hd__decap_3
XFILLER_82_340 VGND VGND VPWR VPWR sky130_fd_sc_hd__decap_3
XFILLER_82_395 VGND VGND VPWR VPWR sky130_fd_sc_hd__decap_3
XTAP_TAPCELL_ROW_25_435 VGND VPWR sky130_fd_sc_hd__tapvpwrvgnd_1
XFILLER_10_189 VGND VGND VPWR VPWR sky130_fd_sc_hd__decap_3
XFILLER_88_12 VGND VGND VPWR VPWR sky130_fd_sc_hd__decap_3
XFILLER_2_355 VGND VGND VPWR VPWR sky130_fd_sc_hd__fill_1
XFILLER_77_156 VGND VGND VPWR VPWR sky130_fd_sc_hd__decap_3
XFILLER_77_134 VGND VGND VPWR VPWR sky130_fd_sc_hd__decap_3
XFILLER_46_510 VGND VGND VPWR VPWR sky130_fd_sc_hd__decap_3
XFILLER_92_115 VGND VGND VPWR VPWR sky130_fd_sc_hd__fill_2
XFILLER_77_178 VGND VGND VPWR VPWR sky130_fd_sc_hd__decap_3
XFILLER_37_60 VGND VGND VPWR VPWR sky130_fd_sc_hd__decap_3
XFILLER_18_256 VGND VGND VPWR VPWR sky130_fd_sc_hd__decap_3
XFILLER_61_502 VGND VGND VPWR VPWR sky130_fd_sc_hd__fill_2
XPHY_EDGE_ROW_16_Right_16 VGND VGND VPWR VPWR sky130_fd_sc_hd__decap_3
XFILLER_61_524 VGND VGND VPWR VPWR sky130_fd_sc_hd__fill_1
XFILLER_61_535 VGND VGND VPWR VPWR sky130_fd_sc_hd__fill_1
XFILLER_73_373 VGND VGND VPWR VPWR sky130_fd_sc_hd__fill_1
XFILLER_73_384 VGND VGND VPWR VPWR sky130_fd_sc_hd__decap_3
XFILLER_61_557 VGND VGND VPWR VPWR sky130_fd_sc_hd__fill_1
XFILLER_53_81 VGND VGND VPWR VPWR sky130_fd_sc_hd__fill_1
XFILLER_41_281 VGND VGND VPWR VPWR sky130_fd_sc_hd__decap_3
X_3560_ _4320_/B _4320_/A _3905_/B VGND VGND VPWR VPWR _3561_/B sky130_fd_sc_hd__mux2_1
XPHY_EDGE_ROW_25_Right_25 VGND VGND VPWR VPWR sky130_fd_sc_hd__decap_3
X_2511_ _2660_/A _2508_/X _5130_/Q VGND VGND VPWR VPWR _2511_/X sky130_fd_sc_hd__o21a_2
X_5230_ _5233_/CLK _5230_/D VGND VGND VPWR VPWR _5230_/Q sky130_fd_sc_hd__dfxtp_2
X_3491_ _5171_/Q _5152_/Q VGND VGND VPWR VPWR _3492_/B sky130_fd_sc_hd__xor2_2
XFILLER_45_3 VGND VGND VPWR VPWR sky130_fd_sc_hd__decap_3
X_2442_ _5182_/Q _5181_/Q _3891_/A _5183_/Q VGND VGND VPWR VPWR _4236_/A sky130_fd_sc_hd__and4b_2
X_5161_ _5271_/CLK _5161_/D VGND VGND VPWR VPWR _5161_/Q sky130_fd_sc_hd__dfxtp_2
XFILLER_68_123 VGND VGND VPWR VPWR sky130_fd_sc_hd__decap_3
XFILLER_68_134 VGND VGND VPWR VPWR sky130_fd_sc_hd__decap_3
X_4112_ _4261_/C _4094_/X _4108_/Y _4111_/X VGND VGND VPWR VPWR _4112_/X sky130_fd_sc_hd__o211a_2
X_5092_ clkload6/A _5092_/D VGND VGND VPWR VPWR _5092_/Q sky130_fd_sc_hd__dfxtp_2
XFILLER_68_156 VGND VGND VPWR VPWR sky130_fd_sc_hd__decap_3
X_4043_ _4078_/A _4078_/B _3917_/X _4042_/X _4225_/A VGND VGND VPWR VPWR _4055_/A
+ sky130_fd_sc_hd__o32a_2
XFILLER_49_370 VGND VGND VPWR VPWR sky130_fd_sc_hd__decap_3
XTAP_TAPCELL_ROW_67_836 VGND VPWR sky130_fd_sc_hd__tapvpwrvgnd_1
XPHY_EDGE_ROW_34_Right_34 VGND VGND VPWR VPWR sky130_fd_sc_hd__decap_3
XFILLER_64_340 VGND VGND VPWR VPWR sky130_fd_sc_hd__decap_3
XFILLER_64_362 VGND VGND VPWR VPWR sky130_fd_sc_hd__fill_2
XFILLER_64_395 VGND VGND VPWR VPWR sky130_fd_sc_hd__fill_1
XFILLER_52_557 VGND VGND VPWR VPWR sky130_fd_sc_hd__fill_1
X_4945_ clkload5/A _4945_/D VGND VGND VPWR VPWR _4945_/Q sky130_fd_sc_hd__dfxtp_2
XFILLER_20_421 VGND VGND VPWR VPWR sky130_fd_sc_hd__decap_3
X_4876_ _5114_/CLK _4876_/D VGND VGND VPWR VPWR _4876_/Q sky130_fd_sc_hd__dfxtp_2
X_3827_ _5162_/Q _4079_/A _4086_/A _3825_/Y VGND VGND VPWR VPWR _3827_/X sky130_fd_sc_hd__o31a_2
XPHY_EDGE_ROW_43_Right_43 VGND VGND VPWR VPWR sky130_fd_sc_hd__decap_3
XFILLER_20_498 VGND VGND VPWR VPWR sky130_fd_sc_hd__decap_3
X_3758_ _3817_/B _4449_/S VGND VGND VPWR VPWR _3760_/A sky130_fd_sc_hd__or2_2
XTAP_TAPCELL_ROW_30_482 VGND VPWR sky130_fd_sc_hd__tapvpwrvgnd_1
X_2709_ _3494_/A _2709_/B VGND VGND VPWR VPWR _5285_/D sky130_fd_sc_hd__nor2_2
X_3689_ _3834_/B _3788_/B VGND VGND VPWR VPWR _3689_/X sky130_fd_sc_hd__or2_2
XFILLER_87_432 VGND VGND VPWR VPWR sky130_fd_sc_hd__decap_3
XFILLER_47_307 VGND VGND VPWR VPWR sky130_fd_sc_hd__decap_3
XFILLER_59_156 VGND VGND VPWR VPWR sky130_fd_sc_hd__decap_3
XPHY_EDGE_ROW_52_Right_52 VGND VGND VPWR VPWR sky130_fd_sc_hd__decap_3
XFILLER_28_521 VGND VGND VPWR VPWR sky130_fd_sc_hd__decap_3
XFILLER_74_115 VGND VGND VPWR VPWR sky130_fd_sc_hd__decap_3
XFILLER_87_498 VGND VGND VPWR VPWR sky130_fd_sc_hd__decap_3
XFILLER_28_554 VGND VGND VPWR VPWR sky130_fd_sc_hd__decap_3
XFILLER_55_340 VGND VGND VPWR VPWR sky130_fd_sc_hd__decap_3
XFILLER_74_47 VGND VGND VPWR VPWR sky130_fd_sc_hd__fill_1
XFILLER_15_204 VGND VGND VPWR VPWR sky130_fd_sc_hd__fill_2
XFILLER_55_373 VGND VGND VPWR VPWR sky130_fd_sc_hd__decap_3
XFILLER_70_321 VGND VGND VPWR VPWR sky130_fd_sc_hd__decap_3
XTAP_TAPCELL_ROW_38_560 VGND VPWR sky130_fd_sc_hd__tapvpwrvgnd_1
XFILLER_15_237 VGND VGND VPWR VPWR sky130_fd_sc_hd__decap_3
XFILLER_70_343 VGND VGND VPWR VPWR sky130_fd_sc_hd__decap_3
XFILLER_82_181 VGND VGND VPWR VPWR sky130_fd_sc_hd__decap_3
XFILLER_70_387 VGND VGND VPWR VPWR sky130_fd_sc_hd__fill_1
XFILLER_90_35 VGND VGND VPWR VPWR sky130_fd_sc_hd__decap_3
XFILLER_11_410 VGND VGND VPWR VPWR sky130_fd_sc_hd__decap_3
XFILLER_23_281 VGND VGND VPWR VPWR sky130_fd_sc_hd__fill_1
XPHY_EDGE_ROW_61_Right_61 VGND VGND VPWR VPWR sky130_fd_sc_hd__decap_3
XFILLER_23_51 VGND VGND VPWR VPWR sky130_fd_sc_hd__decap_3
XFILLER_7_436 VGND VGND VPWR VPWR sky130_fd_sc_hd__decap_3
XFILLER_7_469 VGND VGND VPWR VPWR sky130_fd_sc_hd__fill_1
XFILLER_2_141 VGND VGND VPWR VPWR sky130_fd_sc_hd__decap_3
XFILLER_31_9 VGND VGND VPWR VPWR sky130_fd_sc_hd__decap_3
XPHY_EDGE_ROW_70_Right_70 VGND VGND VPWR VPWR sky130_fd_sc_hd__decap_3
XFILLER_78_421 VGND VGND VPWR VPWR sky130_fd_sc_hd__decap_3
XFILLER_78_454 VGND VGND VPWR VPWR sky130_fd_sc_hd__decap_3
XFILLER_38_318 VGND VGND VPWR VPWR sky130_fd_sc_hd__decap_3
XFILLER_65_104 VGND VGND VPWR VPWR sky130_fd_sc_hd__fill_2
XTAP_TAPCELL_ROW_88_1038 VGND VPWR sky130_fd_sc_hd__tapvpwrvgnd_1
XFILLER_93_424 VGND VGND VPWR VPWR sky130_fd_sc_hd__decap_3
XFILLER_65_148 VGND VGND VPWR VPWR sky130_fd_sc_hd__decap_3
XTAP_TAPCELL_ROW_64_806 VGND VPWR sky130_fd_sc_hd__tapvpwrvgnd_1
XFILLER_0_66 VGND VGND VPWR VPWR sky130_fd_sc_hd__decap_3
XFILLER_80_129 VGND VGND VPWR VPWR sky130_fd_sc_hd__decap_3
XFILLER_0_88 VGND VGND VPWR VPWR sky130_fd_sc_hd__decap_3
XFILLER_61_321 VGND VGND VPWR VPWR sky130_fd_sc_hd__fill_1
XFILLER_61_343 VGND VGND VPWR VPWR sky130_fd_sc_hd__fill_2
XFILLER_73_181 VGND VGND VPWR VPWR sky130_fd_sc_hd__decap_3
XFILLER_61_365 VGND VGND VPWR VPWR sky130_fd_sc_hd__fill_2
XFILLER_61_376 VGND VGND VPWR VPWR sky130_fd_sc_hd__decap_3
X_2991_ _5190_/Q _5191_/Q VGND VGND VPWR VPWR _3192_/B sky130_fd_sc_hd__nand2b_2
XTAP_TAPCELL_ROW_72_883 VGND VPWR sky130_fd_sc_hd__tapvpwrvgnd_1
X_4730_ _5258_/Q _4847_/B _4729_/Y _3338_/B VGND VGND VPWR VPWR _5258_/D sky130_fd_sc_hd__o211a_2
XFILLER_9_53 VGND VGND VPWR VPWR sky130_fd_sc_hd__decap_3
XFILLER_9_42 VGND VGND VPWR VPWR sky130_fd_sc_hd__fill_2
X_4661_ _4227_/D _4661_/B _4661_/C _4661_/D VGND VGND VPWR VPWR _4661_/X sky130_fd_sc_hd__and4b_2
XFILLER_9_64 VGND VGND VPWR VPWR sky130_fd_sc_hd__decap_3
X_3612_ _3606_/X _3608_/X _3611_/X _2430_/Y VGND VGND VPWR VPWR _3793_/B sky130_fd_sc_hd__a22o_2
X_4592_ _4168_/A _3714_/A _4155_/B _4684_/B1 VGND VGND VPWR VPWR _4592_/Y sky130_fd_sc_hd__a22oi_2
XFILLER_6_480 VGND VGND VPWR VPWR sky130_fd_sc_hd__decap_3
X_3543_ _3867_/A _4390_/A _3866_/B VGND VGND VPWR VPWR _3543_/X sky130_fd_sc_hd__mux2_1
X_3474_ _3494_/A _3474_/B VGND VGND VPWR VPWR _5206_/D sky130_fd_sc_hd__nor2_2
X_5213_ _5241_/CLK _5213_/D VGND VGND VPWR VPWR _5213_/Q sky130_fd_sc_hd__dfxtp_2
X_2425_ _5195_/Q VGND VGND VPWR VPWR _2425_/Y sky130_fd_sc_hd__inv_2
X_5144_ _5208_/CLK _5144_/D VGND VGND VPWR VPWR _5144_/Q sky130_fd_sc_hd__dfxtp_2
X_5075_ _5110_/CLK _5075_/D VGND VGND VPWR VPWR _5075_/Q sky130_fd_sc_hd__dfxtp_2
XFILLER_37_351 VGND VGND VPWR VPWR sky130_fd_sc_hd__decap_3
X_4026_ _4078_/B _3854_/X _4025_/Y _4225_/A VGND VGND VPWR VPWR _4026_/X sky130_fd_sc_hd__a211o_2
XFILLER_84_457 VGND VGND VPWR VPWR sky130_fd_sc_hd__decap_3
XTAP_TAPCELL_ROW_35_530 VGND VPWR sky130_fd_sc_hd__tapvpwrvgnd_1
XFILLER_52_387 VGND VGND VPWR VPWR sky130_fd_sc_hd__decap_3
X_4928_ _4994_/CLK _4928_/D VGND VGND VPWR VPWR _4928_/Q sky130_fd_sc_hd__dfxtp_2
X_4859_ _5168_/Q _4868_/A2 _3230_/Y _3239_/X VGND VGND VPWR VPWR _5168_/D sky130_fd_sc_hd__o22a_2
XFILLER_4_417 VGND VGND VPWR VPWR sky130_fd_sc_hd__decap_3
XFILLER_4_439 VGND VGND VPWR VPWR sky130_fd_sc_hd__decap_3
XFILLER_79_218 VGND VGND VPWR VPWR sky130_fd_sc_hd__decap_3
XTAP_TAPCELL_ROW_7_266 VGND VPWR sky130_fd_sc_hd__tapvpwrvgnd_1
XFILLER_85_35 VGND VGND VPWR VPWR sky130_fd_sc_hd__decap_3
XFILLER_75_424 VGND VGND VPWR VPWR sky130_fd_sc_hd__decap_3
XFILLER_87_295 VGND VGND VPWR VPWR sky130_fd_sc_hd__decap_3
XFILLER_87_273 VGND VGND VPWR VPWR sky130_fd_sc_hd__decap_3
XFILLER_75_468 VGND VGND VPWR VPWR sky130_fd_sc_hd__decap_3
XFILLER_16_513 VGND VGND VPWR VPWR sky130_fd_sc_hd__decap_3
XFILLER_18_73 VGND VGND VPWR VPWR sky130_fd_sc_hd__decap_3
XFILLER_28_395 VGND VGND VPWR VPWR sky130_fd_sc_hd__decap_3
XFILLER_43_332 VGND VGND VPWR VPWR sky130_fd_sc_hd__decap_3
XFILLER_43_343 VGND VGND VPWR VPWR sky130_fd_sc_hd__decap_3
XFILLER_55_192 VGND VGND VPWR VPWR sky130_fd_sc_hd__decap_3
XFILLER_43_376 VGND VGND VPWR VPWR sky130_fd_sc_hd__decap_3
XFILLER_11_262 VGND VGND VPWR VPWR sky130_fd_sc_hd__decap_3
XFILLER_11_284 VGND VGND VPWR VPWR sky130_fd_sc_hd__decap_3
XTAP_TAPCELL_ROW_41_588 VGND VPWR sky130_fd_sc_hd__tapvpwrvgnd_1
XFILLER_3_472 VGND VGND VPWR VPWR sky130_fd_sc_hd__decap_3
X_3190_ _2947_/X _3175_/B _3175_/Y _5093_/Q VGND VGND VPWR VPWR _5093_/D sky130_fd_sc_hd__a22o_2
XFILLER_78_262 VGND VGND VPWR VPWR sky130_fd_sc_hd__decap_3
XFILLER_78_240 VGND VGND VPWR VPWR sky130_fd_sc_hd__decap_3
XFILLER_66_435 VGND VGND VPWR VPWR sky130_fd_sc_hd__decap_3
XTAP_TAPCELL_ROW_77_931 VGND VPWR sky130_fd_sc_hd__tapvpwrvgnd_1
XFILLER_78_284 VGND VGND VPWR VPWR sky130_fd_sc_hd__decap_3
XFILLER_19_340 VGND VGND VPWR VPWR sky130_fd_sc_hd__decap_3
XTAP_TAPCELL_ROW_49_666 VGND VPWR sky130_fd_sc_hd__tapvpwrvgnd_1
XFILLER_81_405 VGND VGND VPWR VPWR sky130_fd_sc_hd__decap_3
XFILLER_81_416 VGND VGND VPWR VPWR sky130_fd_sc_hd__fill_2
XFILLER_81_449 VGND VGND VPWR VPWR sky130_fd_sc_hd__decap_3
XFILLER_34_365 VGND VGND VPWR VPWR sky130_fd_sc_hd__fill_1
XFILLER_34_398 VGND VGND VPWR VPWR sky130_fd_sc_hd__decap_3
XFILLER_61_184 VGND VGND VPWR VPWR sky130_fd_sc_hd__decap_3
X_2974_ _3494_/A _2974_/B VGND VGND VPWR VPWR _2974_/Y sky130_fd_sc_hd__nor2_4
X_4713_ _5251_/Q _4725_/B VGND VGND VPWR VPWR _4713_/X sky130_fd_sc_hd__or2_2
X_4644_ _3363_/A _4213_/A _4644_/S VGND VGND VPWR VPWR _4644_/X sky130_fd_sc_hd__mux2_1
XPHY_EDGE_ROW_15_Left_109 VGND VGND VPWR VPWR sky130_fd_sc_hd__decap_3
X_4575_ _4575_/A VGND VGND VPWR VPWR _4575_/Y sky130_fd_sc_hd__inv_2
X_3526_ _4887_/Q _4871_/Q _5095_/Q _5079_/Q _3706_/S0 _3706_/S1 VGND VGND VPWR VPWR
+ _3527_/B sky130_fd_sc_hd__mux4_2
XFILLER_89_505 VGND VGND VPWR VPWR sky130_fd_sc_hd__decap_3
X_3457_ _3457_/A _3457_/B _3457_/C VGND VGND VPWR VPWR _3457_/X sky130_fd_sc_hd__or3_2
XFILLER_57_402 VGND VGND VPWR VPWR sky130_fd_sc_hd__decap_3
X_3388_ _5196_/Q _4854_/B VGND VGND VPWR VPWR _3388_/Y sky130_fd_sc_hd__nand2_2
XFILLER_57_435 VGND VGND VPWR VPWR sky130_fd_sc_hd__decap_3
XFILLER_69_284 VGND VGND VPWR VPWR sky130_fd_sc_hd__decap_3
X_5127_ _5176_/CLK _5127_/D VGND VGND VPWR VPWR _5127_/Q sky130_fd_sc_hd__dfxtp_4
XTAP_TAPCELL_ROW_4_236 VGND VPWR sky130_fd_sc_hd__tapvpwrvgnd_1
XPHY_EDGE_ROW_24_Left_118 VGND VGND VPWR VPWR sky130_fd_sc_hd__decap_3
XFILLER_29_148 VGND VGND VPWR VPWR sky130_fd_sc_hd__decap_3
X_5058_ clkload8/A _5058_/D VGND VGND VPWR VPWR _5058_/Q sky130_fd_sc_hd__dfxtp_2
XPHY_EDGE_ROW_2_Right_2 VGND VGND VPWR VPWR sky130_fd_sc_hd__decap_3
XFILLER_55_49 VGND VGND VPWR VPWR sky130_fd_sc_hd__decap_3
X_4009_ _4011_/A _4011_/B VGND VGND VPWR VPWR _4009_/X sky130_fd_sc_hd__and2_2
XFILLER_84_287 VGND VGND VPWR VPWR sky130_fd_sc_hd__decap_3
XFILLER_25_332 VGND VGND VPWR VPWR sky130_fd_sc_hd__decap_3
XTAP_TAPCELL_ROW_83_989 VGND VPWR sky130_fd_sc_hd__tapvpwrvgnd_1
XFILLER_80_460 VGND VGND VPWR VPWR sky130_fd_sc_hd__decap_3
XFILLER_13_549 VGND VGND VPWR VPWR sky130_fd_sc_hd__decap_3
XFILLER_71_48 VGND VGND VPWR VPWR sky130_fd_sc_hd__fill_2
XPHY_EDGE_ROW_33_Left_127 VGND VGND VPWR VPWR sky130_fd_sc_hd__decap_3
XFILLER_4_203 VGND VGND VPWR VPWR sky130_fd_sc_hd__decap_3
XFILLER_20_41 VGND VGND VPWR VPWR sky130_fd_sc_hd__decap_3
XFILLER_20_74 VGND VGND VPWR VPWR sky130_fd_sc_hd__decap_3
XFILLER_20_85 VGND VGND VPWR VPWR sky130_fd_sc_hd__decap_3
XFILLER_48_402 VGND VGND VPWR VPWR sky130_fd_sc_hd__fill_1
XPHY_EDGE_ROW_42_Left_136 VGND VGND VPWR VPWR sky130_fd_sc_hd__decap_3
XFILLER_0_497 VGND VGND VPWR VPWR sky130_fd_sc_hd__decap_3
XFILLER_48_424 VGND VGND VPWR VPWR sky130_fd_sc_hd__fill_1
XFILLER_48_435 VGND VGND VPWR VPWR sky130_fd_sc_hd__decap_3
XFILLER_48_446 VGND VGND VPWR VPWR sky130_fd_sc_hd__decap_3
XFILLER_63_405 VGND VGND VPWR VPWR sky130_fd_sc_hd__decap_3
XFILLER_75_287 VGND VGND VPWR VPWR sky130_fd_sc_hd__decap_3
XTAP_TAPCELL_ROW_85_1008 VGND VPWR sky130_fd_sc_hd__tapvpwrvgnd_1
XTAP_TAPCELL_ROW_74_901 VGND VPWR sky130_fd_sc_hd__tapvpwrvgnd_1
XFILLER_63_449 VGND VGND VPWR VPWR sky130_fd_sc_hd__decap_3
XTAP_TAPCELL_ROW_46_636 VGND VPWR sky130_fd_sc_hd__tapvpwrvgnd_1
XFILLER_90_224 VGND VGND VPWR VPWR sky130_fd_sc_hd__fill_2
XFILLER_16_354 VGND VGND VPWR VPWR sky130_fd_sc_hd__decap_3
XFILLER_16_365 VGND VGND VPWR VPWR sky130_fd_sc_hd__decap_3
XFILLER_31_335 VGND VGND VPWR VPWR sky130_fd_sc_hd__fill_1
XFILLER_31_346 VGND VGND VPWR VPWR sky130_fd_sc_hd__decap_3
XPHY_EDGE_ROW_51_Left_145 VGND VGND VPWR VPWR sky130_fd_sc_hd__decap_3
X_2690_ _2888_/B _2888_/C _4192_/A VGND VGND VPWR VPWR _2889_/C sky130_fd_sc_hd__a21o_2
XFILLER_77_6 VGND VGND VPWR VPWR sky130_fd_sc_hd__fill_2
X_4360_ _4360_/A _4360_/B VGND VGND VPWR VPWR _4368_/A sky130_fd_sc_hd__xnor2_2
XFILLER_6_98 VGND VGND VPWR VPWR sky130_fd_sc_hd__decap_3
X_3311_ _5152_/Q _3310_/X _3311_/S VGND VGND VPWR VPWR _3312_/B sky130_fd_sc_hd__mux2_1
X_4291_ _3834_/B _3840_/B _4449_/S VGND VGND VPWR VPWR _4291_/X sky130_fd_sc_hd__mux2_1
XPHY_EDGE_ROW_60_Left_154 VGND VGND VPWR VPWR sky130_fd_sc_hd__decap_3
XFILLER_39_402 VGND VGND VPWR VPWR sky130_fd_sc_hd__decap_3
X_3242_ _5169_/Q _4868_/A2 _3230_/Y _3241_/X VGND VGND VPWR VPWR _5132_/D sky130_fd_sc_hd__o22a_2
X_3173_ _2950_/X _3173_/A2 _3157_/Y _5078_/Q VGND VGND VPWR VPWR _5078_/D sky130_fd_sc_hd__a22o_2
XFILLER_66_232 VGND VGND VPWR VPWR sky130_fd_sc_hd__decap_3
XFILLER_54_449 VGND VGND VPWR VPWR sky130_fd_sc_hd__decap_3
XFILLER_81_279 VGND VGND VPWR VPWR sky130_fd_sc_hd__fill_1
XFILLER_62_493 VGND VGND VPWR VPWR sky130_fd_sc_hd__decap_3
XTAP_TAPCELL_ROW_80_959 VGND VPWR sky130_fd_sc_hd__tapvpwrvgnd_1
XTAP_TAPCELL_ROW_17_360 VGND VPWR sky130_fd_sc_hd__tapvpwrvgnd_1
XFILLER_22_357 VGND VGND VPWR VPWR sky130_fd_sc_hd__fill_1
XFILLER_22_368 VGND VGND VPWR VPWR sky130_fd_sc_hd__decap_3
XFILLER_34_195 VGND VGND VPWR VPWR sky130_fd_sc_hd__fill_1
XFILLER_41_29 VGND VGND VPWR VPWR sky130_fd_sc_hd__decap_3
X_2957_ _2908_/X _2970_/A2 _2954_/Y _4889_/Q VGND VGND VPWR VPWR _4889_/D sky130_fd_sc_hd__a22o_2
X_2888_ _4192_/A _2888_/B _2888_/C VGND VGND VPWR VPWR _4191_/C sky130_fd_sc_hd__and3_2
X_4627_ _4626_/X _4606_/Y _4681_/S VGND VGND VPWR VPWR _4628_/B sky130_fd_sc_hd__mux2_1
X_4558_ _4557_/X _4472_/B _4558_/S VGND VGND VPWR VPWR _4666_/C sky130_fd_sc_hd__mux2_1
X_4489_ _4558_/S _4437_/X _4472_/B _4481_/X _4488_/X VGND VGND VPWR VPWR _4489_/X
+ sky130_fd_sc_hd__o311a_2
X_3509_ _3693_/A _3509_/B VGND VGND VPWR VPWR _3509_/X sky130_fd_sc_hd__or2_2
XFILLER_9_9 VGND VGND VPWR VPWR sky130_fd_sc_hd__fill_1
XFILLER_89_324 VGND VGND VPWR VPWR sky130_fd_sc_hd__decap_3
XFILLER_66_37 VGND VGND VPWR VPWR sky130_fd_sc_hd__decap_3
XFILLER_85_530 VGND VGND VPWR VPWR sky130_fd_sc_hd__decap_3
XFILLER_57_265 VGND VGND VPWR VPWR sky130_fd_sc_hd__decap_3
XFILLER_57_276 VGND VGND VPWR VPWR sky130_fd_sc_hd__decap_3
XFILLER_57_287 VGND VGND VPWR VPWR sky130_fd_sc_hd__decap_3
XFILLER_45_449 VGND VGND VPWR VPWR sky130_fd_sc_hd__decap_3
XFILLER_60_419 VGND VGND VPWR VPWR sky130_fd_sc_hd__fill_1
XTAP_TAPCELL_ROW_43_606 VGND VPWR sky130_fd_sc_hd__tapvpwrvgnd_1
XFILLER_82_25 VGND VGND VPWR VPWR sky130_fd_sc_hd__decap_3
XFILLER_13_313 VGND VGND VPWR VPWR sky130_fd_sc_hd__decap_3
XFILLER_15_30 VGND VGND VPWR VPWR sky130_fd_sc_hd__decap_3
XFILLER_25_184 VGND VGND VPWR VPWR sky130_fd_sc_hd__fill_1
XFILLER_53_493 VGND VGND VPWR VPWR sky130_fd_sc_hd__fill_2
XFILLER_82_58 VGND VGND VPWR VPWR sky130_fd_sc_hd__decap_3
XFILLER_13_346 VGND VGND VPWR VPWR sky130_fd_sc_hd__decap_3
XFILLER_15_63 VGND VGND VPWR VPWR sky130_fd_sc_hd__decap_3
XFILLER_9_306 VGND VGND VPWR VPWR sky130_fd_sc_hd__decap_3
XTAP_TAPCELL_ROW_51_683 VGND VPWR sky130_fd_sc_hd__tapvpwrvgnd_1
XFILLER_5_501 VGND VGND VPWR VPWR sky130_fd_sc_hd__decap_3
XFILLER_5_545 VGND VGND VPWR VPWR sky130_fd_sc_hd__decap_3
Xoutput51 _2707_/X VGND VGND VPWR VPWR DEVICES_LDW sky130_fd_sc_hd__clkdlybuf4s25_1
Xoutput62 _5154_/Q VGND VGND VPWR VPWR INSTR_ADDR[1] sky130_fd_sc_hd__clkdlybuf4s25_1
Xoutput73 _2701_/X VGND VGND VPWR VPWR MAIN_LDW sky130_fd_sc_hd__clkdlybuf4s25_1
Xoutput84 _2865_/Y VGND VGND VPWR VPWR MEM_ADDR[2] sky130_fd_sc_hd__clkdlybuf4s25_1
XTAP_TAPCELL_ROW_91_1067 VGND VPWR sky130_fd_sc_hd__tapvpwrvgnd_1
Xoutput95 _2830_/X VGND VGND VPWR VPWR MEM_STR_DATA[12] sky130_fd_sc_hd__clkdlybuf4s25_1
XFILLER_88_390 VGND VGND VPWR VPWR sky130_fd_sc_hd__decap_3
XFILLER_76_541 VGND VGND VPWR VPWR sky130_fd_sc_hd__decap_3
XTAP_TAPCELL_ROW_59_761 VGND VPWR sky130_fd_sc_hd__tapvpwrvgnd_1
XFILLER_91_511 VGND VGND VPWR VPWR sky130_fd_sc_hd__fill_1
XFILLER_91_544 VGND VGND VPWR VPWR sky130_fd_sc_hd__decap_3
XFILLER_63_279 VGND VGND VPWR VPWR sky130_fd_sc_hd__fill_1
XFILLER_16_162 VGND VGND VPWR VPWR sky130_fd_sc_hd__decap_3
XFILLER_31_110 VGND VGND VPWR VPWR sky130_fd_sc_hd__fill_2
X_3860_ _4393_/C _3600_/A _3866_/B VGND VGND VPWR VPWR _3860_/X sky130_fd_sc_hd__mux2_1
XTAP_TAPCELL_ROW_14_330 VGND VPWR sky130_fd_sc_hd__tapvpwrvgnd_1
XFILLER_31_165 VGND VGND VPWR VPWR sky130_fd_sc_hd__decap_3
X_3791_ _3725_/B _3825_/B VGND VGND VPWR VPWR _3791_/Y sky130_fd_sc_hd__nand2b_2
X_2811_ _5138_/Q _2806_/X _2808_/X _2810_/X VGND VGND VPWR VPWR _4799_/B sky130_fd_sc_hd__a22o_2
X_2742_ _5066_/Q _5050_/Q _5034_/Q _5018_/Q _2851_/S0 _2854_/S1 VGND VGND VPWR VPWR
+ _2742_/X sky130_fd_sc_hd__mux4_2
XFILLER_8_361 VGND VGND VPWR VPWR sky130_fd_sc_hd__decap_3
X_4412_ _3363_/A _4213_/A _4412_/S VGND VGND VPWR VPWR _4416_/A sky130_fd_sc_hd__mux2_1
X_2673_ _2677_/S _2673_/B VGND VGND VPWR VPWR _2673_/X sky130_fd_sc_hd__or2_2
XFILLER_8_383 VGND VGND VPWR VPWR sky130_fd_sc_hd__decap_3
X_4343_ _3888_/A _3747_/A _3894_/X _3779_/B _4340_/X VGND VGND VPWR VPWR _4343_/X
+ sky130_fd_sc_hd__o221a_2
X_4274_ _4854_/B _4274_/B _4274_/C _4261_/X VGND VGND VPWR VPWR _4274_/X sky130_fd_sc_hd__or4b_2
X_3225_ _2944_/X _3211_/B _3211_/Y _5124_/Q VGND VGND VPWR VPWR _5124_/D sky130_fd_sc_hd__a22o_2
XFILLER_86_338 VGND VGND VPWR VPWR sky130_fd_sc_hd__decap_3
XFILLER_27_405 VGND VGND VPWR VPWR sky130_fd_sc_hd__decap_3
XFILLER_39_265 VGND VGND VPWR VPWR sky130_fd_sc_hd__fill_2
X_3156_ _3210_/A _3156_/B VGND VGND VPWR VPWR _3157_/B sky130_fd_sc_hd__nor2_4
XFILLER_36_29 VGND VGND VPWR VPWR sky130_fd_sc_hd__decap_3
XFILLER_54_224 VGND VGND VPWR VPWR sky130_fd_sc_hd__decap_3
X_3087_ _2908_/X _3100_/A2 _3084_/Y _5001_/Q VGND VGND VPWR VPWR _5001_/D sky130_fd_sc_hd__a22o_2
XFILLER_22_121 VGND VGND VPWR VPWR sky130_fd_sc_hd__decap_3
XFILLER_10_349 VGND VGND VPWR VPWR sky130_fd_sc_hd__fill_1
X_3989_ _4078_/B _3989_/B VGND VGND VPWR VPWR _3990_/A sky130_fd_sc_hd__nor2_2
XFILLER_6_309 VGND VGND VPWR VPWR sky130_fd_sc_hd__decap_3
XTAP_TAPCELL_ROW_20_388 VGND VPWR sky130_fd_sc_hd__tapvpwrvgnd_1
XFILLER_2_515 VGND VGND VPWR VPWR sky130_fd_sc_hd__decap_3
XFILLER_2_548 VGND VGND VPWR VPWR sky130_fd_sc_hd__decap_3
XFILLER_7_6 VGND VGND VPWR VPWR sky130_fd_sc_hd__fill_2
XFILLER_77_25 VGND VGND VPWR VPWR sky130_fd_sc_hd__decap_3
XFILLER_89_165 VGND VGND VPWR VPWR sky130_fd_sc_hd__decap_3
XFILLER_77_69 VGND VGND VPWR VPWR sky130_fd_sc_hd__decap_3
XFILLER_58_530 VGND VGND VPWR VPWR sky130_fd_sc_hd__fill_2
XFILLER_58_552 VGND VGND VPWR VPWR sky130_fd_sc_hd__decap_3
XFILLER_77_349 VGND VGND VPWR VPWR sky130_fd_sc_hd__decap_3
XFILLER_73_500 VGND VGND VPWR VPWR sky130_fd_sc_hd__decap_3
XFILLER_73_511 VGND VGND VPWR VPWR sky130_fd_sc_hd__decap_3
XFILLER_18_427 VGND VGND VPWR VPWR sky130_fd_sc_hd__decap_3
XTAP_TAPCELL_ROW_56_731 VGND VPWR sky130_fd_sc_hd__tapvpwrvgnd_1
XFILLER_93_57 VGND VGND VPWR VPWR sky130_fd_sc_hd__decap_3
XFILLER_85_393 VGND VGND VPWR VPWR sky130_fd_sc_hd__decap_3
XFILLER_33_408 VGND VGND VPWR VPWR sky130_fd_sc_hd__fill_2
XFILLER_45_246 VGND VGND VPWR VPWR sky130_fd_sc_hd__decap_3
XTAP_TAPCELL_ROW_28_466 VGND VPWR sky130_fd_sc_hd__tapvpwrvgnd_1
XFILLER_26_482 VGND VGND VPWR VPWR sky130_fd_sc_hd__fill_2
XFILLER_26_62 VGND VGND VPWR VPWR sky130_fd_sc_hd__decap_3
XFILLER_60_238 VGND VGND VPWR VPWR sky130_fd_sc_hd__decap_3
XFILLER_13_110 VGND VGND VPWR VPWR sky130_fd_sc_hd__fill_2
XFILLER_26_493 VGND VGND VPWR VPWR sky130_fd_sc_hd__decap_3
XFILLER_41_452 VGND VGND VPWR VPWR sky130_fd_sc_hd__decap_3
XFILLER_41_485 VGND VGND VPWR VPWR sky130_fd_sc_hd__fill_1
XFILLER_13_187 VGND VGND VPWR VPWR sky130_fd_sc_hd__fill_2
XFILLER_42_61 VGND VGND VPWR VPWR sky130_fd_sc_hd__decap_3
XFILLER_9_147 VGND VGND VPWR VPWR sky130_fd_sc_hd__decap_3
XFILLER_42_83 VGND VGND VPWR VPWR sky130_fd_sc_hd__fill_1
XFILLER_9_169 VGND VGND VPWR VPWR sky130_fd_sc_hd__fill_1
XFILLER_3_55 VGND VGND VPWR VPWR sky130_fd_sc_hd__fill_1
XFILLER_68_327 VGND VGND VPWR VPWR sky130_fd_sc_hd__decap_3
XFILLER_3_66 VGND VGND VPWR VPWR sky130_fd_sc_hd__decap_3
X_3010_ _3138_/A _3028_/B VGND VGND VPWR VPWR _3011_/B sky130_fd_sc_hd__nor2_4
XFILLER_83_308 VGND VGND VPWR VPWR sky130_fd_sc_hd__decap_3
XFILLER_64_522 VGND VGND VPWR VPWR sky130_fd_sc_hd__decap_3
XFILLER_64_533 VGND VGND VPWR VPWR sky130_fd_sc_hd__decap_3
XFILLER_76_371 VGND VGND VPWR VPWR sky130_fd_sc_hd__decap_3
XFILLER_36_268 VGND VGND VPWR VPWR sky130_fd_sc_hd__decap_3
XFILLER_17_460 VGND VGND VPWR VPWR sky130_fd_sc_hd__fill_2
XFILLER_17_482 VGND VGND VPWR VPWR sky130_fd_sc_hd__decap_3
XFILLER_24_419 VGND VGND VPWR VPWR sky130_fd_sc_hd__fill_1
XFILLER_51_205 VGND VGND VPWR VPWR sky130_fd_sc_hd__decap_3
X_4961_ clkload7/A _4961_/D VGND VGND VPWR VPWR _4961_/Q sky130_fd_sc_hd__dfxtp_2
XFILLER_44_290 VGND VGND VPWR VPWR sky130_fd_sc_hd__fill_2
XFILLER_51_238 VGND VGND VPWR VPWR sky130_fd_sc_hd__decap_3
X_4892_ _5114_/CLK _4892_/D VGND VGND VPWR VPWR _4892_/Q sky130_fd_sc_hd__dfxtp_2
X_3912_ _3747_/A _3915_/B _4275_/B VGND VGND VPWR VPWR _3912_/Y sky130_fd_sc_hd__o21ai_2
XFILLER_32_452 VGND VGND VPWR VPWR sky130_fd_sc_hd__decap_3
X_3843_ _4192_/B _4192_/C _4192_/D _3842_/A _4192_/A VGND VGND VPWR VPWR _3844_/B
+ sky130_fd_sc_hd__o311a_2
XTAP_TAPCELL_ROW_62_789 VGND VPWR sky130_fd_sc_hd__tapvpwrvgnd_1
X_3774_ _3778_/D VGND VGND VPWR VPWR _3774_/Y sky130_fd_sc_hd__inv_2
X_2725_ _2723_/X _2724_/X _2855_/S VGND VGND VPWR VPWR _2725_/X sky130_fd_sc_hd__mux2_1
X_2656_ _2656_/A _2656_/B VGND VGND VPWR VPWR _3776_/B sky130_fd_sc_hd__and2_2
X_2587_ _5158_/Q _4357_/A VGND VGND VPWR VPWR _2589_/A sky130_fd_sc_hd__and2_2
X_4326_ _4327_/B VGND VGND VPWR VPWR _4326_/Y sky130_fd_sc_hd__inv_2
XFILLER_59_349 VGND VGND VPWR VPWR sky130_fd_sc_hd__decap_3
X_4257_ _4239_/A _4235_/B _3665_/B VGND VGND VPWR VPWR _4257_/Y sky130_fd_sc_hd__a21oi_2
XFILLER_86_124 VGND VGND VPWR VPWR sky130_fd_sc_hd__decap_3
XFILLER_74_319 VGND VGND VPWR VPWR sky130_fd_sc_hd__fill_1
X_4188_ _4207_/A _4188_/B VGND VGND VPWR VPWR _4214_/B sky130_fd_sc_hd__or2_2
X_3208_ _2947_/X _3192_/Y _3193_/Y _5109_/Q VGND VGND VPWR VPWR _5109_/D sky130_fd_sc_hd__a22o_2
XFILLER_86_168 VGND VGND VPWR VPWR sky130_fd_sc_hd__decap_3
XFILLER_55_511 VGND VGND VPWR VPWR sky130_fd_sc_hd__decap_3
XFILLER_55_544 VGND VGND VPWR VPWR sky130_fd_sc_hd__decap_3
XFILLER_67_393 VGND VGND VPWR VPWR sky130_fd_sc_hd__decap_3
X_3139_ _4692_/A _3139_/B VGND VGND VPWR VPWR _3139_/Y sky130_fd_sc_hd__nor2_4
XFILLER_27_268 VGND VGND VPWR VPWR sky130_fd_sc_hd__decap_3
XFILLER_82_352 VGND VGND VPWR VPWR sky130_fd_sc_hd__decap_3
XTAP_TAPCELL_ROW_53_701 VGND VPWR sky130_fd_sc_hd__tapvpwrvgnd_1
XFILLER_82_374 VGND VGND VPWR VPWR sky130_fd_sc_hd__decap_3
XFILLER_23_430 VGND VGND VPWR VPWR sky130_fd_sc_hd__decap_3
XFILLER_42_249 VGND VGND VPWR VPWR sky130_fd_sc_hd__decap_3
XTAP_TAPCELL_ROW_25_436 VGND VPWR sky130_fd_sc_hd__tapvpwrvgnd_1
XFILLER_23_452 VGND VGND VPWR VPWR sky130_fd_sc_hd__decap_3
XFILLER_50_260 VGND VGND VPWR VPWR sky130_fd_sc_hd__decap_3
XFILLER_10_102 VGND VGND VPWR VPWR sky130_fd_sc_hd__decap_3
XFILLER_50_282 VGND VGND VPWR VPWR sky130_fd_sc_hd__decap_3
XFILLER_10_135 VGND VGND VPWR VPWR sky130_fd_sc_hd__decap_3
XFILLER_6_139 VGND VGND VPWR VPWR sky130_fd_sc_hd__fill_1
XFILLER_88_35 VGND VGND VPWR VPWR sky130_fd_sc_hd__decap_3
XFILLER_5_3 VGND VGND VPWR VPWR sky130_fd_sc_hd__decap_3
XFILLER_88_79 VGND VGND VPWR VPWR sky130_fd_sc_hd__decap_3
XFILLER_58_360 VGND VGND VPWR VPWR sky130_fd_sc_hd__decap_3
XFILLER_65_319 VGND VGND VPWR VPWR sky130_fd_sc_hd__decap_3
XFILLER_46_522 VGND VGND VPWR VPWR sky130_fd_sc_hd__decap_3
XFILLER_58_371 VGND VGND VPWR VPWR sky130_fd_sc_hd__decap_3
XFILLER_18_246 VGND VGND VPWR VPWR sky130_fd_sc_hd__decap_3
XFILLER_37_72 VGND VGND VPWR VPWR sky130_fd_sc_hd__decap_3
XFILLER_37_94 VGND VGND VPWR VPWR sky130_fd_sc_hd__decap_3
XFILLER_46_555 VGND VGND VPWR VPWR sky130_fd_sc_hd__decap_3
XFILLER_73_352 VGND VGND VPWR VPWR sky130_fd_sc_hd__decap_3
XFILLER_73_396 VGND VGND VPWR VPWR sky130_fd_sc_hd__decap_3
XFILLER_33_249 VGND VGND VPWR VPWR sky130_fd_sc_hd__decap_3
XFILLER_53_60 VGND VGND VPWR VPWR sky130_fd_sc_hd__decap_3
XFILLER_41_293 VGND VGND VPWR VPWR sky130_fd_sc_hd__fill_2
X_3490_ _3487_/A _3487_/B _3485_/A VGND VGND VPWR VPWR _3492_/A sky130_fd_sc_hd__a21o_2
X_2510_ _2677_/S _2510_/B VGND VGND VPWR VPWR _2510_/X sky130_fd_sc_hd__or2_2
X_2441_ _5183_/Q _3576_/A VGND VGND VPWR VPWR _3567_/S sky130_fd_sc_hd__nand2_2
XFILLER_5_183 VGND VGND VPWR VPWR sky130_fd_sc_hd__decap_3
XFILLER_38_3 VGND VGND VPWR VPWR sky130_fd_sc_hd__decap_3
X_5160_ _5176_/CLK _5160_/D VGND VGND VPWR VPWR _5160_/Q sky130_fd_sc_hd__dfxtp_2
X_4111_ _4191_/A _2878_/B _4125_/B _4110_/X VGND VGND VPWR VPWR _4111_/X sky130_fd_sc_hd__o22a_2
X_5091_ _5107_/CLK _5091_/D VGND VGND VPWR VPWR _5091_/Q sky130_fd_sc_hd__dfxtp_2
XFILLER_37_500 VGND VGND VPWR VPWR sky130_fd_sc_hd__decap_3
X_4042_ _3920_/Y _3916_/X _4078_/B VGND VGND VPWR VPWR _4042_/X sky130_fd_sc_hd__mux2_1
XFILLER_37_533 VGND VGND VPWR VPWR sky130_fd_sc_hd__decap_3
XFILLER_49_382 VGND VGND VPWR VPWR sky130_fd_sc_hd__decap_3
XFILLER_49_393 VGND VGND VPWR VPWR sky130_fd_sc_hd__decap_3
XTAP_TAPCELL_ROW_67_837 VGND VPWR sky130_fd_sc_hd__tapvpwrvgnd_1
XFILLER_83_116 VGND VGND VPWR VPWR sky130_fd_sc_hd__decap_3
XFILLER_64_352 VGND VGND VPWR VPWR sky130_fd_sc_hd__decap_3
XFILLER_83_149 VGND VGND VPWR VPWR sky130_fd_sc_hd__fill_1
XFILLER_76_190 VGND VGND VPWR VPWR sky130_fd_sc_hd__decap_3
XFILLER_52_525 VGND VGND VPWR VPWR sky130_fd_sc_hd__fill_1
X_4944_ clkload4/A _4944_/D VGND VGND VPWR VPWR _4944_/Q sky130_fd_sc_hd__dfxtp_2
XTAP_TAPCELL_ROW_22_406 VGND VPWR sky130_fd_sc_hd__tapvpwrvgnd_1
X_4875_ _5083_/CLK _4875_/D VGND VGND VPWR VPWR _4875_/Q sky130_fd_sc_hd__dfxtp_2
X_3826_ _5162_/Q _4079_/A VGND VGND VPWR VPWR _3826_/Y sky130_fd_sc_hd__nor2_2
XFILLER_20_477 VGND VGND VPWR VPWR sky130_fd_sc_hd__decap_3
X_3757_ _5156_/Q _4286_/B _4309_/S VGND VGND VPWR VPWR _4313_/S sky130_fd_sc_hd__mux2_4
X_2708_ _2873_/A _4847_/B _5282_/Q VGND VGND VPWR VPWR _2709_/B sky130_fd_sc_hd__a21oi_2
XTAP_TAPCELL_ROW_30_483 VGND VPWR sky130_fd_sc_hd__tapvpwrvgnd_1
X_3688_ _3834_/B _3788_/B VGND VGND VPWR VPWR _4166_/B sky130_fd_sc_hd__nor2_2
X_2639_ _2633_/X _2635_/X _2638_/X _2433_/Y VGND VGND VPWR VPWR _4397_/A sky130_fd_sc_hd__a22o_2
XFILLER_58_27 VGND VGND VPWR VPWR sky130_fd_sc_hd__fill_1
XFILLER_59_102 VGND VGND VPWR VPWR sky130_fd_sc_hd__decap_3
XFILLER_87_411 VGND VGND VPWR VPWR sky130_fd_sc_hd__decap_3
XFILLER_58_49 VGND VGND VPWR VPWR sky130_fd_sc_hd__decap_3
XFILLER_59_113 VGND VGND VPWR VPWR sky130_fd_sc_hd__decap_3
X_4309_ _4302_/A _4299_/A _4309_/S VGND VGND VPWR VPWR _4310_/B sky130_fd_sc_hd__mux2_1
XFILLER_87_455 VGND VGND VPWR VPWR sky130_fd_sc_hd__decap_3
XFILLER_87_444 VGND VGND VPWR VPWR sky130_fd_sc_hd__decap_3
XFILLER_47_319 VGND VGND VPWR VPWR sky130_fd_sc_hd__decap_3
XFILLER_87_477 VGND VGND VPWR VPWR sky130_fd_sc_hd__decap_3
XFILLER_28_533 VGND VGND VPWR VPWR sky130_fd_sc_hd__decap_3
XFILLER_74_127 VGND VGND VPWR VPWR sky130_fd_sc_hd__fill_1
XFILLER_55_352 VGND VGND VPWR VPWR sky130_fd_sc_hd__decap_3
XFILLER_15_216 VGND VGND VPWR VPWR sky130_fd_sc_hd__decap_3
XFILLER_43_503 VGND VGND VPWR VPWR sky130_fd_sc_hd__fill_1
XFILLER_55_385 VGND VGND VPWR VPWR sky130_fd_sc_hd__decap_3
XTAP_TAPCELL_ROW_38_561 VGND VPWR sky130_fd_sc_hd__tapvpwrvgnd_1
XFILLER_15_249 VGND VGND VPWR VPWR sky130_fd_sc_hd__decap_3
XFILLER_55_396 VGND VGND VPWR VPWR sky130_fd_sc_hd__decap_3
XFILLER_70_333 VGND VGND VPWR VPWR sky130_fd_sc_hd__fill_2
XFILLER_70_355 VGND VGND VPWR VPWR sky130_fd_sc_hd__decap_3
XFILLER_11_433 VGND VGND VPWR VPWR sky130_fd_sc_hd__decap_3
XFILLER_23_260 VGND VGND VPWR VPWR sky130_fd_sc_hd__decap_3
XFILLER_70_399 VGND VGND VPWR VPWR sky130_fd_sc_hd__decap_3
XFILLER_11_455 VGND VGND VPWR VPWR sky130_fd_sc_hd__decap_3
XFILLER_23_293 VGND VGND VPWR VPWR sky130_fd_sc_hd__decap_3
XFILLER_7_404 VGND VGND VPWR VPWR sky130_fd_sc_hd__fill_1
XFILLER_11_499 VGND VGND VPWR VPWR sky130_fd_sc_hd__decap_3
XFILLER_23_96 VGND VGND VPWR VPWR sky130_fd_sc_hd__decap_3
XFILLER_2_131 VGND VGND VPWR VPWR sky130_fd_sc_hd__decap_3
XFILLER_78_400 VGND VGND VPWR VPWR sky130_fd_sc_hd__decap_3
XFILLER_2_175 VGND VGND VPWR VPWR sky130_fd_sc_hd__decap_3
XFILLER_2_197 VGND VGND VPWR VPWR sky130_fd_sc_hd__decap_3
XFILLER_78_433 VGND VGND VPWR VPWR sky130_fd_sc_hd__decap_3
XFILLER_93_403 VGND VGND VPWR VPWR sky130_fd_sc_hd__decap_3
XFILLER_78_466 VGND VGND VPWR VPWR sky130_fd_sc_hd__fill_1
XFILLER_65_116 VGND VGND VPWR VPWR sky130_fd_sc_hd__decap_3
XTAP_TAPCELL_ROW_88_1039 VGND VPWR sky130_fd_sc_hd__tapvpwrvgnd_1
XFILLER_93_436 VGND VGND VPWR VPWR sky130_fd_sc_hd__decap_3
XFILLER_0_12 VGND VGND VPWR VPWR sky130_fd_sc_hd__decap_3
XTAP_TAPCELL_ROW_64_807 VGND VPWR sky130_fd_sc_hd__tapvpwrvgnd_1
XFILLER_93_469 VGND VGND VPWR VPWR sky130_fd_sc_hd__fill_2
XFILLER_93_458 VGND VGND VPWR VPWR sky130_fd_sc_hd__decap_3
XFILLER_61_300 VGND VGND VPWR VPWR sky130_fd_sc_hd__decap_3
XFILLER_80_108 VGND VGND VPWR VPWR sky130_fd_sc_hd__decap_3
XFILLER_61_333 VGND VGND VPWR VPWR sky130_fd_sc_hd__decap_3
XFILLER_64_81 VGND VGND VPWR VPWR sky130_fd_sc_hd__decap_3
XFILLER_21_208 VGND VGND VPWR VPWR sky130_fd_sc_hd__decap_3
X_2990_ _2950_/X _2974_/B _2974_/Y _4918_/Q VGND VGND VPWR VPWR _4918_/D sky130_fd_sc_hd__a22o_2
XTAP_TAPCELL_ROW_72_884 VGND VPWR sky130_fd_sc_hd__tapvpwrvgnd_1
XFILLER_9_21 VGND VGND VPWR VPWR sky130_fd_sc_hd__decap_3
XFILLER_61_388 VGND VGND VPWR VPWR sky130_fd_sc_hd__decap_3
XFILLER_61_399 VGND VGND VPWR VPWR sky130_fd_sc_hd__decap_3
XFILLER_14_293 VGND VGND VPWR VPWR sky130_fd_sc_hd__decap_3
X_4660_ _3666_/A _4261_/C _4686_/B1 _3779_/A _4657_/X VGND VGND VPWR VPWR _4661_/D
+ sky130_fd_sc_hd__o221a_2
X_3611_ _3609_/X _3610_/X _5133_/Q VGND VGND VPWR VPWR _3611_/X sky130_fd_sc_hd__mux2_1
X_4591_ _2703_/A _2656_/B _3778_/D _2656_/A VGND VGND VPWR VPWR _4594_/B sky130_fd_sc_hd__o2bb2a_2
X_3542_ _3537_/X _3989_/B _4078_/B VGND VGND VPWR VPWR _4104_/A sky130_fd_sc_hd__mux2_1
XFILLER_6_492 VGND VGND VPWR VPWR sky130_fd_sc_hd__decap_3
X_3473_ _3458_/A _3471_/X _3472_/Y _4847_/B _2423_/Y VGND VGND VPWR VPWR _3474_/B
+ sky130_fd_sc_hd__o32a_2
XFILLER_69_411 VGND VGND VPWR VPWR sky130_fd_sc_hd__fill_1
X_5212_ _5233_/CLK _5212_/D VGND VGND VPWR VPWR _5212_/Q sky130_fd_sc_hd__dfxtp_2
X_2424_ _5200_/Q VGND VGND VPWR VPWR _2424_/Y sky130_fd_sc_hd__inv_2
X_5143_ _5286_/CLK _5143_/D VGND VGND VPWR VPWR _5143_/Q sky130_fd_sc_hd__dfxtp_2
XFILLER_69_477 VGND VGND VPWR VPWR sky130_fd_sc_hd__decap_3
XFILLER_84_403 VGND VGND VPWR VPWR sky130_fd_sc_hd__decap_3
XFILLER_69_499 VGND VGND VPWR VPWR sky130_fd_sc_hd__decap_3
X_5074_ _5107_/CLK _5074_/D VGND VGND VPWR VPWR _5074_/Q sky130_fd_sc_hd__dfxtp_2
X_4025_ _4078_/B _4025_/B VGND VGND VPWR VPWR _4025_/Y sky130_fd_sc_hd__nor2_2
XFILLER_25_503 VGND VGND VPWR VPWR sky130_fd_sc_hd__fill_1
XFILLER_25_514 VGND VGND VPWR VPWR sky130_fd_sc_hd__decap_3
XFILLER_37_374 VGND VGND VPWR VPWR sky130_fd_sc_hd__decap_3
XFILLER_37_396 VGND VGND VPWR VPWR sky130_fd_sc_hd__decap_3
XFILLER_44_29 VGND VGND VPWR VPWR sky130_fd_sc_hd__fill_2
XFILLER_52_344 VGND VGND VPWR VPWR sky130_fd_sc_hd__decap_3
XFILLER_64_193 VGND VGND VPWR VPWR sky130_fd_sc_hd__decap_3
XTAP_TAPCELL_ROW_35_531 VGND VPWR sky130_fd_sc_hd__tapvpwrvgnd_1
XFILLER_92_491 VGND VGND VPWR VPWR sky130_fd_sc_hd__decap_3
X_4927_ clkload4/A _4927_/D VGND VGND VPWR VPWR _4927_/Q sky130_fd_sc_hd__dfxtp_2
XFILLER_60_17 VGND VGND VPWR VPWR sky130_fd_sc_hd__fill_1
X_4858_ _2455_/X _2458_/X _5281_/D _3589_/Y _4857_/X VGND VGND VPWR VPWR _5279_/D
+ sky130_fd_sc_hd__a41o_2
X_3809_ _3852_/A _3809_/B VGND VGND VPWR VPWR _3810_/B sky130_fd_sc_hd__nor2_2
X_4789_ _5266_/Q _4847_/B VGND VGND VPWR VPWR _4789_/X sky130_fd_sc_hd__or2_2
XFILLER_69_37 VGND VGND VPWR VPWR sky130_fd_sc_hd__decap_3
XTAP_TAPCELL_ROW_7_267 VGND VPWR sky130_fd_sc_hd__tapvpwrvgnd_1
XFILLER_47_116 VGND VGND VPWR VPWR sky130_fd_sc_hd__fill_2
XFILLER_28_330 VGND VGND VPWR VPWR sky130_fd_sc_hd__decap_3
XFILLER_16_525 VGND VGND VPWR VPWR sky130_fd_sc_hd__decap_3
XFILLER_18_85 VGND VGND VPWR VPWR sky130_fd_sc_hd__fill_2
XFILLER_28_374 VGND VGND VPWR VPWR sky130_fd_sc_hd__decap_3
XFILLER_43_300 VGND VGND VPWR VPWR sky130_fd_sc_hd__decap_3
XFILLER_62_119 VGND VGND VPWR VPWR sky130_fd_sc_hd__decap_3
XFILLER_90_417 VGND VGND VPWR VPWR sky130_fd_sc_hd__decap_3
XFILLER_83_480 VGND VGND VPWR VPWR sky130_fd_sc_hd__decap_3
XFILLER_43_355 VGND VGND VPWR VPWR sky130_fd_sc_hd__decap_3
XFILLER_31_539 VGND VGND VPWR VPWR sky130_fd_sc_hd__fill_1
XFILLER_43_388 VGND VGND VPWR VPWR sky130_fd_sc_hd__decap_3
XFILLER_43_399 VGND VGND VPWR VPWR sky130_fd_sc_hd__fill_2
XTAP_TAPCELL_ROW_41_589 VGND VPWR sky130_fd_sc_hd__tapvpwrvgnd_1
XFILLER_11_296 VGND VGND VPWR VPWR sky130_fd_sc_hd__fill_1
XFILLER_3_495 VGND VGND VPWR VPWR sky130_fd_sc_hd__decap_3
XFILLER_22_6 VGND VGND VPWR VPWR sky130_fd_sc_hd__decap_3
XFILLER_66_403 VGND VGND VPWR VPWR sky130_fd_sc_hd__decap_3
Xload_slew148 _4390_/B VGND VGND VPWR VPWR _3817_/B sky130_fd_sc_hd__buf_4
XTAP_TAPCELL_ROW_77_932 VGND VPWR sky130_fd_sc_hd__tapvpwrvgnd_1
XFILLER_78_296 VGND VGND VPWR VPWR sky130_fd_sc_hd__decap_3
XFILLER_66_447 VGND VGND VPWR VPWR sky130_fd_sc_hd__decap_3
XFILLER_66_469 VGND VGND VPWR VPWR sky130_fd_sc_hd__decap_3
XTAP_TAPCELL_ROW_49_667 VGND VPWR sky130_fd_sc_hd__tapvpwrvgnd_1
XFILLER_53_108 VGND VGND VPWR VPWR sky130_fd_sc_hd__decap_3
XFILLER_81_428 VGND VGND VPWR VPWR sky130_fd_sc_hd__decap_3
XFILLER_19_385 VGND VGND VPWR VPWR sky130_fd_sc_hd__decap_3
XFILLER_19_396 VGND VGND VPWR VPWR sky130_fd_sc_hd__decap_3
XFILLER_34_333 VGND VGND VPWR VPWR sky130_fd_sc_hd__decap_3
XFILLER_74_480 VGND VGND VPWR VPWR sky130_fd_sc_hd__decap_3
XFILLER_93_299 VGND VGND VPWR VPWR sky130_fd_sc_hd__decap_3
XFILLER_34_344 VGND VGND VPWR VPWR sky130_fd_sc_hd__decap_3
XFILLER_22_539 VGND VGND VPWR VPWR sky130_fd_sc_hd__decap_3
X_2973_ _3028_/B _3174_/B VGND VGND VPWR VPWR _2973_/Y sky130_fd_sc_hd__nor2_4
XTAP_TAPCELL_ROW_32_501 VGND VPWR sky130_fd_sc_hd__tapvpwrvgnd_1
X_4712_ input47/X _4694_/Y _4711_/X _3366_/A VGND VGND VPWR VPWR _5250_/D sky130_fd_sc_hd__o211a_2
X_4643_ _4236_/A _2521_/B _4684_/B1 _4233_/B VGND VGND VPWR VPWR _4643_/Y sky130_fd_sc_hd__a22oi_2
X_4574_ _3825_/B _3600_/A _4638_/S VGND VGND VPWR VPWR _4575_/A sky130_fd_sc_hd__mux2_1
X_3525_ _5063_/Q _5047_/Q _5031_/Q _5015_/Q _3706_/S0 _3706_/S1 VGND VGND VPWR VPWR
+ _3525_/X sky130_fd_sc_hd__mux4_2
X_3456_ _3457_/A _3457_/C _3457_/B VGND VGND VPWR VPWR _3458_/B sky130_fd_sc_hd__o21a_2
X_3387_ _3494_/A _3387_/B VGND VGND VPWR VPWR _5195_/D sky130_fd_sc_hd__nor2_2
XFILLER_57_414 VGND VGND VPWR VPWR sky130_fd_sc_hd__decap_3
X_5126_ clkload8/A _5126_/D VGND VGND VPWR VPWR _5126_/Q sky130_fd_sc_hd__dfxtp_2
XTAP_TAPCELL_ROW_4_237 VGND VPWR sky130_fd_sc_hd__tapvpwrvgnd_1
XFILLER_84_200 VGND VGND VPWR VPWR sky130_fd_sc_hd__decap_3
XFILLER_57_447 VGND VGND VPWR VPWR sky130_fd_sc_hd__fill_1
X_5057_ _5105_/CLK _5057_/D VGND VGND VPWR VPWR _5057_/Q sky130_fd_sc_hd__dfxtp_2
XFILLER_84_244 VGND VGND VPWR VPWR sky130_fd_sc_hd__decap_3
X_4008_ _3977_/A _3954_/B _3745_/A VGND VGND VPWR VPWR _4011_/B sky130_fd_sc_hd__a21o_2
XFILLER_65_491 VGND VGND VPWR VPWR sky130_fd_sc_hd__decap_3
XFILLER_72_439 VGND VGND VPWR VPWR sky130_fd_sc_hd__decap_3
XFILLER_25_355 VGND VGND VPWR VPWR sky130_fd_sc_hd__decap_3
XFILLER_52_130 VGND VGND VPWR VPWR sky130_fd_sc_hd__decap_3
XFILLER_52_141 VGND VGND VPWR VPWR sky130_fd_sc_hd__fill_2
XFILLER_25_399 VGND VGND VPWR VPWR sky130_fd_sc_hd__decap_3
XFILLER_4_215 VGND VGND VPWR VPWR sky130_fd_sc_hd__decap_3
XFILLER_20_53 VGND VGND VPWR VPWR sky130_fd_sc_hd__fill_1
XFILLER_88_550 VGND VGND VPWR VPWR sky130_fd_sc_hd__decap_3
XFILLER_48_414 VGND VGND VPWR VPWR sky130_fd_sc_hd__decap_3
XFILLER_48_458 VGND VGND VPWR VPWR sky130_fd_sc_hd__decap_3
XFILLER_75_222 VGND VGND VPWR VPWR sky130_fd_sc_hd__fill_2
XFILLER_35_108 VGND VGND VPWR VPWR sky130_fd_sc_hd__decap_3
XFILLER_63_428 VGND VGND VPWR VPWR sky130_fd_sc_hd__decap_3
XFILLER_75_277 VGND VGND VPWR VPWR sky130_fd_sc_hd__decap_3
XTAP_TAPCELL_ROW_85_1009 VGND VPWR sky130_fd_sc_hd__tapvpwrvgnd_1
XTAP_TAPCELL_ROW_74_902 VGND VPWR sky130_fd_sc_hd__tapvpwrvgnd_1
XFILLER_56_491 VGND VGND VPWR VPWR sky130_fd_sc_hd__fill_1
XTAP_TAPCELL_ROW_46_637 VGND VPWR sky130_fd_sc_hd__tapvpwrvgnd_1
XFILLER_71_461 VGND VGND VPWR VPWR sky130_fd_sc_hd__fill_2
XFILLER_16_377 VGND VGND VPWR VPWR sky130_fd_sc_hd__decap_3
XFILLER_31_369 VGND VGND VPWR VPWR sky130_fd_sc_hd__decap_3
XFILLER_61_93 VGND VGND VPWR VPWR sky130_fd_sc_hd__fill_1
XFILLER_6_66 VGND VGND VPWR VPWR sky130_fd_sc_hd__decap_3
X_3310_ _5273_/Q _3309_/X _3310_/S VGND VGND VPWR VPWR _3310_/X sky130_fd_sc_hd__mux2_1
XFILLER_3_281 VGND VGND VPWR VPWR sky130_fd_sc_hd__decap_3
X_4290_ _4397_/B _4449_/S _4147_/Y VGND VGND VPWR VPWR _4290_/Y sky130_fd_sc_hd__o21ai_2
X_3241_ _5283_/Q _3338_/B input5/X VGND VGND VPWR VPWR _3241_/X sky130_fd_sc_hd__and3_2
XFILLER_20_3 VGND VGND VPWR VPWR sky130_fd_sc_hd__decap_3
XFILLER_66_211 VGND VGND VPWR VPWR sky130_fd_sc_hd__decap_3
X_3172_ _2947_/X _3157_/B _3157_/Y _5077_/Q VGND VGND VPWR VPWR _5077_/D sky130_fd_sc_hd__a22o_2
XFILLER_39_436 VGND VGND VPWR VPWR sky130_fd_sc_hd__decap_3
XFILLER_39_458 VGND VGND VPWR VPWR sky130_fd_sc_hd__decap_3
XFILLER_66_244 VGND VGND VPWR VPWR sky130_fd_sc_hd__decap_3
XTAP_TAPCELL_ROW_1_207 VGND VPWR sky130_fd_sc_hd__tapvpwrvgnd_1
XFILLER_66_277 VGND VGND VPWR VPWR sky130_fd_sc_hd__decap_3
XFILLER_47_491 VGND VGND VPWR VPWR sky130_fd_sc_hd__decap_3
XFILLER_34_141 VGND VGND VPWR VPWR sky130_fd_sc_hd__decap_3
XTAP_TAPCELL_ROW_17_361 VGND VPWR sky130_fd_sc_hd__tapvpwrvgnd_1
X_2956_ _2905_/X _2970_/A2 _2954_/Y _4888_/Q VGND VGND VPWR VPWR _4888_/D sky130_fd_sc_hd__a22o_2
X_2887_ _2887_/A _4171_/B VGND VGND VPWR VPWR _2887_/Y sky130_fd_sc_hd__nor2_2
X_4626_ _3840_/B _3834_/B _4638_/S VGND VGND VPWR VPWR _4626_/X sky130_fd_sc_hd__mux2_1
Xclkbuf_leaf_35_CLK clkbuf_leaf_5_CLK/A VGND VGND VPWR VPWR clkload8/A sky130_fd_sc_hd__clkbuf_8
X_4557_ _4556_/Y _4533_/X _4681_/S VGND VGND VPWR VPWR _4557_/X sky130_fd_sc_hd__mux2_1
X_4488_ _4487_/A _4485_/X _4487_/Y _4312_/Y VGND VGND VPWR VPWR _4488_/X sky130_fd_sc_hd__a211o_2
X_3508_ _5065_/Q _5049_/Q _5033_/Q _5017_/Q _3706_/S0 _3706_/S1 VGND VGND VPWR VPWR
+ _3509_/B sky130_fd_sc_hd__mux4_2
X_3439_ _3432_/B _3432_/C _3432_/A VGND VGND VPWR VPWR _3440_/B sky130_fd_sc_hd__a21boi_2
XFILLER_57_200 VGND VGND VPWR VPWR sky130_fd_sc_hd__decap_3
XFILLER_66_27 VGND VGND VPWR VPWR sky130_fd_sc_hd__fill_1
X_5109_ _5109_/CLK _5109_/D VGND VGND VPWR VPWR _5109_/Q sky130_fd_sc_hd__dfxtp_2
XFILLER_72_269 VGND VGND VPWR VPWR sky130_fd_sc_hd__fill_2
XTAP_TAPCELL_ROW_43_607 VGND VPWR sky130_fd_sc_hd__tapvpwrvgnd_1
XFILLER_82_15 VGND VGND VPWR VPWR sky130_fd_sc_hd__decap_3
XFILLER_53_472 VGND VGND VPWR VPWR sky130_fd_sc_hd__decap_3
XFILLER_13_358 VGND VGND VPWR VPWR sky130_fd_sc_hd__decap_3
XFILLER_80_291 VGND VGND VPWR VPWR sky130_fd_sc_hd__decap_3
XTAP_TAPCELL_ROW_51_684 VGND VPWR sky130_fd_sc_hd__tapvpwrvgnd_1
XFILLER_31_52 VGND VGND VPWR VPWR sky130_fd_sc_hd__decap_3
Xclkbuf_leaf_26_CLK clkload0/A VGND VGND VPWR VPWR _5099_/CLK sky130_fd_sc_hd__clkbuf_8
XFILLER_31_63 VGND VGND VPWR VPWR sky130_fd_sc_hd__decap_3
XFILLER_31_85 VGND VGND VPWR VPWR sky130_fd_sc_hd__decap_3
XFILLER_5_557 VGND VGND VPWR VPWR sky130_fd_sc_hd__fill_1
Xoutput52 _2703_/X VGND VGND VPWR VPWR DEVICES_STRH sky130_fd_sc_hd__clkdlybuf4s25_1
XFILLER_68_509 VGND VGND VPWR VPWR sky130_fd_sc_hd__fill_2
Xoutput63 _5139_/Q VGND VGND VPWR VPWR INSTR_ADDR[2] sky130_fd_sc_hd__clkdlybuf4s25_1
Xoutput74 _2698_/X VGND VGND VPWR VPWR MAIN_STRH sky130_fd_sc_hd__clkdlybuf4s25_1
Xoutput85 _2867_/Y VGND VGND VPWR VPWR MEM_ADDR[3] sky130_fd_sc_hd__clkdlybuf4s25_1
XTAP_TAPCELL_ROW_91_1068 VGND VPWR sky130_fd_sc_hd__tapvpwrvgnd_1
XFILLER_0_240 VGND VGND VPWR VPWR sky130_fd_sc_hd__decap_3
XFILLER_0_262 VGND VGND VPWR VPWR sky130_fd_sc_hd__decap_3
Xoutput96 _2839_/X VGND VGND VPWR VPWR MEM_STR_DATA[13] sky130_fd_sc_hd__clkdlybuf4s25_1
XFILLER_0_284 VGND VGND VPWR VPWR sky130_fd_sc_hd__decap_3
XFILLER_76_553 VGND VGND VPWR VPWR sky130_fd_sc_hd__decap_3
XFILLER_76_531 VGND VGND VPWR VPWR sky130_fd_sc_hd__fill_1
XFILLER_36_406 VGND VGND VPWR VPWR sky130_fd_sc_hd__fill_1
XTAP_TAPCELL_ROW_59_762 VGND VPWR sky130_fd_sc_hd__tapvpwrvgnd_1
XFILLER_91_501 VGND VGND VPWR VPWR sky130_fd_sc_hd__decap_3
XFILLER_36_439 VGND VGND VPWR VPWR sky130_fd_sc_hd__decap_3
XFILLER_48_299 VGND VGND VPWR VPWR sky130_fd_sc_hd__decap_3
XFILLER_56_82 VGND VGND VPWR VPWR sky130_fd_sc_hd__fill_2
XFILLER_16_141 VGND VGND VPWR VPWR sky130_fd_sc_hd__decap_3
XFILLER_51_409 VGND VGND VPWR VPWR sky130_fd_sc_hd__decap_3
XFILLER_91_556 VGND VGND VPWR VPWR sky130_fd_sc_hd__fill_2
XFILLER_44_483 VGND VGND VPWR VPWR sky130_fd_sc_hd__fill_2
XTAP_TAPCELL_ROW_14_331 VGND VPWR sky130_fd_sc_hd__tapvpwrvgnd_1
XFILLER_31_144 VGND VGND VPWR VPWR sky130_fd_sc_hd__decap_3
X_3790_ _4166_/A _4169_/B _3789_/X VGND VGND VPWR VPWR _3790_/Y sky130_fd_sc_hd__o21ai_2
X_2810_ _2832_/A _2809_/X _2435_/Y VGND VGND VPWR VPWR _2810_/X sky130_fd_sc_hd__o21a_2
XFILLER_31_199 VGND VGND VPWR VPWR sky130_fd_sc_hd__decap_3
X_2741_ _4890_/Q _4874_/Q _5098_/Q _5082_/Q _2851_/S0 _2854_/S1 VGND VGND VPWR VPWR
+ _2741_/X sky130_fd_sc_hd__mux4_2
Xclkbuf_leaf_17_CLK clkload2/A VGND VGND VPWR VPWR _5285_/CLK sky130_fd_sc_hd__clkbuf_8
X_4411_ _4522_/A _4468_/A _4411_/C VGND VGND VPWR VPWR _4411_/X sky130_fd_sc_hd__or3_2
X_2672_ _5073_/Q _5057_/Q _5041_/Q _5025_/Q _2672_/S0 _2672_/S1 VGND VGND VPWR VPWR
+ _2673_/B sky130_fd_sc_hd__mux4_2
X_4342_ _4362_/A _4379_/A _4339_/Y _4261_/C _3749_/A VGND VGND VPWR VPWR _4345_/B
+ sky130_fd_sc_hd__o32a_2
X_4273_ _3848_/Y _4262_/X _4272_/X VGND VGND VPWR VPWR _4274_/C sky130_fd_sc_hd__o21ai_2
X_3224_ _2941_/X _3227_/A2 _3211_/Y _5123_/Q VGND VGND VPWR VPWR _5123_/D sky130_fd_sc_hd__a22o_2
.ends
